* NGSPICE file created from semi_cpu_top.ext - technology: sky130A

* Black-box entry subcircuit for sky130_fd_sc_hd__and3_1 abstract view
.subckt sky130_fd_sc_hd__and3_1 A B C VGND VNB VPB VPWR X
.ends

* Black-box entry subcircuit for sky130_fd_sc_hd__tapvpwrvgnd_1 abstract view
.subckt sky130_fd_sc_hd__tapvpwrvgnd_1 VGND VPWR
.ends

* Black-box entry subcircuit for sky130_fd_sc_hd__a22o_1 abstract view
.subckt sky130_fd_sc_hd__a22o_1 A1 A2 B1 B2 VGND VNB VPB VPWR X
.ends

* Black-box entry subcircuit for sky130_fd_sc_hd__fill_1 abstract view
.subckt sky130_fd_sc_hd__fill_1 VGND VNB VPB VPWR
.ends

* Black-box entry subcircuit for sky130_fd_sc_hd__mux2_1 abstract view
.subckt sky130_fd_sc_hd__mux2_1 A0 A1 S VGND VNB VPB VPWR X
.ends

* Black-box entry subcircuit for sky130_fd_sc_hd__buf_2 abstract view
.subckt sky130_fd_sc_hd__buf_2 A VGND VNB VPB VPWR X
.ends

* Black-box entry subcircuit for sky130_fd_sc_hd__decap_3 abstract view
.subckt sky130_fd_sc_hd__decap_3 VGND VNB VPB VPWR
.ends

* Black-box entry subcircuit for sky130_fd_sc_hd__decap_4 abstract view
.subckt sky130_fd_sc_hd__decap_4 VGND VNB VPB VPWR
.ends

* Black-box entry subcircuit for sky130_fd_sc_hd__decap_8 abstract view
.subckt sky130_fd_sc_hd__decap_8 VGND VNB VPB VPWR
.ends

* Black-box entry subcircuit for sky130_ef_sc_hd__decap_12 abstract view
.subckt sky130_ef_sc_hd__decap_12 VPWR VGND VPB VNB
.ends

* Black-box entry subcircuit for sky130_fd_sc_hd__dfrtp_1 abstract view
.subckt sky130_fd_sc_hd__dfrtp_1 CLK D RESET_B VGND VNB VPB VPWR Q
.ends

* Black-box entry subcircuit for sky130_fd_sc_hd__fill_2 abstract view
.subckt sky130_fd_sc_hd__fill_2 VGND VNB VPB VPWR
.ends

* Black-box entry subcircuit for sky130_fd_sc_hd__dlygate4sd1_1 abstract view
.subckt sky130_fd_sc_hd__dlygate4sd1_1 A VGND VNB VPB VPWR X
.ends

* Black-box entry subcircuit for sky130_fd_sc_hd__clkbuf_1 abstract view
.subckt sky130_fd_sc_hd__clkbuf_1 A VGND VNB VPB VPWR X
.ends

* Black-box entry subcircuit for sky130_fd_sc_hd__decap_6 abstract view
.subckt sky130_fd_sc_hd__decap_6 VGND VNB VPB VPWR
.ends

* Black-box entry subcircuit for sky130_fd_sc_hd__mux4_1 abstract view
.subckt sky130_fd_sc_hd__mux4_1 A0 A1 A2 A3 S0 S1 VGND VNB VPB VPWR X
.ends

* Black-box entry subcircuit for sky130_fd_sc_hd__nor2_1 abstract view
.subckt sky130_fd_sc_hd__nor2_1 A B VGND VNB VPB VPWR Y
.ends

* Black-box entry subcircuit for sky130_fd_sc_hd__a22oi_4 abstract view
.subckt sky130_fd_sc_hd__a22oi_4 A1 A2 B1 B2 VGND VNB VPB VPWR Y
.ends

* Black-box entry subcircuit for sky130_fd_sc_hd__inv_2 abstract view
.subckt sky130_fd_sc_hd__inv_2 A VGND VNB VPB VPWR Y
.ends

* Black-box entry subcircuit for sky130_fd_sc_hd__buf_4 abstract view
.subckt sky130_fd_sc_hd__buf_4 A VGND VNB VPB VPWR X
.ends

* Black-box entry subcircuit for sky130_fd_sc_hd__and2_1 abstract view
.subckt sky130_fd_sc_hd__and2_1 A B VGND VNB VPB VPWR X
.ends

* Black-box entry subcircuit for sky130_fd_sc_hd__a21oi_2 abstract view
.subckt sky130_fd_sc_hd__a21oi_2 A1 A2 B1 VGND VNB VPB VPWR Y
.ends

* Black-box entry subcircuit for sky130_fd_sc_hd__or2_1 abstract view
.subckt sky130_fd_sc_hd__or2_1 A B VGND VNB VPB VPWR X
.ends

* Black-box entry subcircuit for sky130_fd_sc_hd__mux2_4 abstract view
.subckt sky130_fd_sc_hd__mux2_4 A0 A1 S VGND VNB VPB VPWR X
.ends

* Black-box entry subcircuit for sky130_fd_sc_hd__a22o_2 abstract view
.subckt sky130_fd_sc_hd__a22o_2 A1 A2 B1 B2 VGND VNB VPB VPWR X
.ends

* Black-box entry subcircuit for sky130_fd_sc_hd__a221o_1 abstract view
.subckt sky130_fd_sc_hd__a221o_1 A1 A2 B1 B2 C1 VGND VNB VPB VPWR X
.ends

* Black-box entry subcircuit for sky130_fd_sc_hd__o21a_1 abstract view
.subckt sky130_fd_sc_hd__o21a_1 A1 A2 B1 VGND VNB VPB VPWR X
.ends

* Black-box entry subcircuit for sky130_fd_sc_hd__a21oi_1 abstract view
.subckt sky130_fd_sc_hd__a21oi_1 A1 A2 B1 VGND VNB VPB VPWR Y
.ends

* Black-box entry subcircuit for sky130_fd_sc_hd__or3_1 abstract view
.subckt sky130_fd_sc_hd__or3_1 A B C VGND VNB VPB VPWR X
.ends

* Black-box entry subcircuit for sky130_fd_sc_hd__dfrtp_2 abstract view
.subckt sky130_fd_sc_hd__dfrtp_2 CLK D RESET_B VGND VNB VPB VPWR Q
.ends

* Black-box entry subcircuit for sky130_fd_sc_hd__mux2_2 abstract view
.subckt sky130_fd_sc_hd__mux2_2 A0 A1 S VGND VNB VPB VPWR X
.ends

* Black-box entry subcircuit for sky130_fd_sc_hd__nand2_1 abstract view
.subckt sky130_fd_sc_hd__nand2_1 A B VGND VNB VPB VPWR Y
.ends

* Black-box entry subcircuit for sky130_fd_sc_hd__dlygate4sd3_1 abstract view
.subckt sky130_fd_sc_hd__dlygate4sd3_1 A VGND VNB VPB VPWR X
.ends

* Black-box entry subcircuit for sky130_fd_sc_hd__clkbuf_4 abstract view
.subckt sky130_fd_sc_hd__clkbuf_4 A VGND VNB VPB VPWR X
.ends

* Black-box entry subcircuit for sky130_fd_sc_hd__or2b_1 abstract view
.subckt sky130_fd_sc_hd__or2b_1 A B_N VGND VNB VPB VPWR X
.ends

* Black-box entry subcircuit for sky130_fd_sc_hd__a32o_1 abstract view
.subckt sky130_fd_sc_hd__a32o_1 A1 A2 A3 B1 B2 VGND VNB VPB VPWR X
.ends

* Black-box entry subcircuit for sky130_fd_sc_hd__nor2_2 abstract view
.subckt sky130_fd_sc_hd__nor2_2 A B VGND VNB VPB VPWR Y
.ends

* Black-box entry subcircuit for sky130_fd_sc_hd__and2b_1 abstract view
.subckt sky130_fd_sc_hd__and2b_1 A_N B VGND VNB VPB VPWR X
.ends

* Black-box entry subcircuit for sky130_fd_sc_hd__o21ai_2 abstract view
.subckt sky130_fd_sc_hd__o21ai_2 A1 A2 B1 VGND VNB VPB VPWR Y
.ends

* Black-box entry subcircuit for sky130_fd_sc_hd__and4b_1 abstract view
.subckt sky130_fd_sc_hd__and4b_1 A_N B C D VGND VNB VPB VPWR X
.ends

* Black-box entry subcircuit for sky130_fd_sc_hd__xor2_1 abstract view
.subckt sky130_fd_sc_hd__xor2_1 A B VGND VNB VPB VPWR X
.ends

* Black-box entry subcircuit for sky130_fd_sc_hd__o21bai_1 abstract view
.subckt sky130_fd_sc_hd__o21bai_1 A1 A2 B1_N VGND VNB VPB VPWR Y
.ends

* Black-box entry subcircuit for sky130_fd_sc_hd__buf_6 abstract view
.subckt sky130_fd_sc_hd__buf_6 A VGND VNB VPB VPWR X
.ends

* Black-box entry subcircuit for sky130_fd_sc_hd__nor3_1 abstract view
.subckt sky130_fd_sc_hd__nor3_1 A B C VGND VNB VPB VPWR Y
.ends

* Black-box entry subcircuit for sky130_fd_sc_hd__a31o_1 abstract view
.subckt sky130_fd_sc_hd__a31o_1 A1 A2 A3 B1 VGND VNB VPB VPWR X
.ends

* Black-box entry subcircuit for sky130_fd_sc_hd__dfrtp_4 abstract view
.subckt sky130_fd_sc_hd__dfrtp_4 CLK D RESET_B VGND VNB VPB VPWR Q
.ends

* Black-box entry subcircuit for sky130_fd_sc_hd__o22a_1 abstract view
.subckt sky130_fd_sc_hd__o22a_1 A1 A2 B1 B2 VGND VNB VPB VPWR X
.ends

* Black-box entry subcircuit for sky130_fd_sc_hd__o21bai_2 abstract view
.subckt sky130_fd_sc_hd__o21bai_2 A1 A2 B1_N VGND VNB VPB VPWR Y
.ends

* Black-box entry subcircuit for sky130_fd_sc_hd__dlymetal6s4s_1 abstract view
.subckt sky130_fd_sc_hd__dlymetal6s4s_1 A VGND VNB VPB VPWR X
.ends

* Black-box entry subcircuit for sky130_fd_sc_hd__o31a_1 abstract view
.subckt sky130_fd_sc_hd__o31a_1 A1 A2 A3 B1 VGND VNB VPB VPWR X
.ends

* Black-box entry subcircuit for sky130_fd_sc_hd__a2bb2o_1 abstract view
.subckt sky130_fd_sc_hd__a2bb2o_1 A1_N A2_N B1 B2 VGND VNB VPB VPWR X
.ends

* Black-box entry subcircuit for sky130_fd_sc_hd__nand3_2 abstract view
.subckt sky130_fd_sc_hd__nand3_2 A B C VGND VNB VPB VPWR Y
.ends

* Black-box entry subcircuit for sky130_fd_sc_hd__or4_4 abstract view
.subckt sky130_fd_sc_hd__or4_4 A B C D VGND VNB VPB VPWR X
.ends

* Black-box entry subcircuit for sky130_fd_sc_hd__and3b_1 abstract view
.subckt sky130_fd_sc_hd__and3b_1 A_N B C VGND VNB VPB VPWR X
.ends

* Black-box entry subcircuit for sky130_fd_sc_hd__o32a_2 abstract view
.subckt sky130_fd_sc_hd__o32a_2 A1 A2 A3 B1 B2 VGND VNB VPB VPWR X
.ends

* Black-box entry subcircuit for sky130_fd_sc_hd__a21o_1 abstract view
.subckt sky130_fd_sc_hd__a21o_1 A1 A2 B1 VGND VNB VPB VPWR X
.ends

* Black-box entry subcircuit for sky130_fd_sc_hd__a311oi_4 abstract view
.subckt sky130_fd_sc_hd__a311oi_4 A1 A2 A3 B1 C1 VGND VNB VPB VPWR Y
.ends

* Black-box entry subcircuit for sky130_fd_sc_hd__or3_4 abstract view
.subckt sky130_fd_sc_hd__or3_4 A B C VGND VNB VPB VPWR X
.ends

* Black-box entry subcircuit for sky130_fd_sc_hd__o32a_1 abstract view
.subckt sky130_fd_sc_hd__o32a_1 A1 A2 A3 B1 B2 VGND VNB VPB VPWR X
.ends

* Black-box entry subcircuit for sky130_fd_sc_hd__xnor2_4 abstract view
.subckt sky130_fd_sc_hd__xnor2_4 A B VGND VNB VPB VPWR Y
.ends

* Black-box entry subcircuit for sky130_fd_sc_hd__o31ai_4 abstract view
.subckt sky130_fd_sc_hd__o31ai_4 A1 A2 A3 B1 VGND VNB VPB VPWR Y
.ends

* Black-box entry subcircuit for sky130_fd_sc_hd__nand4_1 abstract view
.subckt sky130_fd_sc_hd__nand4_1 A B C D VGND VNB VPB VPWR Y
.ends

* Black-box entry subcircuit for sky130_fd_sc_hd__o21ai_1 abstract view
.subckt sky130_fd_sc_hd__o21ai_1 A1 A2 B1 VGND VNB VPB VPWR Y
.ends

* Black-box entry subcircuit for sky130_fd_sc_hd__nand3_1 abstract view
.subckt sky130_fd_sc_hd__nand3_1 A B C VGND VNB VPB VPWR Y
.ends

* Black-box entry subcircuit for sky130_fd_sc_hd__xnor2_2 abstract view
.subckt sky130_fd_sc_hd__xnor2_2 A B VGND VNB VPB VPWR Y
.ends

* Black-box entry subcircuit for sky130_fd_sc_hd__clkbuf_8 abstract view
.subckt sky130_fd_sc_hd__clkbuf_8 A VGND VNB VPB VPWR X
.ends

* Black-box entry subcircuit for sky130_fd_sc_hd__o2bb2a_1 abstract view
.subckt sky130_fd_sc_hd__o2bb2a_1 A1_N A2_N B1 B2 VGND VNB VPB VPWR X
.ends

* Black-box entry subcircuit for sky130_fd_sc_hd__a22o_4 abstract view
.subckt sky130_fd_sc_hd__a22o_4 A1 A2 B1 B2 VGND VNB VPB VPWR X
.ends

* Black-box entry subcircuit for sky130_fd_sc_hd__clkbuf_2 abstract view
.subckt sky130_fd_sc_hd__clkbuf_2 A VGND VNB VPB VPWR X
.ends

* Black-box entry subcircuit for sky130_fd_sc_hd__and4_1 abstract view
.subckt sky130_fd_sc_hd__and4_1 A B C D VGND VNB VPB VPWR X
.ends

* Black-box entry subcircuit for sky130_fd_sc_hd__clkinv_4 abstract view
.subckt sky130_fd_sc_hd__clkinv_4 A VGND VNB VPB VPWR Y
.ends

* Black-box entry subcircuit for sky130_fd_sc_hd__a211o_1 abstract view
.subckt sky130_fd_sc_hd__a211o_1 A1 A2 B1 C1 VGND VNB VPB VPWR X
.ends

* Black-box entry subcircuit for sky130_fd_sc_hd__o31ai_2 abstract view
.subckt sky130_fd_sc_hd__o31ai_2 A1 A2 A3 B1 VGND VNB VPB VPWR Y
.ends

* Black-box entry subcircuit for sky130_fd_sc_hd__buf_1 abstract view
.subckt sky130_fd_sc_hd__buf_1 A VGND VNB VPB VPWR X
.ends

* Black-box entry subcircuit for sky130_fd_sc_hd__nand2_2 abstract view
.subckt sky130_fd_sc_hd__nand2_2 A B VGND VNB VPB VPWR Y
.ends

* Black-box entry subcircuit for sky130_fd_sc_hd__xor2_4 abstract view
.subckt sky130_fd_sc_hd__xor2_4 A B VGND VNB VPB VPWR X
.ends

* Black-box entry subcircuit for sky130_fd_sc_hd__or2_2 abstract view
.subckt sky130_fd_sc_hd__or2_2 A B VGND VNB VPB VPWR X
.ends

* Black-box entry subcircuit for sky130_fd_sc_hd__a21bo_1 abstract view
.subckt sky130_fd_sc_hd__a21bo_1 A1 A2 B1_N VGND VNB VPB VPWR X
.ends

* Black-box entry subcircuit for sky130_fd_sc_hd__o22ai_2 abstract view
.subckt sky130_fd_sc_hd__o22ai_2 A1 A2 B1 B2 VGND VNB VPB VPWR Y
.ends

* Black-box entry subcircuit for sky130_fd_sc_hd__o211a_1 abstract view
.subckt sky130_fd_sc_hd__o211a_1 A1 A2 B1 C1 VGND VNB VPB VPWR X
.ends

* Black-box entry subcircuit for sky130_fd_sc_hd__a21o_4 abstract view
.subckt sky130_fd_sc_hd__a21o_4 A1 A2 B1 VGND VNB VPB VPWR X
.ends

* Black-box entry subcircuit for sky130_fd_sc_hd__inv_6 abstract view
.subckt sky130_fd_sc_hd__inv_6 A VGND VNB VPB VPWR Y
.ends

* Black-box entry subcircuit for sky130_fd_sc_hd__bufinv_16 abstract view
.subckt sky130_fd_sc_hd__bufinv_16 A VGND VNB VPB VPWR Y
.ends

* Black-box entry subcircuit for sky130_fd_sc_hd__clkbuf_16 abstract view
.subckt sky130_fd_sc_hd__clkbuf_16 A VGND VNB VPB VPWR X
.ends

* Black-box entry subcircuit for sky130_fd_sc_hd__o32ai_4 abstract view
.subckt sky130_fd_sc_hd__o32ai_4 A1 A2 A3 B1 B2 VGND VNB VPB VPWR Y
.ends

* Black-box entry subcircuit for sky130_fd_sc_hd__xor2_2 abstract view
.subckt sky130_fd_sc_hd__xor2_2 A B VGND VNB VPB VPWR X
.ends

* Black-box entry subcircuit for sky130_fd_sc_hd__o31a_4 abstract view
.subckt sky130_fd_sc_hd__o31a_4 A1 A2 A3 B1 VGND VNB VPB VPWR X
.ends

* Black-box entry subcircuit for sky130_fd_sc_hd__a211o_4 abstract view
.subckt sky130_fd_sc_hd__a211o_4 A1 A2 B1 C1 VGND VNB VPB VPWR X
.ends

* Black-box entry subcircuit for sky130_fd_sc_hd__inv_8 abstract view
.subckt sky130_fd_sc_hd__inv_8 A VGND VNB VPB VPWR Y
.ends

* Black-box entry subcircuit for sky130_fd_sc_hd__o2111a_4 abstract view
.subckt sky130_fd_sc_hd__o2111a_4 A1 A2 B1 C1 D1 VGND VNB VPB VPWR X
.ends

* Black-box entry subcircuit for sky130_fd_sc_hd__and2_2 abstract view
.subckt sky130_fd_sc_hd__and2_2 A B VGND VNB VPB VPWR X
.ends

* Black-box entry subcircuit for sky130_fd_sc_hd__clkinv_2 abstract view
.subckt sky130_fd_sc_hd__clkinv_2 A VGND VNB VPB VPWR Y
.ends

* Black-box entry subcircuit for sky130_fd_sc_hd__a21bo_4 abstract view
.subckt sky130_fd_sc_hd__a21bo_4 A1 A2 B1_N VGND VNB VPB VPWR X
.ends

* Black-box entry subcircuit for sky130_fd_sc_hd__nand2_4 abstract view
.subckt sky130_fd_sc_hd__nand2_4 A B VGND VNB VPB VPWR Y
.ends

* Black-box entry subcircuit for sky130_fd_sc_hd__or4bb_4 abstract view
.subckt sky130_fd_sc_hd__or4bb_4 A B C_N D_N VGND VNB VPB VPWR X
.ends

* Black-box entry subcircuit for sky130_fd_sc_hd__or3b_1 abstract view
.subckt sky130_fd_sc_hd__or3b_1 A B C_N VGND VNB VPB VPWR X
.ends

* Black-box entry subcircuit for sky130_fd_sc_hd__or3_2 abstract view
.subckt sky130_fd_sc_hd__or3_2 A B C VGND VNB VPB VPWR X
.ends

* Black-box entry subcircuit for sky130_fd_sc_hd__mux4_2 abstract view
.subckt sky130_fd_sc_hd__mux4_2 A0 A1 A2 A3 S0 S1 VGND VNB VPB VPWR X
.ends

* Black-box entry subcircuit for sky130_fd_sc_hd__o211ai_2 abstract view
.subckt sky130_fd_sc_hd__o211ai_2 A1 A2 B1 C1 VGND VNB VPB VPWR Y
.ends

* Black-box entry subcircuit for sky130_fd_sc_hd__o32a_4 abstract view
.subckt sky130_fd_sc_hd__o32a_4 A1 A2 A3 B1 B2 VGND VNB VPB VPWR X
.ends

* Black-box entry subcircuit for sky130_fd_sc_hd__nor3_4 abstract view
.subckt sky130_fd_sc_hd__nor3_4 A B C VGND VNB VPB VPWR Y
.ends

* Black-box entry subcircuit for sky130_fd_sc_hd__nor4_4 abstract view
.subckt sky130_fd_sc_hd__nor4_4 A B C D VGND VNB VPB VPWR Y
.ends

* Black-box entry subcircuit for sky130_fd_sc_hd__a21oi_4 abstract view
.subckt sky130_fd_sc_hd__a21oi_4 A1 A2 B1 VGND VNB VPB VPWR Y
.ends

* Black-box entry subcircuit for sky130_fd_sc_hd__xnor2_1 abstract view
.subckt sky130_fd_sc_hd__xnor2_1 A B VGND VNB VPB VPWR Y
.ends

* Black-box entry subcircuit for sky130_fd_sc_hd__inv_12 abstract view
.subckt sky130_fd_sc_hd__inv_12 A VGND VNB VPB VPWR Y
.ends

* Black-box entry subcircuit for sky130_fd_sc_hd__nor2b_2 abstract view
.subckt sky130_fd_sc_hd__nor2b_2 A B_N VGND VNB VPB VPWR Y
.ends

* Black-box entry subcircuit for sky130_fd_sc_hd__clkinvlp_4 abstract view
.subckt sky130_fd_sc_hd__clkinvlp_4 A VGND VNB VPB VPWR Y
.ends

* Black-box entry subcircuit for sky130_fd_sc_hd__or4bb_1 abstract view
.subckt sky130_fd_sc_hd__or4bb_1 A B C_N D_N VGND VNB VPB VPWR X
.ends

* Black-box entry subcircuit for sky130_fd_sc_hd__o22ai_4 abstract view
.subckt sky130_fd_sc_hd__o22ai_4 A1 A2 B1 B2 VGND VNB VPB VPWR Y
.ends

* Black-box entry subcircuit for sky130_fd_sc_hd__clkinv_1 abstract view
.subckt sky130_fd_sc_hd__clkinv_1 A VGND VNB VPB VPWR Y
.ends

* Black-box entry subcircuit for sky130_fd_sc_hd__o21ai_4 abstract view
.subckt sky130_fd_sc_hd__o21ai_4 A1 A2 B1 VGND VNB VPB VPWR Y
.ends

* Black-box entry subcircuit for sky130_fd_sc_hd__a2bb2o_2 abstract view
.subckt sky130_fd_sc_hd__a2bb2o_2 A1_N A2_N B1 B2 VGND VNB VPB VPWR X
.ends

* Black-box entry subcircuit for sky130_fd_sc_hd__a31oi_1 abstract view
.subckt sky130_fd_sc_hd__a31oi_1 A1 A2 A3 B1 VGND VNB VPB VPWR Y
.ends

* Black-box entry subcircuit for sky130_fd_sc_hd__a211oi_1 abstract view
.subckt sky130_fd_sc_hd__a211oi_1 A1 A2 B1 C1 VGND VNB VPB VPWR Y
.ends

* Black-box entry subcircuit for sky130_fd_sc_hd__a41o_1 abstract view
.subckt sky130_fd_sc_hd__a41o_1 A1 A2 A3 A4 B1 VGND VNB VPB VPWR X
.ends

* Black-box entry subcircuit for sky130_fd_sc_hd__a22oi_2 abstract view
.subckt sky130_fd_sc_hd__a22oi_2 A1 A2 B1 B2 VGND VNB VPB VPWR Y
.ends

* Black-box entry subcircuit for sky130_fd_sc_hd__nor4_1 abstract view
.subckt sky130_fd_sc_hd__nor4_1 A B C D VGND VNB VPB VPWR Y
.ends

* Black-box entry subcircuit for sky130_fd_sc_hd__o31ai_1 abstract view
.subckt sky130_fd_sc_hd__o31ai_1 A1 A2 A3 B1 VGND VNB VPB VPWR Y
.ends

* Black-box entry subcircuit for sky130_fd_sc_hd__a21boi_1 abstract view
.subckt sky130_fd_sc_hd__a21boi_1 A1 A2 B1_N VGND VNB VPB VPWR Y
.ends

* Black-box entry subcircuit for sky130_fd_sc_hd__a31o_4 abstract view
.subckt sky130_fd_sc_hd__a31o_4 A1 A2 A3 B1 VGND VNB VPB VPWR X
.ends

* Black-box entry subcircuit for sky130_fd_sc_hd__a22oi_1 abstract view
.subckt sky130_fd_sc_hd__a22oi_1 A1 A2 B1 B2 VGND VNB VPB VPWR Y
.ends

* Black-box entry subcircuit for sky130_fd_sc_hd__nor3_2 abstract view
.subckt sky130_fd_sc_hd__nor3_2 A B C VGND VNB VPB VPWR Y
.ends

* Black-box entry subcircuit for sky130_fd_sc_hd__a221o_2 abstract view
.subckt sky130_fd_sc_hd__a221o_2 A1 A2 B1 B2 C1 VGND VNB VPB VPWR X
.ends

* Black-box entry subcircuit for sky130_fd_sc_hd__a31oi_2 abstract view
.subckt sky130_fd_sc_hd__a31oi_2 A1 A2 A3 B1 VGND VNB VPB VPWR Y
.ends

* Black-box entry subcircuit for sky130_fd_sc_hd__a211o_2 abstract view
.subckt sky130_fd_sc_hd__a211o_2 A1 A2 B1 C1 VGND VNB VPB VPWR X
.ends

* Black-box entry subcircuit for sky130_fd_sc_hd__o221a_1 abstract view
.subckt sky130_fd_sc_hd__o221a_1 A1 A2 B1 B2 C1 VGND VNB VPB VPWR X
.ends

* Black-box entry subcircuit for sky130_fd_sc_hd__or2_4 abstract view
.subckt sky130_fd_sc_hd__or2_4 A B VGND VNB VPB VPWR X
.ends

* Black-box entry subcircuit for sky130_fd_sc_hd__nand3_4 abstract view
.subckt sky130_fd_sc_hd__nand3_4 A B C VGND VNB VPB VPWR Y
.ends

* Black-box entry subcircuit for sky130_fd_sc_hd__nand2b_4 abstract view
.subckt sky130_fd_sc_hd__nand2b_4 A_N B VGND VNB VPB VPWR Y
.ends

* Black-box entry subcircuit for sky130_fd_sc_hd__and2b_2 abstract view
.subckt sky130_fd_sc_hd__and2b_2 A_N B VGND VNB VPB VPWR X
.ends

* Black-box entry subcircuit for sky130_fd_sc_hd__a21o_2 abstract view
.subckt sky130_fd_sc_hd__a21o_2 A1 A2 B1 VGND VNB VPB VPWR X
.ends

* Black-box entry subcircuit for sky130_fd_sc_hd__o311a_4 abstract view
.subckt sky130_fd_sc_hd__o311a_4 A1 A2 A3 B1 C1 VGND VNB VPB VPWR X
.ends

* Black-box entry subcircuit for sky130_fd_sc_hd__o311a_1 abstract view
.subckt sky130_fd_sc_hd__o311a_1 A1 A2 A3 B1 C1 VGND VNB VPB VPWR X
.ends

* Black-box entry subcircuit for sky130_fd_sc_hd__dlymetal6s2s_1 abstract view
.subckt sky130_fd_sc_hd__dlymetal6s2s_1 A VGND VNB VPB VPWR X
.ends

* Black-box entry subcircuit for sky130_fd_sc_hd__a311o_2 abstract view
.subckt sky130_fd_sc_hd__a311o_2 A1 A2 A3 B1 C1 VGND VNB VPB VPWR X
.ends

* Black-box entry subcircuit for sky130_fd_sc_hd__a31oi_4 abstract view
.subckt sky130_fd_sc_hd__a31oi_4 A1 A2 A3 B1 VGND VNB VPB VPWR Y
.ends

* Black-box entry subcircuit for sky130_fd_sc_hd__o21ba_1 abstract view
.subckt sky130_fd_sc_hd__o21ba_1 A1 A2 B1_N VGND VNB VPB VPWR X
.ends

* Black-box entry subcircuit for sky130_fd_sc_hd__diode_2 abstract view
.subckt sky130_fd_sc_hd__diode_2 DIODE VGND VNB VPB VPWR
.ends

* Black-box entry subcircuit for sky130_fd_sc_hd__and2_4 abstract view
.subckt sky130_fd_sc_hd__and2_4 A B VGND VNB VPB VPWR X
.ends

* Black-box entry subcircuit for sky130_fd_sc_hd__a31o_2 abstract view
.subckt sky130_fd_sc_hd__a31o_2 A1 A2 A3 B1 VGND VNB VPB VPWR X
.ends

* Black-box entry subcircuit for sky130_fd_sc_hd__a211oi_2 abstract view
.subckt sky130_fd_sc_hd__a211oi_2 A1 A2 B1 C1 VGND VNB VPB VPWR Y
.ends

* Black-box entry subcircuit for sky130_fd_sc_hd__nor2_4 abstract view
.subckt sky130_fd_sc_hd__nor2_4 A B VGND VNB VPB VPWR Y
.ends

* Black-box entry subcircuit for sky130_fd_sc_hd__a2bb2o_4 abstract view
.subckt sky130_fd_sc_hd__a2bb2o_4 A1_N A2_N B1 B2 VGND VNB VPB VPWR X
.ends

.subckt semi_cpu_top Result[0] Result[10] Result[11] Result[12] Result[13] Result[14]
+ Result[15] Result[16] Result[17] Result[18] Result[19] Result[1] Result[20] Result[21]
+ Result[22] Result[23] Result[24] Result[25] Result[26] Result[27] Result[28] Result[29]
+ Result[2] Result[30] Result[31] Result[3] Result[4] Result[5] Result[6] Result[7]
+ Result[8] Result[9] VGND VPWR clk control reset
X_3155_ _1062_ _1011_ _1216_ VGND VGND VPWR VPWR _1314_ sky130_fd_sc_hd__and3_1
XTAP_TAPCELL_ROW_65_732 VGND VPWR sky130_fd_sc_hd__tapvpwrvgnd_1
X_3086_ RF0.regs\[10\]\[26\] _1090_ _0675_ RF0.regs\[25\]\[26\] VGND VGND VPWR VPWR
+ _1246_ sky130_fd_sc_hd__a22o_1
XFILLER_0_76_133 VGND VGND VPWR VPWR sky130_fd_sc_hd__fill_1
XTAP_TAPCELL_ROW_37_489 VGND VPWR sky130_fd_sc_hd__tapvpwrvgnd_1
XFILLER_0_43_81 VGND VGND VPWR VPWR sky130_fd_sc_hd__fill_1
X_3988_ _1857_ RF0.regs\[15\]\[25\] _2060_ VGND VGND VPWR VPWR _2067_ sky130_fd_sc_hd__mux2_1
X_2939_ _1098_ VGND VGND VPWR VPWR _1099_ sky130_fd_sc_hd__buf_2
XFILLER_0_17_277 VGND VGND VPWR VPWR sky130_fd_sc_hd__decap_3
XTAP_TAPCELL_ROW_20_345 VGND VPWR sky130_fd_sc_hd__tapvpwrvgnd_1
XFILLER_0_32_203 VGND VGND VPWR VPWR sky130_fd_sc_hd__decap_4
XFILLER_0_32_214 VGND VGND VPWR VPWR sky130_fd_sc_hd__decap_8
XFILLER_0_13_461 VPWR VGND VPWR VGND sky130_ef_sc_hd__decap_12
X_4609_ clknet_leaf_24_clk _0259_ _0003_ VGND VGND VPWR VPWR RF0.regs\[30\]\[3\] sky130_fd_sc_hd__dfrtp_1
XFILLER_0_20_409 VGND VGND VPWR VPWR sky130_fd_sc_hd__decap_8
XTAP_TAPCELL_ROW_28_412 VGND VPWR sky130_fd_sc_hd__tapvpwrvgnd_1
XFILLER_0_67_144 VGND VGND VPWR VPWR sky130_fd_sc_hd__fill_2
XFILLER_0_67_155 VPWR VGND VPWR VGND sky130_ef_sc_hd__decap_12
XTAP_TAPCELL_ROW_71_779 VGND VPWR sky130_fd_sc_hd__tapvpwrvgnd_1
XFILLER_0_23_225 VPWR VGND VPWR VGND sky130_ef_sc_hd__decap_12
Xrebuffer7 _0892_ VGND VGND VPWR VPWR net42 sky130_fd_sc_hd__dlygate4sd1_1
XPHY_EDGE_ROW_39_Left_121 VGND VGND VPWR VPWR sky130_fd_sc_hd__decap_3
XFILLER_0_48_15 VPWR VGND VPWR VGND sky130_ef_sc_hd__decap_12
XTAP_TAPCELL_ROW_79_846 VGND VPWR sky130_fd_sc_hd__tapvpwrvgnd_1
XPHY_EDGE_ROW_48_Left_130 VGND VGND VPWR VPWR sky130_fd_sc_hd__decap_3
XTAP_TAPCELL_ROW_62_702 VGND VPWR sky130_fd_sc_hd__tapvpwrvgnd_1
X_3911_ _2026_ VGND VGND VPWR VPWR _0414_ sky130_fd_sc_hd__clkbuf_1
X_3842_ _1975_ RF0.regs\[5\]\[16\] _1957_ VGND VGND VPWR VPWR _1976_ sky130_fd_sc_hd__mux2_1
XFILLER_0_6_469 VGND VGND VPWR VPWR sky130_fd_sc_hd__decap_6
X_3773_ _1876_ _1877_ _1898_ _1913_ _1065_ _1039_ VGND VGND VPWR VPWR _1914_ sky130_fd_sc_hd__mux4_1
XFILLER_0_54_361 VGND VGND VPWR VPWR sky130_fd_sc_hd__decap_3
X_2724_ _0854_ _0855_ VGND VGND VPWR VPWR _0885_ sky130_fd_sc_hd__nor2_1
X_2655_ RF0.regs\[10\]\[10\] _0614_ _0670_ RF0.regs\[25\]\[10\] VGND VGND VPWR VPWR
+ _0816_ sky130_fd_sc_hd__a22oi_4
X_4325_ _2250_ VGND VGND VPWR VPWR _0011_ sky130_fd_sc_hd__inv_2
X_2586_ _0746_ VGND VGND VPWR VPWR _0747_ sky130_fd_sc_hd__buf_4
XFILLER_0_10_475 VGND VGND VPWR VPWR sky130_fd_sc_hd__fill_1
X_4256_ _1085_ _1460_ _2209_ _0654_ VGND VGND VPWR VPWR net28 sky130_fd_sc_hd__a22o_1
XFILLER_0_38_81 VGND VGND VPWR VPWR sky130_fd_sc_hd__decap_3
X_4187_ _2173_ VGND VGND VPWR VPWR _0285_ sky130_fd_sc_hd__clkbuf_1
X_3207_ _1246_ _1243_ _1068_ VGND VGND VPWR VPWR _1366_ sky130_fd_sc_hd__mux2_1
X_3138_ _1296_ _1297_ _1074_ VGND VGND VPWR VPWR _1298_ sky130_fd_sc_hd__mux2_1
X_3069_ _1221_ _1228_ _1038_ VGND VGND VPWR VPWR _1229_ sky130_fd_sc_hd__mux2_1
XFILLER_0_49_155 VGND VGND VPWR VPWR sky130_fd_sc_hd__fill_1
XFILLER_0_9_263 VPWR VGND VPWR VGND sky130_ef_sc_hd__decap_12
XFILLER_0_52_309 VPWR VGND VPWR VGND sky130_ef_sc_hd__decap_12
XFILLER_0_72_180 VPWR VGND VPWR VGND sky130_ef_sc_hd__decap_12
XFILLER_0_18_29 VGND VGND VPWR VPWR sky130_fd_sc_hd__decap_3
XFILLER_0_28_306 VGND VGND VPWR VPWR sky130_fd_sc_hd__fill_2
XFILLER_0_68_475 VGND VGND VPWR VPWR sky130_fd_sc_hd__fill_1
XFILLER_0_55_103 VGND VGND VPWR VPWR sky130_fd_sc_hd__fill_1
XFILLER_0_50_27 VGND VGND VPWR VPWR sky130_fd_sc_hd__fill_1
XFILLER_0_50_49 VGND VGND VPWR VPWR sky130_fd_sc_hd__fill_2
XFILLER_0_70_128 VGND VGND VPWR VPWR sky130_fd_sc_hd__decap_8
XFILLER_0_51_364 VGND VGND VPWR VPWR sky130_fd_sc_hd__decap_3
X_2440_ _0594_ _0600_ VGND VGND VPWR VPWR _0601_ sky130_fd_sc_hd__and2_1
XFILLER_0_51_375 VGND VGND VPWR VPWR sky130_fd_sc_hd__decap_3
XFILLER_0_59_69 VGND VGND VPWR VPWR sky130_fd_sc_hd__decap_6
X_2371_ _0560_ VGND VGND VPWR VPWR _0476_ sky130_fd_sc_hd__clkbuf_1
X_4110_ net136 _2095_ _2097_ VGND VGND VPWR VPWR _2132_ sky130_fd_sc_hd__mux2_1
XFILLER_0_75_57 VPWR VGND VPWR VGND sky130_ef_sc_hd__decap_12
X_4041_ _1883_ _2094_ _1684_ VGND VGND VPWR VPWR _2095_ sky130_fd_sc_hd__a21oi_2
XTAP_TAPCELL_ROW_39_507 VGND VPWR sky130_fd_sc_hd__tapvpwrvgnd_1
XTAP_TAPCELL_ROW_47_573 VGND VPWR sky130_fd_sc_hd__tapvpwrvgnd_1
XFILLER_0_59_420 VGND VGND VPWR VPWR sky130_fd_sc_hd__fill_1
XFILLER_0_59_442 VGND VGND VPWR VPWR sky130_fd_sc_hd__decap_6
XFILLER_0_24_83 VGND VGND VPWR VPWR sky130_fd_sc_hd__fill_1
XFILLER_0_24_94 VGND VGND VPWR VPWR sky130_fd_sc_hd__fill_2
XFILLER_0_59_475 VGND VGND VPWR VPWR sky130_fd_sc_hd__decap_3
XFILLER_0_74_445 VPWR VGND VPWR VGND sky130_ef_sc_hd__decap_12
XFILLER_0_6_200 VGND VGND VPWR VPWR sky130_fd_sc_hd__decap_8
XFILLER_0_34_309 VGND VGND VPWR VPWR sky130_fd_sc_hd__decap_3
X_3825_ _1925_ VGND VGND VPWR VPWR _1962_ sky130_fd_sc_hd__inv_2
X_3756_ _1057_ _1875_ VGND VGND VPWR VPWR _1897_ sky130_fd_sc_hd__or2_1
X_2707_ _0867_ VGND VGND VPWR VPWR _0868_ sky130_fd_sc_hd__inv_2
XFILLER_0_42_353 VGND VGND VPWR VPWR sky130_fd_sc_hd__decap_4
X_3687_ _1833_ RF0.regs\[5\]\[31\] _1835_ VGND VGND VPWR VPWR _1836_ sky130_fd_sc_hd__mux2_4
XFILLER_0_71_3 VPWR VGND VPWR VGND sky130_ef_sc_hd__decap_12
X_2638_ RF0.regs\[10\]\[23\] _0617_ _0674_ RF0.regs\[25\]\[23\] VGND VGND VPWR VPWR
+ _0799_ sky130_fd_sc_hd__a22o_1
XFILLER_0_10_261 VGND VGND VPWR VPWR sky130_fd_sc_hd__decap_8
XFILLER_0_10_250 VGND VGND VPWR VPWR sky130_fd_sc_hd__fill_2
X_2569_ RF0.regs\[15\]\[8\] _0662_ _0667_ RF0.regs\[5\]\[8\] VGND VGND VPWR VPWR _0730_
+ sky130_fd_sc_hd__a22o_2
X_4308_ _1205_ _2244_ _1123_ _1333_ _2245_ VGND VGND VPWR VPWR net24 sky130_fd_sc_hd__a221o_1
X_4239_ _2200_ VGND VGND VPWR VPWR _0260_ sky130_fd_sc_hd__clkbuf_1
XFILLER_0_69_228 VPWR VGND VPWR VGND sky130_ef_sc_hd__decap_12
XTAP_TAPCELL_ROW_81_874 VGND VPWR sky130_fd_sc_hd__tapvpwrvgnd_1
XTAP_TAPCELL_ROW_81_863 VGND VPWR sky130_fd_sc_hd__tapvpwrvgnd_1
XFILLER_0_37_125 VPWR VGND VPWR VGND sky130_ef_sc_hd__decap_12
XFILLER_0_37_147 VPWR VGND VPWR VGND sky130_ef_sc_hd__decap_12
XFILLER_0_65_445 VGND VGND VPWR VPWR sky130_fd_sc_hd__decap_3
XFILLER_0_37_169 VPWR VGND VPWR VGND sky130_ef_sc_hd__decap_12
XFILLER_0_18_394 VGND VGND VPWR VPWR sky130_fd_sc_hd__fill_2
XFILLER_0_52_139 VGND VGND VPWR VPWR sky130_fd_sc_hd__fill_1
XFILLER_0_45_27 VPWR VGND VPWR VGND sky130_ef_sc_hd__decap_12
XFILLER_0_0_29 VPWR VGND VPWR VGND sky130_ef_sc_hd__decap_12
XFILLER_0_61_15 VPWR VGND VPWR VGND sky130_ef_sc_hd__decap_12
XTAP_TAPCELL_ROW_44_554 VGND VPWR sky130_fd_sc_hd__tapvpwrvgnd_1
X_4590_ _2286_ VGND VGND VPWR VPWR _0240_ sky130_fd_sc_hd__inv_2
X_3610_ _0954_ _1759_ _1757_ VGND VGND VPWR VPWR _1761_ sky130_fd_sc_hd__o21a_1
XFILLER_0_3_214 VGND VGND VPWR VPWR sky130_fd_sc_hd__fill_2
X_3541_ RF0.regs\[15\]\[9\] _0609_ _0629_ RF0.regs\[10\]\[9\] VGND VGND VPWR VPWR
+ _1695_ sky130_fd_sc_hd__a22o_1
XFILLER_0_10_41 VGND VGND VPWR VPWR sky130_fd_sc_hd__decap_4
XFILLER_0_51_172 VGND VGND VPWR VPWR sky130_fd_sc_hd__decap_3
X_3472_ RF0.regs\[20\]\[4\] _0624_ _0608_ RF0.regs\[15\]\[4\] _1627_ VGND VGND VPWR
+ VPWR _1628_ sky130_fd_sc_hd__a221o_1
X_2423_ _0586_ VGND VGND VPWR VPWR _0450_ sky130_fd_sc_hd__clkbuf_1
X_2354_ IM0.addr\[3\] _0515_ net52 VGND VGND VPWR VPWR _0552_ sky130_fd_sc_hd__a21oi_1
XFILLER_0_19_72 VPWR VGND VPWR VGND sky130_ef_sc_hd__decap_12
X_4024_ _2005_ RF0.regs\[15\]\[8\] _2082_ VGND VGND VPWR VPWR _2086_ sky130_fd_sc_hd__mux2_1
XFILLER_0_74_253 VGND VGND VPWR VPWR sky130_fd_sc_hd__decap_6
X_4857_ clknet_leaf_25_clk _0507_ _0251_ VGND VGND VPWR VPWR IM0.addr\[27\] sky130_fd_sc_hd__dfrtp_1
XFILLER_0_62_404 VGND VGND VPWR VPWR sky130_fd_sc_hd__decap_4
XFILLER_0_34_117 VPWR VGND VPWR VGND sky130_ef_sc_hd__decap_12
X_3808_ _1426_ _1445_ VGND VGND VPWR VPWR _1949_ sky130_fd_sc_hd__or2_1
XFILLER_0_62_426 VGND VGND VPWR VPWR sky130_fd_sc_hd__decap_6
XFILLER_0_15_331 VGND VGND VPWR VPWR sky130_fd_sc_hd__decap_4
X_4788_ clknet_leaf_9_clk _0438_ _0182_ VGND VGND VPWR VPWR RF0.regs\[5\]\[22\] sky130_fd_sc_hd__dfrtp_1
X_3739_ _1000_ _1432_ _1433_ VGND VGND VPWR VPWR _1880_ sky130_fd_sc_hd__or3_1
XFILLER_0_70_481 VGND VGND VPWR VPWR sky130_fd_sc_hd__fill_1
XTAP_TAPCELL_ROW_7_235 VGND VPWR sky130_fd_sc_hd__tapvpwrvgnd_1
XTAP_TAPCELL_ROW_58_668 VGND VPWR sky130_fd_sc_hd__tapvpwrvgnd_1
XFILLER_0_38_412 VGND VGND VPWR VPWR sky130_fd_sc_hd__decap_8
XTAP_TAPCELL_ROW_41_524 VGND VPWR sky130_fd_sc_hd__tapvpwrvgnd_1
XFILLER_0_65_264 VPWR VGND VPWR VGND sky130_ef_sc_hd__decap_12
XFILLER_0_80_278 VPWR VGND VPWR VGND sky130_ef_sc_hd__decap_12
XFILLER_0_21_389 VGND VGND VPWR VPWR sky130_fd_sc_hd__decap_3
XFILLER_0_56_15 VPWR VGND VPWR VGND sky130_ef_sc_hd__decap_12
XFILLER_0_48_209 VGND VGND VPWR VPWR sky130_fd_sc_hd__decap_8
XFILLER_0_29_423 VGND VGND VPWR VPWR sky130_fd_sc_hd__fill_1
X_2972_ _0778_ _0784_ _1068_ VGND VGND VPWR VPWR _1132_ sky130_fd_sc_hd__mux2_1
X_4711_ clknet_leaf_2_clk _0361_ _0105_ VGND VGND VPWR VPWR RF0.regs\[15\]\[9\] sky130_fd_sc_hd__dfrtp_1
XFILLER_0_56_253 VGND VGND VPWR VPWR sky130_fd_sc_hd__decap_8
X_4642_ clknet_leaf_19_clk _0292_ _0036_ VGND VGND VPWR VPWR RF0.regs\[25\]\[4\] sky130_fd_sc_hd__dfrtp_2
XFILLER_0_56_286 VGND VGND VPWR VPWR sky130_fd_sc_hd__fill_1
X_4573_ _2284_ VGND VGND VPWR VPWR _0225_ sky130_fd_sc_hd__inv_2
XTAP_TAPCELL_ROW_12_281 VGND VPWR sky130_fd_sc_hd__tapvpwrvgnd_1
X_3524_ RF0.regs\[15\]\[0\] _0608_ _0628_ RF0.regs\[10\]\[0\] VGND VGND VPWR VPWR
+ _1678_ sky130_fd_sc_hd__a22o_1
XFILLER_0_12_345 VPWR VGND VPWR VGND sky130_ef_sc_hd__decap_12
XFILLER_0_24_183 VGND VGND VPWR VPWR sky130_fd_sc_hd__fill_1
X_3455_ _1606_ _1610_ _1609_ VGND VGND VPWR VPWR _1611_ sky130_fd_sc_hd__mux2_2
X_2406_ net107 VGND VGND VPWR VPWR _0578_ sky130_fd_sc_hd__clkbuf_1
X_3386_ _1537_ _1542_ VGND VGND VPWR VPWR _1543_ sky130_fd_sc_hd__nand2_1
X_2337_ net85 _0522_ VGND VGND VPWR VPWR _0545_ sky130_fd_sc_hd__nor2_1
XFILLER_0_34_3 VPWR VGND VPWR VGND sky130_ef_sc_hd__decap_12
X_4007_ _1975_ RF0.regs\[15\]\[16\] _2071_ VGND VGND VPWR VPWR _2077_ sky130_fd_sc_hd__mux2_1
XFILLER_0_50_407 VGND VGND VPWR VPWR sky130_fd_sc_hd__decap_8
XFILLER_0_50_418 VGND VGND VPWR VPWR sky130_fd_sc_hd__fill_2
Xhold30 IM0.addr\[18\] VGND VGND VPWR VPWR net65 sky130_fd_sc_hd__dlygate4sd3_1
Xhold41 IM0.addr\[22\] VGND VGND VPWR VPWR net76 sky130_fd_sc_hd__dlygate4sd3_1
Xhold63 RF0.regs\[0\]\[30\] VGND VGND VPWR VPWR net98 sky130_fd_sc_hd__dlygate4sd3_1
Xhold74 RF0.regs\[0\]\[27\] VGND VGND VPWR VPWR net109 sky130_fd_sc_hd__dlygate4sd3_1
Xhold52 RF0.regs\[0\]\[13\] VGND VGND VPWR VPWR net87 sky130_fd_sc_hd__dlygate4sd3_1
Xhold85 RF0.regs\[20\]\[29\] VGND VGND VPWR VPWR net120 sky130_fd_sc_hd__dlygate4sd3_1
Xhold96 RF0.regs\[20\]\[22\] VGND VGND VPWR VPWR net131 sky130_fd_sc_hd__dlygate4sd3_1
XTAP_TAPCELL_ROW_18_329 VGND VPWR sky130_fd_sc_hd__tapvpwrvgnd_1
XTAP_TAPCELL_ROW_26_395 VGND VPWR sky130_fd_sc_hd__tapvpwrvgnd_1
XFILLER_0_26_404 VPWR VGND VPWR VGND sky130_ef_sc_hd__decap_12
XFILLER_0_53_223 VGND VGND VPWR VPWR sky130_fd_sc_hd__fill_1
XPHY_EDGE_ROW_20_Left_102 VGND VGND VPWR VPWR sky130_fd_sc_hd__decap_3
XFILLER_0_53_289 VGND VGND VPWR VPWR sky130_fd_sc_hd__decap_4
XFILLER_0_34_481 VGND VGND VPWR VPWR sky130_fd_sc_hd__fill_1
X_3240_ _1047_ _1297_ _1398_ VGND VGND VPWR VPWR _1399_ sky130_fd_sc_hd__a21oi_1
XFILLER_0_67_69 VGND VGND VPWR VPWR sky130_fd_sc_hd__decap_4
X_3171_ _1327_ _1329_ _1020_ VGND VGND VPWR VPWR _1330_ sky130_fd_sc_hd__mux2_1
XFILLER_0_76_337 VGND VGND VPWR VPWR sky130_fd_sc_hd__fill_1
XTAP_TAPCELL_ROW_52_619 VGND VPWR sky130_fd_sc_hd__tapvpwrvgnd_1
XFILLER_0_29_275 VGND VGND VPWR VPWR sky130_fd_sc_hd__decap_4
XFILLER_0_32_83 VGND VGND VPWR VPWR sky130_fd_sc_hd__fill_1
X_2955_ _1007_ _0806_ VGND VGND VPWR VPWR _1115_ sky130_fd_sc_hd__nand2_1
X_2886_ _1010_ VGND VGND VPWR VPWR _1047_ sky130_fd_sc_hd__clkbuf_4
XFILLER_0_44_245 VGND VGND VPWR VPWR sky130_fd_sc_hd__fill_1
XTAP_TAPCELL_ROW_60_685 VGND VPWR sky130_fd_sc_hd__tapvpwrvgnd_1
X_4625_ clknet_leaf_4_clk _0275_ _0019_ VGND VGND VPWR VPWR RF0.regs\[30\]\[19\] sky130_fd_sc_hd__dfrtp_1
X_4556_ _2280_ VGND VGND VPWR VPWR _2283_ sky130_fd_sc_hd__buf_4
X_3507_ _1019_ _1661_ VGND VGND VPWR VPWR _1662_ sky130_fd_sc_hd__nor2_1
X_4487_ _2272_ VGND VGND VPWR VPWR _0151_ sky130_fd_sc_hd__inv_2
X_3438_ _1593_ _1594_ VGND VGND VPWR VPWR _1595_ sky130_fd_sc_hd__or2_1
X_3369_ _1521_ _1525_ _1063_ VGND VGND VPWR VPWR _1526_ sky130_fd_sc_hd__mux2_1
XTAP_TAPCELL_ROW_68_752 VGND VPWR sky130_fd_sc_hd__tapvpwrvgnd_1
XPHY_EDGE_ROW_11_Left_93 VGND VGND VPWR VPWR sky130_fd_sc_hd__decap_3
XFILLER_0_67_304 VGND VGND VPWR VPWR sky130_fd_sc_hd__decap_3
XFILLER_0_35_223 VGND VGND VPWR VPWR sky130_fd_sc_hd__fill_1
XFILLER_0_16_481 VGND VGND VPWR VPWR sky130_fd_sc_hd__fill_1
XFILLER_0_50_248 VGND VGND VPWR VPWR sky130_fd_sc_hd__decap_4
Xoutput20 net20 VGND VGND VPWR VPWR Result[27] sky130_fd_sc_hd__clkbuf_4
Xoutput31 net31 VGND VGND VPWR VPWR Result[8] sky130_fd_sc_hd__buf_2
XFILLER_0_31_473 VGND VGND VPWR VPWR sky130_fd_sc_hd__decap_4
Xoutput7 net49 VGND VGND VPWR VPWR Result[15] sky130_fd_sc_hd__buf_2
XFILLER_0_37_39 VPWR VGND VPWR VGND sky130_ef_sc_hd__decap_12
XFILLER_0_53_27 VPWR VGND VPWR VGND sky130_ef_sc_hd__decap_12
X_2740_ _0738_ VGND VGND VPWR VPWR _0901_ sky130_fd_sc_hd__inv_2
X_2671_ _0822_ _0831_ VGND VGND VPWR VPWR _0832_ sky130_fd_sc_hd__or2b_1
XFILLER_0_41_215 VGND VGND VPWR VPWR sky130_fd_sc_hd__decap_8
X_4410_ _2261_ VGND VGND VPWR VPWR _0085_ sky130_fd_sc_hd__inv_2
XFILLER_0_1_334 VGND VGND VPWR VPWR sky130_fd_sc_hd__fill_2
XFILLER_0_1_323 VGND VGND VPWR VPWR sky130_fd_sc_hd__decap_4
X_4341_ _2251_ VGND VGND VPWR VPWR _0026_ sky130_fd_sc_hd__inv_2
X_4272_ _0654_ _1529_ _1530_ _1205_ _1828_ VGND VGND VPWR VPWR net5 sky130_fd_sc_hd__a32o_1
X_3223_ _1308_ _1343_ VGND VGND VPWR VPWR _1382_ sky130_fd_sc_hd__nor2_1
X_3154_ _0791_ _1309_ _1311_ VGND VGND VPWR VPWR _1313_ sky130_fd_sc_hd__o21a_1
X_3085_ RF0.regs\[10\]\[27\] _1090_ _0675_ RF0.regs\[25\]\[27\] VGND VGND VPWR VPWR
+ _1245_ sky130_fd_sc_hd__a22o_1
XFILLER_0_76_189 VGND VGND VPWR VPWR sky130_fd_sc_hd__decap_6
XFILLER_0_9_445 VGND VGND VPWR VPWR sky130_fd_sc_hd__decap_3
X_3987_ _2066_ VGND VGND VPWR VPWR _0378_ sky130_fd_sc_hd__clkbuf_1
X_2938_ _1097_ VGND VGND VPWR VPWR _1098_ sky130_fd_sc_hd__buf_2
XFILLER_0_17_289 VGND VGND VPWR VPWR sky130_fd_sc_hd__fill_2
XTAP_TAPCELL_ROW_20_346 VGND VPWR sky130_fd_sc_hd__tapvpwrvgnd_1
X_2869_ RF0.regs\[10\]\[2\] _0613_ _0669_ RF0.regs\[25\]\[2\] VGND VGND VPWR VPWR
+ _1030_ sky130_fd_sc_hd__a22oi_4
XFILLER_0_32_226 VPWR VGND VPWR VGND sky130_ef_sc_hd__decap_12
X_4608_ clknet_leaf_24_clk _0258_ _0002_ VGND VGND VPWR VPWR RF0.regs\[30\]\[2\] sky130_fd_sc_hd__dfrtp_1
XFILLER_0_13_473 VGND VGND VPWR VPWR sky130_fd_sc_hd__decap_8
X_4539_ _2281_ VGND VGND VPWR VPWR _0194_ sky130_fd_sc_hd__inv_2
XTAP_TAPCELL_ROW_28_413 VGND VPWR sky130_fd_sc_hd__tapvpwrvgnd_1
XFILLER_0_67_167 VGND VGND VPWR VPWR sky130_fd_sc_hd__fill_1
XFILLER_0_63_351 VGND VGND VPWR VPWR sky130_fd_sc_hd__decap_6
XFILLER_0_23_237 VGND VGND VPWR VPWR sky130_fd_sc_hd__decap_4
Xrebuffer8 _0892_ VGND VGND VPWR VPWR net43 sky130_fd_sc_hd__dlygate4sd1_1
XFILLER_0_48_27 VGND VGND VPWR VPWR sky130_fd_sc_hd__fill_1
XTAP_TAPCELL_ROW_79_847 VGND VPWR sky130_fd_sc_hd__tapvpwrvgnd_1
XFILLER_0_64_15 VPWR VGND VPWR VGND sky130_ef_sc_hd__decap_12
XTAP_TAPCELL_ROW_62_703 VGND VPWR sky130_fd_sc_hd__tapvpwrvgnd_1
X_3910_ _1838_ RF0.regs\[10\]\[30\] _2024_ VGND VGND VPWR VPWR _2026_ sky130_fd_sc_hd__mux2_2
X_3841_ _1919_ _1974_ VGND VGND VPWR VPWR _1975_ sky130_fd_sc_hd__nor2_2
XFILLER_0_58_178 VGND VGND VPWR VPWR sky130_fd_sc_hd__fill_2
XFILLER_0_13_74 VGND VGND VPWR VPWR sky130_fd_sc_hd__decap_8
X_3772_ _1912_ VGND VGND VPWR VPWR _1913_ sky130_fd_sc_hd__inv_2
XFILLER_0_73_159 VGND VGND VPWR VPWR sky130_fd_sc_hd__fill_1
X_2723_ _0859_ _0883_ VGND VGND VPWR VPWR _0884_ sky130_fd_sc_hd__and2b_1
XFILLER_0_81_181 VPWR VGND VPWR VGND sky130_ef_sc_hd__decap_12
XFILLER_0_14_237 VGND VGND VPWR VPWR sky130_fd_sc_hd__fill_1
X_2654_ _0813_ _0814_ _0658_ VGND VGND VPWR VPWR _0815_ sky130_fd_sc_hd__o21ai_2
X_2585_ _0696_ _0745_ _0700_ _0698_ VGND VGND VPWR VPWR _0746_ sky130_fd_sc_hd__and4b_1
XFILLER_0_10_421 VPWR VGND VPWR VGND sky130_ef_sc_hd__decap_12
X_4324_ _2250_ VGND VGND VPWR VPWR _0010_ sky130_fd_sc_hd__inv_2
X_4255_ _1617_ _1618_ VGND VGND VPWR VPWR _2209_ sky130_fd_sc_hd__xor2_1
X_4186_ _1842_ RF0.regs\[30\]\[29\] _2170_ VGND VGND VPWR VPWR _2173_ sky130_fd_sc_hd__mux2_1
X_3206_ _1150_ _1364_ VGND VGND VPWR VPWR _1365_ sky130_fd_sc_hd__nand2_1
X_3137_ _1023_ _0876_ _1014_ VGND VGND VPWR VPWR _1297_ sky130_fd_sc_hd__mux2_1
X_3068_ _1224_ _1227_ _1064_ VGND VGND VPWR VPWR _1228_ sky130_fd_sc_hd__mux2_1
XFILLER_0_49_101 VGND VGND VPWR VPWR sky130_fd_sc_hd__fill_2
XFILLER_0_49_167 VGND VGND VPWR VPWR sky130_fd_sc_hd__fill_1
XFILLER_0_9_275 VGND VGND VPWR VPWR sky130_fd_sc_hd__decap_4
XTAP_TAPCELL_ROW_33_460 VGND VPWR sky130_fd_sc_hd__tapvpwrvgnd_1
XFILLER_0_72_192 VGND VGND VPWR VPWR sky130_fd_sc_hd__decap_4
XFILLER_0_60_321 VGND VGND VPWR VPWR sky130_fd_sc_hd__decap_8
XFILLER_0_5_481 VGND VGND VPWR VPWR sky130_fd_sc_hd__fill_1
XFILLER_0_60_365 VGND VGND VPWR VPWR sky130_fd_sc_hd__fill_1
XFILLER_0_20_218 VGND VGND VPWR VPWR sky130_fd_sc_hd__decap_3
XFILLER_0_13_281 VGND VGND VPWR VPWR sky130_fd_sc_hd__decap_6
XFILLER_0_34_29 VGND VGND VPWR VPWR sky130_fd_sc_hd__fill_1
XFILLER_0_68_421 VPWR VGND VPWR VGND sky130_ef_sc_hd__decap_12
XFILLER_0_36_340 VGND VGND VPWR VPWR sky130_fd_sc_hd__decap_8
XFILLER_0_63_181 VPWR VGND VPWR VGND sky130_ef_sc_hd__decap_12
XFILLER_0_59_15 VPWR VGND VPWR VGND sky130_ef_sc_hd__decap_12
X_2370_ net99 VGND VGND VPWR VPWR _0560_ sky130_fd_sc_hd__clkbuf_1
XFILLER_0_75_69 VGND VGND VPWR VPWR sky130_fd_sc_hd__decap_4
X_4040_ RF0.regs\[0\]\[0\] _0605_ _1680_ VGND VGND VPWR VPWR _2094_ sky130_fd_sc_hd__o21bai_1
XTAP_TAPCELL_ROW_39_508 VGND VPWR sky130_fd_sc_hd__tapvpwrvgnd_1
XTAP_TAPCELL_ROW_47_574 VGND VPWR sky130_fd_sc_hd__tapvpwrvgnd_1
XFILLER_0_74_413 VGND VGND VPWR VPWR sky130_fd_sc_hd__decap_6
XFILLER_0_74_457 VPWR VGND VPWR VGND sky130_ef_sc_hd__decap_12
XTAP_TAPCELL_ROW_30_430 VGND VPWR sky130_fd_sc_hd__tapvpwrvgnd_1
X_3824_ _1864_ _1919_ VGND VGND VPWR VPWR _1961_ sky130_fd_sc_hd__nand2_1
XFILLER_0_6_267 VGND VGND VPWR VPWR sky130_fd_sc_hd__decap_4
X_3755_ _1697_ _1874_ _1582_ _1891_ _1895_ VGND VGND VPWR VPWR _1896_ sky130_fd_sc_hd__a221o_1
XFILLER_0_42_321 VPWR VGND VPWR VGND sky130_ef_sc_hd__decap_12
X_2706_ _0865_ _0866_ VGND VGND VPWR VPWR _0867_ sky130_fd_sc_hd__nor2_1
XFILLER_0_42_365 VPWR VGND VPWR VGND sky130_ef_sc_hd__decap_12
X_3686_ _1834_ VGND VGND VPWR VPWR _1835_ sky130_fd_sc_hd__clkbuf_4
XPHY_EDGE_ROW_12_Right_12 VGND VGND VPWR VPWR sky130_fd_sc_hd__decap_3
X_2637_ _0797_ _0690_ _0750_ VGND VGND VPWR VPWR _0798_ sky130_fd_sc_hd__mux2_4
XFILLER_0_64_3 VPWR VGND VPWR VGND sky130_ef_sc_hd__decap_12
X_2568_ _0728_ VGND VGND VPWR VPWR _0729_ sky130_fd_sc_hd__buf_6
X_2499_ IM0.addr\[2\] _0555_ VGND VGND VPWR VPWR _0660_ sky130_fd_sc_hd__and2b_1
X_4307_ _1099_ _0992_ _1100_ VGND VGND VPWR VPWR _2245_ sky130_fd_sc_hd__nor3_1
X_4238_ _2013_ net152 _2192_ VGND VGND VPWR VPWR _2200_ sky130_fd_sc_hd__mux2_1
X_4169_ _2163_ VGND VGND VPWR VPWR _0293_ sky130_fd_sc_hd__clkbuf_1
XPHY_EDGE_ROW_21_Right_21 VGND VGND VPWR VPWR sky130_fd_sc_hd__decap_3
XTAP_TAPCELL_ROW_81_875 VGND VPWR sky130_fd_sc_hd__tapvpwrvgnd_1
XTAP_TAPCELL_ROW_81_864 VGND VPWR sky130_fd_sc_hd__tapvpwrvgnd_1
XFILLER_0_65_402 VGND VGND VPWR VPWR sky130_fd_sc_hd__fill_2
XPHY_EDGE_ROW_67_Left_149 VGND VGND VPWR VPWR sky130_fd_sc_hd__decap_3
XFILLER_0_37_137 VGND VGND VPWR VPWR sky130_fd_sc_hd__decap_3
XFILLER_0_37_159 VGND VGND VPWR VPWR sky130_fd_sc_hd__decap_8
XPHY_EDGE_ROW_30_Right_30 VGND VGND VPWR VPWR sky130_fd_sc_hd__decap_3
XPHY_EDGE_ROW_76_Left_158 VGND VGND VPWR VPWR sky130_fd_sc_hd__decap_3
XFILLER_0_45_39 VGND VGND VPWR VPWR sky130_fd_sc_hd__decap_8
XFILLER_0_61_27 VPWR VGND VPWR VGND sky130_ef_sc_hd__decap_12
XFILLER_0_68_251 VGND VGND VPWR VPWR sky130_fd_sc_hd__fill_1
XFILLER_0_71_405 VPWR VGND VPWR VGND sky130_ef_sc_hd__decap_12
XFILLER_0_71_449 VPWR VGND VPWR VGND sky130_ef_sc_hd__decap_12
XFILLER_0_24_354 VGND VGND VPWR VPWR sky130_fd_sc_hd__decap_8
X_3540_ RF0.regs\[5\]\[9\] _0633_ _0637_ RF0.regs\[30\]\[9\] _0640_ VGND VGND VPWR
+ VPWR _1694_ sky130_fd_sc_hd__a221o_1
X_3471_ RF0.regs\[5\]\[4\] _0632_ _0637_ RF0.regs\[30\]\[4\] _0640_ VGND VGND VPWR
+ VPWR _1627_ sky130_fd_sc_hd__a221o_1
X_2422_ net103 VGND VGND VPWR VPWR _0586_ sky130_fd_sc_hd__clkbuf_1
X_2353_ _0517_ _0551_ VGND VGND VPWR VPWR _0485_ sky130_fd_sc_hd__nor2_1
XFILLER_0_19_84 VPWR VGND VPWR VGND sky130_ef_sc_hd__decap_12
X_4023_ _2085_ VGND VGND VPWR VPWR _0361_ sky130_fd_sc_hd__clkbuf_1
XFILLER_0_47_402 VGND VGND VPWR VPWR sky130_fd_sc_hd__decap_8
X_4856_ clknet_leaf_25_clk _0506_ _0250_ VGND VGND VPWR VPWR IM0.addr\[26\] sky130_fd_sc_hd__dfrtp_1
XFILLER_0_51_60 VGND VGND VPWR VPWR sky130_fd_sc_hd__fill_2
XFILLER_0_62_416 VGND VGND VPWR VPWR sky130_fd_sc_hd__decap_4
XFILLER_0_34_129 VGND VGND VPWR VPWR sky130_fd_sc_hd__fill_1
X_3807_ _1863_ _1934_ _1947_ VGND VGND VPWR VPWR _1948_ sky130_fd_sc_hd__a21oi_2
XFILLER_0_27_181 VPWR VGND VPWR VGND sky130_ef_sc_hd__decap_12
X_4787_ clknet_leaf_6_clk _0437_ _0181_ VGND VGND VPWR VPWR RF0.regs\[5\]\[21\] sky130_fd_sc_hd__dfrtp_1
X_3738_ _1084_ _1878_ _1300_ _1597_ _0652_ VGND VGND VPWR VPWR _1879_ sky130_fd_sc_hd__a32o_1
XFILLER_0_42_195 VGND VGND VPWR VPWR sky130_fd_sc_hd__fill_1
X_3669_ _1065_ _1188_ _1190_ _1819_ VGND VGND VPWR VPWR _1820_ sky130_fd_sc_hd__a31o_1
XTAP_TAPCELL_ROW_7_236 VGND VPWR sky130_fd_sc_hd__tapvpwrvgnd_1
XTAP_TAPCELL_ROW_58_669 VGND VPWR sky130_fd_sc_hd__tapvpwrvgnd_1
XTAP_TAPCELL_ROW_41_525 VGND VPWR sky130_fd_sc_hd__tapvpwrvgnd_1
XFILLER_0_65_243 VGND VGND VPWR VPWR sky130_fd_sc_hd__fill_1
XFILLER_0_65_276 VGND VGND VPWR VPWR sky130_fd_sc_hd__decap_4
XFILLER_0_65_287 VGND VGND VPWR VPWR sky130_fd_sc_hd__decap_4
XFILLER_0_33_173 VGND VGND VPWR VPWR sky130_fd_sc_hd__fill_1
XFILLER_0_33_195 VGND VGND VPWR VPWR sky130_fd_sc_hd__fill_1
XFILLER_0_56_27 VGND VGND VPWR VPWR sky130_fd_sc_hd__fill_1
XFILLER_0_72_15 VPWR VGND VPWR VGND sky130_ef_sc_hd__decap_12
X_2971_ _0789_ _0799_ _1068_ VGND VGND VPWR VPWR _1131_ sky130_fd_sc_hd__mux2_1
X_4710_ clknet_leaf_22_clk _0360_ _0104_ VGND VGND VPWR VPWR RF0.regs\[15\]\[8\] sky130_fd_sc_hd__dfrtp_1
X_4641_ clknet_leaf_19_clk _0291_ _0035_ VGND VGND VPWR VPWR RF0.regs\[25\]\[3\] sky130_fd_sc_hd__dfrtp_4
XFILLER_0_44_427 VGND VGND VPWR VPWR sky130_fd_sc_hd__decap_4
XFILLER_0_44_449 VGND VGND VPWR VPWR sky130_fd_sc_hd__decap_3
X_4572_ _2284_ VGND VGND VPWR VPWR _0224_ sky130_fd_sc_hd__inv_2
XTAP_TAPCELL_ROW_12_282 VGND VPWR sky130_fd_sc_hd__tapvpwrvgnd_1
X_3523_ RF0.regs\[5\]\[0\] _0632_ _0636_ RF0.regs\[30\]\[0\] _0606_ VGND VGND VPWR
+ VPWR _1677_ sky130_fd_sc_hd__a221o_1
X_3454_ RF0.regs\[0\]\[6\] _0602_ _1603_ _1605_ VGND VGND VPWR VPWR _1610_ sky130_fd_sc_hd__o22a_1
X_2405_ _0577_ VGND VGND VPWR VPWR _0459_ sky130_fd_sc_hd__clkbuf_1
XTAP_TAPCELL_ROW_4_206 VGND VPWR sky130_fd_sc_hd__tapvpwrvgnd_1
X_3385_ _1539_ _1166_ _1541_ VGND VGND VPWR VPWR _1542_ sky130_fd_sc_hd__o21bai_2
X_2336_ net68 _0523_ VGND VGND VPWR VPWR _0495_ sky130_fd_sc_hd__xor2_1
XFILLER_0_27_3 VGND VGND VPWR VPWR sky130_fd_sc_hd__decap_8
X_4006_ _2076_ VGND VGND VPWR VPWR _0369_ sky130_fd_sc_hd__clkbuf_1
XFILLER_0_46_82 VGND VGND VPWR VPWR sky130_fd_sc_hd__fill_2
XFILLER_0_79_346 VGND VGND VPWR VPWR sky130_fd_sc_hd__fill_1
XFILLER_0_79_335 VGND VGND VPWR VPWR sky130_fd_sc_hd__fill_1
X_4839_ clknet_leaf_0_clk _0489_ _0233_ VGND VGND VPWR VPWR IM0.addr\[9\] sky130_fd_sc_hd__dfrtp_1
XFILLER_0_43_471 VGND VGND VPWR VPWR sky130_fd_sc_hd__decap_8
Xhold20 _0550_ VGND VGND VPWR VPWR net55 sky130_fd_sc_hd__dlygate4sd3_1
Xhold31 IM0.addr\[13\] VGND VGND VPWR VPWR net66 sky130_fd_sc_hd__dlygate4sd3_1
Xhold64 RF0.regs\[0\]\[28\] VGND VGND VPWR VPWR net99 sky130_fd_sc_hd__dlygate4sd3_1
Xhold42 _0540_ VGND VGND VPWR VPWR net77 sky130_fd_sc_hd__dlygate4sd3_1
Xhold53 RF0.regs\[0\]\[3\] VGND VGND VPWR VPWR net88 sky130_fd_sc_hd__dlygate4sd3_1
Xhold75 RF0.regs\[0\]\[26\] VGND VGND VPWR VPWR net110 sky130_fd_sc_hd__dlygate4sd3_1
Xhold97 RF0.regs\[20\]\[11\] VGND VGND VPWR VPWR net132 sky130_fd_sc_hd__dlygate4sd3_1
Xhold86 RF0.regs\[20\]\[21\] VGND VGND VPWR VPWR net121 sky130_fd_sc_hd__dlygate4sd3_1
XFILLER_0_42_29 VGND VGND VPWR VPWR sky130_fd_sc_hd__decap_4
XTAP_TAPCELL_ROW_26_396 VGND VPWR sky130_fd_sc_hd__tapvpwrvgnd_1
XFILLER_0_26_416 VGND VGND VPWR VPWR sky130_fd_sc_hd__fill_1
XFILLER_0_53_257 VGND VGND VPWR VPWR sky130_fd_sc_hd__decap_4
XFILLER_0_53_279 VGND VGND VPWR VPWR sky130_fd_sc_hd__fill_1
XFILLER_0_67_15 VPWR VGND VPWR VGND sky130_ef_sc_hd__decap_12
X_3170_ _1024_ _1328_ _1073_ VGND VGND VPWR VPWR _1329_ sky130_fd_sc_hd__mux2_1
XFILLER_0_17_405 VGND VGND VPWR VPWR sky130_fd_sc_hd__fill_2
X_2954_ _1113_ VGND VGND VPWR VPWR _1114_ sky130_fd_sc_hd__inv_2
XFILLER_0_17_449 VPWR VGND VPWR VGND sky130_ef_sc_hd__decap_12
XTAP_TAPCELL_ROW_60_686 VGND VPWR sky130_fd_sc_hd__tapvpwrvgnd_1
X_2885_ _1045_ VGND VGND VPWR VPWR _1046_ sky130_fd_sc_hd__inv_2
XPHY_EDGE_ROW_6_Right_6 VGND VGND VPWR VPWR sky130_fd_sc_hd__decap_3
X_4624_ clknet_leaf_4_clk _0274_ _0018_ VGND VGND VPWR VPWR RF0.regs\[30\]\[18\] sky130_fd_sc_hd__dfrtp_1
XFILLER_0_40_430 VGND VGND VPWR VPWR sky130_fd_sc_hd__decap_6
X_4555_ _2282_ VGND VGND VPWR VPWR _0209_ sky130_fd_sc_hd__inv_2
X_3506_ _1292_ _1428_ _1009_ VGND VGND VPWR VPWR _1661_ sky130_fd_sc_hd__mux2_1
X_4486_ _2272_ VGND VGND VPWR VPWR _0150_ sky130_fd_sc_hd__inv_2
X_3437_ _0889_ _0846_ VGND VGND VPWR VPWR _1594_ sky130_fd_sc_hd__and2_1
X_3368_ _1522_ _1524_ _1047_ VGND VGND VPWR VPWR _1525_ sky130_fd_sc_hd__mux2_1
X_2319_ IM0.addr\[24\] _0529_ net56 VGND VGND VPWR VPWR _0538_ sky130_fd_sc_hd__a21oi_1
X_3299_ _1455_ _0966_ _0961_ VGND VGND VPWR VPWR _1457_ sky130_fd_sc_hd__a21oi_2
XTAP_TAPCELL_ROW_68_753 VGND VPWR sky130_fd_sc_hd__tapvpwrvgnd_1
XFILLER_0_35_246 VGND VGND VPWR VPWR sky130_fd_sc_hd__decap_3
XFILLER_0_23_419 VGND VGND VPWR VPWR sky130_fd_sc_hd__fill_2
Xoutput21 net21 VGND VGND VPWR VPWR Result[28] sky130_fd_sc_hd__clkbuf_4
Xoutput10 net10 VGND VGND VPWR VPWR Result[18] sky130_fd_sc_hd__clkbuf_4
Xoutput32 net32 VGND VGND VPWR VPWR Result[9] sky130_fd_sc_hd__buf_2
Xoutput8 net8 VGND VGND VPWR VPWR Result[16] sky130_fd_sc_hd__buf_2
XFILLER_0_53_39 VGND VGND VPWR VPWR sky130_fd_sc_hd__decap_8
XFILLER_0_58_327 VGND VGND VPWR VPWR sky130_fd_sc_hd__fill_2
XFILLER_0_73_308 VGND VGND VPWR VPWR sky130_fd_sc_hd__fill_1
XFILLER_0_81_330 VGND VGND VPWR VPWR sky130_fd_sc_hd__decap_6
XPHY_EDGE_ROW_59_Right_59 VGND VGND VPWR VPWR sky130_fd_sc_hd__decap_3
XFILLER_0_81_363 VGND VGND VPWR VPWR sky130_fd_sc_hd__fill_1
XFILLER_0_81_352 VGND VGND VPWR VPWR sky130_fd_sc_hd__fill_1
X_2670_ RF0.regs\[10\]\[9\] _0828_ _0671_ RF0.regs\[25\]\[9\] VGND VGND VPWR VPWR
+ _0831_ sky130_fd_sc_hd__a22o_1
XFILLER_0_41_205 VGND VGND VPWR VPWR sky130_fd_sc_hd__fill_1
XFILLER_0_22_474 VGND VGND VPWR VPWR sky130_fd_sc_hd__fill_2
X_4340_ _2251_ VGND VGND VPWR VPWR _0025_ sky130_fd_sc_hd__inv_2
X_4271_ _0654_ _1489_ _1540_ _1538_ _1818_ VGND VGND VPWR VPWR net4 sky130_fd_sc_hd__a32o_1
X_3222_ _1240_ _1241_ _1269_ VGND VGND VPWR VPWR _1381_ sky130_fd_sc_hd__mux2_2
X_3153_ _0791_ _1309_ _1311_ VGND VGND VPWR VPWR _1312_ sky130_fd_sc_hd__nor3_1
XPHY_EDGE_ROW_68_Right_68 VGND VGND VPWR VPWR sky130_fd_sc_hd__decap_3
X_3084_ _1243_ _1181_ _1044_ VGND VGND VPWR VPWR _1244_ sky130_fd_sc_hd__mux2_1
XFILLER_0_9_413 VPWR VGND VPWR VGND sky130_ef_sc_hd__decap_12
XPHY_EDGE_ROW_77_Right_77 VGND VGND VPWR VPWR sky130_fd_sc_hd__decap_3
X_3986_ _1853_ RF0.regs\[15\]\[26\] _2060_ VGND VGND VPWR VPWR _2066_ sky130_fd_sc_hd__mux2_1
X_2937_ _1096_ VGND VGND VPWR VPWR _1097_ sky130_fd_sc_hd__buf_2
XFILLER_0_17_268 VGND VGND VPWR VPWR sky130_fd_sc_hd__fill_1
XTAP_TAPCELL_ROW_20_347 VGND VPWR sky130_fd_sc_hd__tapvpwrvgnd_1
X_2868_ _0863_ _1028_ _0722_ VGND VGND VPWR VPWR _1029_ sky130_fd_sc_hd__mux2_1
X_4607_ clknet_leaf_22_clk _0257_ _0001_ VGND VGND VPWR VPWR RF0.regs\[30\]\[1\] sky130_fd_sc_hd__dfrtp_1
XFILLER_0_32_238 VGND VGND VPWR VPWR sky130_fd_sc_hd__decap_3
X_2799_ RF0.regs\[10\]\[21\] _0616_ _0673_ RF0.regs\[25\]\[21\] VGND VGND VPWR VPWR
+ _0960_ sky130_fd_sc_hd__a22oi_4
X_4538_ _2281_ VGND VGND VPWR VPWR _0193_ sky130_fd_sc_hd__inv_2
XFILLER_0_4_195 VGND VGND VPWR VPWR sky130_fd_sc_hd__fill_1
X_4469_ _2270_ VGND VGND VPWR VPWR _0135_ sky130_fd_sc_hd__inv_2
XFILLER_0_68_91 VGND VGND VPWR VPWR sky130_fd_sc_hd__decap_3
XTAP_TAPCELL_ROW_28_414 VGND VPWR sky130_fd_sc_hd__tapvpwrvgnd_1
XFILLER_0_67_124 VPWR VGND VPWR VGND sky130_ef_sc_hd__decap_12
XTAP_TAPCELL_ROW_36_480 VGND VPWR sky130_fd_sc_hd__tapvpwrvgnd_1
Xrebuffer9 net46 VGND VGND VPWR VPWR net44 sky130_fd_sc_hd__dlymetal6s4s_1
XTAP_TAPCELL_ROW_79_848 VGND VPWR sky130_fd_sc_hd__tapvpwrvgnd_1
XFILLER_0_64_27 VGND VGND VPWR VPWR sky130_fd_sc_hd__fill_1
XTAP_TAPCELL_ROW_62_704 VGND VPWR sky130_fd_sc_hd__tapvpwrvgnd_1
XFILLER_0_80_15 VPWR VGND VPWR VGND sky130_ef_sc_hd__decap_12
X_3840_ _1749_ _1970_ VGND VGND VPWR VPWR _1974_ sky130_fd_sc_hd__nor2_1
X_3771_ _1208_ _1523_ _1076_ VGND VGND VPWR VPWR _1912_ sky130_fd_sc_hd__mux2_1
XTAP_TAPCELL_ROW_70_770 VGND VPWR sky130_fd_sc_hd__tapvpwrvgnd_1
XFILLER_0_73_127 VPWR VGND VPWR VGND sky130_ef_sc_hd__decap_12
X_2722_ RF0.regs\[10\]\[4\] _0809_ _0669_ RF0.regs\[25\]\[4\] VGND VGND VPWR VPWR
+ _0883_ sky130_fd_sc_hd__a22o_1
XFILLER_0_81_193 VGND VGND VPWR VPWR sky130_fd_sc_hd__decap_3
X_2653_ _0729_ _0730_ _0732_ _0731_ VGND VGND VPWR VPWR _0814_ sky130_fd_sc_hd__o31a_1
XFILLER_0_1_110 VGND VGND VPWR VPWR sky130_fd_sc_hd__fill_2
X_2584_ _0734_ _0739_ _0741_ _0744_ VGND VGND VPWR VPWR _0745_ sky130_fd_sc_hd__and4b_1
XFILLER_0_10_433 VPWR VGND VPWR VGND sky130_ef_sc_hd__decap_12
X_4323_ _2250_ VGND VGND VPWR VPWR _0009_ sky130_fd_sc_hd__inv_2
XFILLER_0_10_477 VGND VGND VPWR VPWR sky130_fd_sc_hd__decap_4
X_4254_ _1002_ _2206_ _2207_ _2208_ VGND VGND VPWR VPWR net27 sky130_fd_sc_hd__a2bb2o_1
X_4185_ _2172_ VGND VGND VPWR VPWR _0286_ sky130_fd_sc_hd__clkbuf_1
X_3205_ _1361_ _1363_ _1037_ VGND VGND VPWR VPWR _1364_ sky130_fd_sc_hd__mux2_1
XFILLER_0_38_94 VPWR VGND VPWR VGND sky130_ef_sc_hd__decap_12
X_3136_ _0851_ _1022_ _1042_ VGND VGND VPWR VPWR _1296_ sky130_fd_sc_hd__mux2_1
X_3067_ _1225_ _1226_ _1011_ VGND VGND VPWR VPWR _1227_ sky130_fd_sc_hd__mux2_1
XFILLER_0_9_232 VGND VGND VPWR VPWR sky130_fd_sc_hd__decap_4
XFILLER_0_9_210 VGND VGND VPWR VPWR sky130_fd_sc_hd__decap_8
XFILLER_0_64_105 VGND VGND VPWR VPWR sky130_fd_sc_hd__decap_6
XFILLER_0_64_138 VGND VGND VPWR VPWR sky130_fd_sc_hd__fill_2
X_3969_ _2056_ VGND VGND VPWR VPWR _0386_ sky130_fd_sc_hd__clkbuf_1
XFILLER_0_60_300 VGND VGND VPWR VPWR sky130_fd_sc_hd__decap_8
XTAP_TAPCELL_ROW_76_818 VGND VPWR sky130_fd_sc_hd__tapvpwrvgnd_1
XFILLER_0_68_400 VGND VGND VPWR VPWR sky130_fd_sc_hd__fill_1
XFILLER_0_68_433 VPWR VGND VPWR VGND sky130_ef_sc_hd__decap_12
XFILLER_0_28_319 VGND VGND VPWR VPWR sky130_fd_sc_hd__decap_6
XFILLER_0_68_477 VGND VGND VPWR VPWR sky130_fd_sc_hd__decap_4
XFILLER_0_50_29 VPWR VGND VPWR VGND sky130_ef_sc_hd__decap_12
XFILLER_0_3_408 VPWR VGND VPWR VGND sky130_ef_sc_hd__decap_12
XFILLER_0_51_333 VGND VGND VPWR VPWR sky130_fd_sc_hd__decap_3
XFILLER_0_63_193 VGND VGND VPWR VPWR sky130_fd_sc_hd__fill_2
XFILLER_0_59_27 VPWR VGND VPWR VGND sky130_ef_sc_hd__decap_12
XFILLER_0_75_15 VPWR VGND VPWR VGND sky130_ef_sc_hd__decap_12
XTAP_TAPCELL_ROW_39_509 VGND VPWR sky130_fd_sc_hd__tapvpwrvgnd_1
XFILLER_0_78_219 VGND VGND VPWR VPWR sky130_fd_sc_hd__fill_2
XTAP_TAPCELL_ROW_47_575 VGND VPWR sky130_fd_sc_hd__tapvpwrvgnd_1
XFILLER_0_46_127 VPWR VGND VPWR VGND sky130_ef_sc_hd__decap_12
X_3823_ _1960_ VGND VGND VPWR VPWR _0436_ sky130_fd_sc_hd__clkbuf_1
XFILLER_0_74_469 VGND VGND VPWR VPWR sky130_fd_sc_hd__decap_6
XFILLER_0_27_330 VGND VGND VPWR VPWR sky130_fd_sc_hd__decap_6
XFILLER_0_27_352 VGND VGND VPWR VPWR sky130_fd_sc_hd__decap_3
XFILLER_0_6_246 VGND VGND VPWR VPWR sky130_fd_sc_hd__decap_3
X_3754_ _1892_ _1894_ _1577_ VGND VGND VPWR VPWR _1895_ sky130_fd_sc_hd__o21a_1
XTAP_TAPCELL_ROW_30_431 VGND VPWR sky130_fd_sc_hd__tapvpwrvgnd_1
X_2705_ RF0.regs\[10\]\[0\] _0809_ _0667_ RF0.regs\[25\]\[0\] VGND VGND VPWR VPWR
+ _0866_ sky130_fd_sc_hd__a22o_1
XFILLER_0_42_333 VGND VGND VPWR VPWR sky130_fd_sc_hd__decap_6
X_3685_ _0512_ _0605_ _0635_ VGND VGND VPWR VPWR _1834_ sky130_fd_sc_hd__nand3_2
XFILLER_0_42_377 VGND VGND VPWR VPWR sky130_fd_sc_hd__decap_3
X_2636_ _0771_ _0690_ VGND VGND VPWR VPWR _0797_ sky130_fd_sc_hd__nand2_1
X_2567_ _0706_ _0727_ _0724_ _0726_ VGND VGND VPWR VPWR _0728_ sky130_fd_sc_hd__or4_4
XFILLER_0_57_3 VPWR VGND VPWR VGND sky130_ef_sc_hd__decap_12
X_2498_ _0658_ VGND VGND VPWR VPWR _0659_ sky130_fd_sc_hd__buf_2
X_4306_ _1040_ _2229_ _2241_ _2243_ VGND VGND VPWR VPWR _2244_ sky130_fd_sc_hd__a2bb2o_1
X_4237_ _2199_ VGND VGND VPWR VPWR _0261_ sky130_fd_sc_hd__clkbuf_1
X_4168_ _2011_ RF0.regs\[25\]\[5\] _2156_ VGND VGND VPWR VPWR _2163_ sky130_fd_sc_hd__mux2_1
XFILLER_0_69_208 VGND VGND VPWR VPWR sky130_fd_sc_hd__decap_8
XTAP_TAPCELL_ROW_2_189 VGND VPWR sky130_fd_sc_hd__tapvpwrvgnd_1
X_4099_ _2126_ VGND VGND VPWR VPWR _0326_ sky130_fd_sc_hd__clkbuf_1
X_3119_ _1187_ _1278_ _1076_ VGND VGND VPWR VPWR _1279_ sky130_fd_sc_hd__mux2_1
XFILLER_0_77_241 VGND VGND VPWR VPWR sky130_fd_sc_hd__fill_1
XTAP_TAPCELL_ROW_81_865 VGND VPWR sky130_fd_sc_hd__tapvpwrvgnd_1
XTAP_TAPCELL_ROW_81_876 VGND VPWR sky130_fd_sc_hd__tapvpwrvgnd_1
XFILLER_0_18_363 VGND VGND VPWR VPWR sky130_fd_sc_hd__fill_1
XFILLER_0_60_141 VGND VGND VPWR VPWR sky130_fd_sc_hd__decap_3
XFILLER_0_28_105 VGND VGND VPWR VPWR sky130_fd_sc_hd__decap_8
XFILLER_0_61_39 VPWR VGND VPWR VGND sky130_ef_sc_hd__decap_12
XFILLER_0_28_138 VGND VGND VPWR VPWR sky130_fd_sc_hd__fill_2
XFILLER_0_56_425 VGND VGND VPWR VPWR sky130_fd_sc_hd__decap_6
XFILLER_0_71_417 VPWR VGND VPWR VGND sky130_ef_sc_hd__decap_12
XFILLER_0_10_76 VGND VGND VPWR VPWR sky130_fd_sc_hd__fill_1
X_3470_ RF0.regs\[10\]\[4\] _0628_ _0616_ RF0.regs\[25\]\[4\] VGND VGND VPWR VPWR
+ _1626_ sky130_fd_sc_hd__a22o_1
X_2421_ _0585_ VGND VGND VPWR VPWR _0451_ sky130_fd_sc_hd__clkbuf_1
X_2352_ net72 _0516_ VGND VGND VPWR VPWR _0551_ sky130_fd_sc_hd__nor2_1
XFILLER_0_19_63 VGND VGND VPWR VPWR sky130_fd_sc_hd__fill_1
XFILLER_0_19_96 VGND VGND VPWR VPWR sky130_fd_sc_hd__decap_4
X_4022_ _2001_ RF0.regs\[15\]\[9\] _2082_ VGND VGND VPWR VPWR _2085_ sky130_fd_sc_hd__mux2_1
XFILLER_0_35_40 VGND VGND VPWR VPWR sky130_fd_sc_hd__fill_1
XFILLER_0_59_241 VGND VGND VPWR VPWR sky130_fd_sc_hd__fill_1
X_4855_ clknet_leaf_26_clk _0505_ _0249_ VGND VGND VPWR VPWR IM0.addr\[25\] sky130_fd_sc_hd__dfrtp_1
X_3806_ _1454_ _1939_ _1940_ _1946_ VGND VGND VPWR VPWR _1947_ sky130_fd_sc_hd__a2bb2o_1
X_4786_ clknet_leaf_4_clk _0436_ _0180_ VGND VGND VPWR VPWR RF0.regs\[5\]\[20\] sky130_fd_sc_hd__dfrtp_1
X_3737_ _1876_ _1877_ _1064_ VGND VGND VPWR VPWR _1878_ sky130_fd_sc_hd__mux2_1
XFILLER_0_42_130 VGND VGND VPWR VPWR sky130_fd_sc_hd__decap_4
XFILLER_0_15_355 VGND VGND VPWR VPWR sky130_fd_sc_hd__decap_3
XFILLER_0_42_141 VPWR VGND VPWR VGND sky130_ef_sc_hd__decap_12
X_3668_ _1065_ _1391_ VGND VGND VPWR VPWR _1819_ sky130_fd_sc_hd__nor2_1
X_3599_ _1725_ _1730_ _1749_ VGND VGND VPWR VPWR _1750_ sky130_fd_sc_hd__and3b_1
X_2619_ _0777_ _0778_ VGND VGND VPWR VPWR _0780_ sky130_fd_sc_hd__nor2_1
XTAP_TAPCELL_ROW_7_237 VGND VPWR sky130_fd_sc_hd__tapvpwrvgnd_1
XTAP_TAPCELL_ROW_41_526 VGND VPWR sky130_fd_sc_hd__tapvpwrvgnd_1
XFILLER_0_21_358 VGND VGND VPWR VPWR sky130_fd_sc_hd__fill_2
XFILLER_0_72_27 VGND VGND VPWR VPWR sky130_fd_sc_hd__fill_1
X_2970_ _1126_ _1127_ _1129_ _1059_ VGND VGND VPWR VPWR _1130_ sky130_fd_sc_hd__a31o_1
XFILLER_0_16_119 VGND VGND VPWR VPWR sky130_fd_sc_hd__fill_2
X_4640_ clknet_leaf_19_clk _0290_ _0034_ VGND VGND VPWR VPWR RF0.regs\[25\]\[2\] sky130_fd_sc_hd__dfrtp_4
XFILLER_0_56_299 VGND VGND VPWR VPWR sky130_fd_sc_hd__fill_1
XFILLER_0_71_225 VGND VGND VPWR VPWR sky130_fd_sc_hd__fill_2
X_4571_ _2284_ VGND VGND VPWR VPWR _0223_ sky130_fd_sc_hd__inv_2
XFILLER_0_12_303 VGND VGND VPWR VPWR sky130_fd_sc_hd__decap_4
XFILLER_0_52_461 VGND VGND VPWR VPWR sky130_fd_sc_hd__fill_2
XFILLER_0_52_472 VGND VGND VPWR VPWR sky130_fd_sc_hd__decap_4
X_3522_ _1670_ _1671_ net12 VGND VGND VPWR VPWR _1676_ sky130_fd_sc_hd__mux2_2
XFILLER_0_12_369 VGND VGND VPWR VPWR sky130_fd_sc_hd__fill_1
X_3453_ _1096_ _1592_ _1607_ _1608_ _0713_ VGND VGND VPWR VPWR _1609_ sky130_fd_sc_hd__o32a_2
X_2404_ net106 VGND VGND VPWR VPWR _0577_ sky130_fd_sc_hd__clkbuf_1
X_3384_ _0651_ _1489_ _1540_ VGND VGND VPWR VPWR _1541_ sky130_fd_sc_hd__and3_1
X_2335_ _0524_ net64 VGND VGND VPWR VPWR _0496_ sky130_fd_sc_hd__nor2_1
XTAP_TAPCELL_ROW_4_207 VGND VPWR sky130_fd_sc_hd__tapvpwrvgnd_1
XFILLER_0_46_94 VGND VGND VPWR VPWR sky130_fd_sc_hd__decap_4
X_4005_ _1972_ RF0.regs\[15\]\[17\] _2071_ VGND VGND VPWR VPWR _2076_ sky130_fd_sc_hd__mux2_1
X_4838_ clknet_leaf_0_clk _0488_ _0232_ VGND VGND VPWR VPWR IM0.addr\[8\] sky130_fd_sc_hd__dfrtp_1
XFILLER_0_47_277 VGND VGND VPWR VPWR sky130_fd_sc_hd__decap_3
XFILLER_0_7_374 VGND VGND VPWR VPWR sky130_fd_sc_hd__fill_1
XFILLER_0_7_396 VGND VGND VPWR VPWR sky130_fd_sc_hd__decap_6
X_4769_ clknet_leaf_24_clk _0419_ _0163_ VGND VGND VPWR VPWR RF0.regs\[5\]\[3\] sky130_fd_sc_hd__dfrtp_1
XFILLER_0_43_461 VGND VGND VPWR VPWR sky130_fd_sc_hd__fill_1
XFILLER_0_11_380 VPWR VGND VPWR VGND sky130_ef_sc_hd__decap_12
Xhold21 IM0.addr\[25\] VGND VGND VPWR VPWR net56 sky130_fd_sc_hd__dlygate4sd3_1
Xhold32 _0546_ VGND VGND VPWR VPWR net67 sky130_fd_sc_hd__dlygate4sd3_1
Xhold54 RF0.regs\[0\]\[31\] VGND VGND VPWR VPWR net89 sky130_fd_sc_hd__dlygate4sd3_1
Xhold43 IM0.addr\[27\] VGND VGND VPWR VPWR net78 sky130_fd_sc_hd__dlygate4sd3_1
Xhold65 RF0.regs\[0\]\[4\] VGND VGND VPWR VPWR net100 sky130_fd_sc_hd__dlygate4sd3_1
Xhold76 RF0.regs\[0\]\[0\] VGND VGND VPWR VPWR net111 sky130_fd_sc_hd__dlygate4sd3_1
Xhold98 RF0.regs\[20\]\[10\] VGND VGND VPWR VPWR net133 sky130_fd_sc_hd__dlygate4sd3_1
Xhold87 RF0.regs\[20\]\[25\] VGND VGND VPWR VPWR net122 sky130_fd_sc_hd__dlygate4sd3_1
XTAP_TAPCELL_ROW_26_397 VGND VPWR sky130_fd_sc_hd__tapvpwrvgnd_1
XFILLER_0_26_439 VGND VGND VPWR VPWR sky130_fd_sc_hd__decap_8
XFILLER_0_53_225 VPWR VGND VPWR VGND sky130_ef_sc_hd__decap_12
XFILLER_0_67_27 VPWR VGND VPWR VGND sky130_ef_sc_hd__decap_12
XTAP_TAPCELL_ROW_17_320 VGND VPWR sky130_fd_sc_hd__tapvpwrvgnd_1
X_2953_ _1006_ _0909_ _1004_ VGND VGND VPWR VPWR _1113_ sky130_fd_sc_hd__mux2_1
XFILLER_0_8_138 VGND VGND VPWR VPWR sky130_fd_sc_hd__fill_2
XFILLER_0_29_288 VGND VGND VPWR VPWR sky130_fd_sc_hd__decap_8
XFILLER_0_44_203 VGND VGND VPWR VPWR sky130_fd_sc_hd__fill_2
XTAP_TAPCELL_ROW_60_687 VGND VPWR sky130_fd_sc_hd__tapvpwrvgnd_1
X_2884_ _0799_ _0796_ _1044_ VGND VGND VPWR VPWR _1045_ sky130_fd_sc_hd__mux2_1
X_4623_ clknet_leaf_5_clk _0273_ _0017_ VGND VGND VPWR VPWR RF0.regs\[30\]\[17\] sky130_fd_sc_hd__dfrtp_1
X_4554_ _2282_ VGND VGND VPWR VPWR _0208_ sky130_fd_sc_hd__inv_2
XFILLER_0_12_144 VGND VGND VPWR VPWR sky130_fd_sc_hd__fill_1
X_3505_ RF0.regs\[0\]\[2\] _0602_ VGND VGND VPWR VPWR _1660_ sky130_fd_sc_hd__nor2_1
XFILLER_0_12_155 VGND VGND VPWR VPWR sky130_fd_sc_hd__fill_1
X_4485_ _2272_ VGND VGND VPWR VPWR _0149_ sky130_fd_sc_hd__inv_2
X_3436_ _0850_ _0851_ _1592_ VGND VGND VPWR VPWR _1593_ sky130_fd_sc_hd__a21o_1
X_3367_ _1523_ VGND VGND VPWR VPWR _1524_ sky130_fd_sc_hd__inv_2
X_2318_ _0531_ _0537_ VGND VGND VPWR VPWR _0506_ sky130_fd_sc_hd__nor2_1
XFILLER_0_57_93 VGND VGND VPWR VPWR sky130_fd_sc_hd__fill_2
X_3298_ _1455_ _0966_ _0961_ VGND VGND VPWR VPWR _1456_ sky130_fd_sc_hd__and3_1
XTAP_TAPCELL_ROW_68_754 VGND VPWR sky130_fd_sc_hd__tapvpwrvgnd_1
XFILLER_0_79_144 VGND VGND VPWR VPWR sky130_fd_sc_hd__fill_1
XFILLER_0_67_317 VPWR VGND VPWR VGND sky130_ef_sc_hd__decap_12
XTAP_TAPCELL_ROW_51_610 VGND VPWR sky130_fd_sc_hd__tapvpwrvgnd_1
XFILLER_0_16_461 VPWR VGND VPWR VGND sky130_ef_sc_hd__decap_12
XFILLER_0_31_442 VGND VGND VPWR VPWR sky130_fd_sc_hd__decap_6
Xoutput22 net22 VGND VGND VPWR VPWR Result[29] sky130_fd_sc_hd__clkbuf_4
Xoutput9 net9 VGND VGND VPWR VPWR Result[17] sky130_fd_sc_hd__buf_2
Xoutput11 net11 VGND VGND VPWR VPWR Result[19] sky130_fd_sc_hd__buf_2
XFILLER_0_9_3 VPWR VGND VPWR VGND sky130_ef_sc_hd__decap_12
XFILLER_0_26_203 VGND VGND VPWR VPWR sky130_fd_sc_hd__fill_1
XFILLER_0_26_236 VGND VGND VPWR VPWR sky130_fd_sc_hd__fill_2
XFILLER_0_78_15 VPWR VGND VPWR VGND sky130_ef_sc_hd__decap_12
X_4270_ _2219_ VGND VGND VPWR VPWR net3 sky130_fd_sc_hd__inv_2
X_3221_ _1270_ _1304_ _1360_ _1377_ _1379_ VGND VGND VPWR VPWR _1380_ sky130_fd_sc_hd__a311oi_4
X_3152_ _1310_ _0977_ VGND VGND VPWR VPWR _1311_ sky130_fd_sc_hd__nor2_1
X_3083_ RF0.regs\[10\]\[25\] _1090_ _0675_ RF0.regs\[25\]\[25\] VGND VGND VPWR VPWR
+ _1243_ sky130_fd_sc_hd__a22o_1
XFILLER_0_49_328 VGND VGND VPWR VPWR sky130_fd_sc_hd__decap_8
XFILLER_0_9_425 VPWR VGND VPWR VGND sky130_ef_sc_hd__decap_12
XFILLER_0_43_51 VGND VGND VPWR VPWR sky130_fd_sc_hd__decap_4
XFILLER_0_57_361 VGND VGND VPWR VPWR sky130_fd_sc_hd__decap_6
X_3985_ _2065_ VGND VGND VPWR VPWR _0379_ sky130_fd_sc_hd__clkbuf_1
XFILLER_0_72_320 VGND VGND VPWR VPWR sky130_fd_sc_hd__decap_4
XFILLER_0_17_225 VPWR VGND VPWR VGND sky130_ef_sc_hd__decap_12
X_2936_ _1095_ VGND VGND VPWR VPWR _1096_ sky130_fd_sc_hd__clkbuf_4
XFILLER_0_72_353 VGND VGND VPWR VPWR sky130_fd_sc_hd__decap_6
X_2867_ RF0.regs\[10\]\[0\] _0613_ _0668_ RF0.regs\[25\]\[0\] VGND VGND VPWR VPWR
+ _1028_ sky130_fd_sc_hd__a22oi_4
XTAP_TAPCELL_ROW_20_348 VGND VPWR sky130_fd_sc_hd__tapvpwrvgnd_1
X_4606_ clknet_leaf_24_clk _0256_ _0000_ VGND VGND VPWR VPWR RF0.regs\[30\]\[0\] sky130_fd_sc_hd__dfrtp_1
XFILLER_0_4_141 VGND VGND VPWR VPWR sky130_fd_sc_hd__fill_2
X_2798_ _0624_ _0793_ _0958_ VGND VGND VPWR VPWR _0959_ sky130_fd_sc_hd__or3_4
X_4537_ _2281_ VGND VGND VPWR VPWR _0192_ sky130_fd_sc_hd__inv_2
X_4468_ _2270_ VGND VGND VPWR VPWR _0134_ sky130_fd_sc_hd__inv_2
XFILLER_0_0_391 VGND VGND VPWR VPWR sky130_fd_sc_hd__fill_1
X_3419_ RF0.regs\[20\]\[8\] _0624_ _1090_ RF0.regs\[25\]\[8\] _1575_ VGND VGND VPWR
+ VPWR _1576_ sky130_fd_sc_hd__a221o_1
X_4399_ _2260_ VGND VGND VPWR VPWR _0075_ sky130_fd_sc_hd__inv_2
XTAP_TAPCELL_ROW_28_415 VGND VPWR sky130_fd_sc_hd__tapvpwrvgnd_1
XFILLER_0_67_136 VGND VGND VPWR VPWR sky130_fd_sc_hd__decap_8
XTAP_TAPCELL_ROW_36_481 VGND VPWR sky130_fd_sc_hd__tapvpwrvgnd_1
XFILLER_0_67_169 VGND VGND VPWR VPWR sky130_fd_sc_hd__decap_6
XFILLER_0_48_29 VPWR VGND VPWR VGND sky130_ef_sc_hd__decap_12
XTAP_TAPCELL_ROW_79_849 VGND VPWR sky130_fd_sc_hd__tapvpwrvgnd_1
XTAP_TAPCELL_ROW_62_705 VGND VPWR sky130_fd_sc_hd__tapvpwrvgnd_1
XFILLER_0_80_27 VGND VGND VPWR VPWR sky130_fd_sc_hd__fill_1
XFILLER_0_73_106 VGND VGND VPWR VPWR sky130_fd_sc_hd__decap_3
XFILLER_0_6_417 VGND VGND VPWR VPWR sky130_fd_sc_hd__decap_3
X_3770_ _1098_ _1491_ _1493_ _1152_ _1910_ VGND VGND VPWR VPWR _1911_ sky130_fd_sc_hd__o32a_1
XTAP_TAPCELL_ROW_70_771 VGND VPWR sky130_fd_sc_hd__tapvpwrvgnd_1
X_2721_ _0875_ _0879_ _0881_ VGND VGND VPWR VPWR _0882_ sky130_fd_sc_hd__a21o_1
X_2652_ net45 _0733_ VGND VGND VPWR VPWR _0813_ sky130_fd_sc_hd__nor2_1
X_2583_ _0743_ VGND VGND VPWR VPWR _0744_ sky130_fd_sc_hd__inv_2
XFILLER_0_10_445 VPWR VGND VPWR VGND sky130_ef_sc_hd__decap_12
X_4322_ _2250_ VGND VGND VPWR VPWR _0008_ sky130_fd_sc_hd__inv_2
X_4253_ _1630_ _0882_ _1099_ VGND VGND VPWR VPWR _2208_ sky130_fd_sc_hd__a21oi_1
X_3204_ _1111_ _1362_ _1062_ VGND VGND VPWR VPWR _1363_ sky130_fd_sc_hd__mux2_1
X_4184_ _1838_ RF0.regs\[30\]\[30\] _2170_ VGND VGND VPWR VPWR _2172_ sky130_fd_sc_hd__mux2_2
X_3135_ _1057_ _1294_ VGND VGND VPWR VPWR _1295_ sky130_fd_sc_hd__nor2_1
X_3066_ _1168_ _0915_ _1007_ VGND VGND VPWR VPWR _1226_ sky130_fd_sc_hd__mux2_1
XFILLER_0_49_147 VGND VGND VPWR VPWR sky130_fd_sc_hd__fill_1
XFILLER_0_49_169 VGND VGND VPWR VPWR sky130_fd_sc_hd__fill_2
X_3968_ _2018_ RF0.regs\[10\]\[2\] _2046_ VGND VGND VPWR VPWR _2056_ sky130_fd_sc_hd__mux2_1
X_2919_ _1052_ VGND VGND VPWR VPWR _1080_ sky130_fd_sc_hd__clkbuf_4
X_3899_ _2018_ RF0.regs\[5\]\[2\] _1994_ VGND VGND VPWR VPWR _2019_ sky130_fd_sc_hd__mux2_1
XFILLER_0_5_461 VPWR VGND VPWR VGND sky130_ef_sc_hd__decap_12
XFILLER_0_60_334 VGND VGND VPWR VPWR sky130_fd_sc_hd__fill_1
XTAP_TAPCELL_ROW_76_819 VGND VPWR sky130_fd_sc_hd__tapvpwrvgnd_1
XFILLER_0_68_445 VPWR VGND VPWR VGND sky130_ef_sc_hd__decap_12
XFILLER_0_28_309 VGND VGND VPWR VPWR sky130_fd_sc_hd__fill_1
XFILLER_0_51_301 VPWR VGND VPWR VGND sky130_ef_sc_hd__decap_12
XFILLER_0_63_161 VGND VGND VPWR VPWR sky130_fd_sc_hd__decap_3
XFILLER_0_59_39 VPWR VGND VPWR VGND sky130_ef_sc_hd__decap_12
XFILLER_0_75_27 VPWR VGND VPWR VGND sky130_ef_sc_hd__decap_12
XTAP_TAPCELL_ROW_47_576 VGND VPWR sky130_fd_sc_hd__tapvpwrvgnd_1
XFILLER_0_59_467 VGND VGND VPWR VPWR sky130_fd_sc_hd__decap_8
XFILLER_0_46_139 VGND VGND VPWR VPWR sky130_fd_sc_hd__fill_1
X_3822_ _1959_ RF0.regs\[5\]\[20\] _1957_ VGND VGND VPWR VPWR _1960_ sky130_fd_sc_hd__mux2_1
X_3753_ _1001_ _1893_ VGND VGND VPWR VPWR _1894_ sky130_fd_sc_hd__nor2_1
XTAP_TAPCELL_ROW_30_432 VGND VPWR sky130_fd_sc_hd__tapvpwrvgnd_1
XFILLER_0_40_52 VGND VGND VPWR VPWR sky130_fd_sc_hd__fill_2
X_3684_ _1088_ _1832_ VGND VGND VPWR VPWR _1833_ sky130_fd_sc_hd__xnor2_4
X_2704_ _0710_ _0719_ _0720_ _0721_ VGND VGND VPWR VPWR _0865_ sky130_fd_sc_hd__o31ai_4
XFILLER_0_40_74 VGND VGND VPWR VPWR sky130_fd_sc_hd__fill_1
XFILLER_0_54_183 VGND VGND VPWR VPWR sky130_fd_sc_hd__decap_3
XFILLER_0_54_194 VGND VGND VPWR VPWR sky130_fd_sc_hd__fill_2
X_2635_ RF0.regs\[10\]\[22\] _0617_ _0674_ RF0.regs\[25\]\[22\] VGND VGND VPWR VPWR
+ _0796_ sky130_fd_sc_hd__a22o_1
XFILLER_0_2_475 VGND VGND VPWR VPWR sky130_fd_sc_hd__fill_1
XFILLER_0_10_253 VGND VGND VPWR VPWR sky130_fd_sc_hd__fill_2
X_2566_ RF0.regs\[15\]\[6\] _0662_ _0667_ RF0.regs\[5\]\[6\] VGND VGND VPWR VPWR _0727_
+ sky130_fd_sc_hd__a22o_1
X_4305_ _1066_ _2242_ _1126_ _1127_ VGND VGND VPWR VPWR _2243_ sky130_fd_sc_hd__nand4_1
XFILLER_0_10_275 VGND VGND VPWR VPWR sky130_fd_sc_hd__decap_4
X_2497_ _0657_ VGND VGND VPWR VPWR _0658_ sky130_fd_sc_hd__clkbuf_4
X_4236_ _2011_ net161 _2192_ VGND VGND VPWR VPWR _2199_ sky130_fd_sc_hd__mux2_1
XFILLER_0_4_41 VGND VGND VPWR VPWR sky130_fd_sc_hd__fill_2
X_4167_ _2162_ VGND VGND VPWR VPWR _0294_ sky130_fd_sc_hd__clkbuf_1
XFILLER_0_4_85 VGND VGND VPWR VPWR sky130_fd_sc_hd__fill_1
X_3118_ _0789_ _0799_ _1044_ VGND VGND VPWR VPWR _1278_ sky130_fd_sc_hd__mux2_1
X_4098_ net141 _2009_ _2120_ VGND VGND VPWR VPWR _2126_ sky130_fd_sc_hd__mux2_1
X_3049_ _1054_ _0937_ _1068_ VGND VGND VPWR VPWR _1209_ sky130_fd_sc_hd__mux2_1
XTAP_TAPCELL_ROW_81_866 VGND VPWR sky130_fd_sc_hd__tapvpwrvgnd_1
XFILLER_0_81_81 VGND VGND VPWR VPWR sky130_fd_sc_hd__decap_3
XTAP_TAPCELL_ROW_81_877 VGND VPWR sky130_fd_sc_hd__tapvpwrvgnd_1
XFILLER_0_73_481 VGND VGND VPWR VPWR sky130_fd_sc_hd__fill_1
XFILLER_0_18_386 VGND VGND VPWR VPWR sky130_fd_sc_hd__decap_8
XTAP_TAPCELL_ROW_44_546 VGND VPWR sky130_fd_sc_hd__tapvpwrvgnd_1
XFILLER_0_56_415 VGND VGND VPWR VPWR sky130_fd_sc_hd__fill_1
XFILLER_0_68_253 VPWR VGND VPWR VGND sky130_ef_sc_hd__decap_12
XFILLER_0_64_481 VGND VGND VPWR VPWR sky130_fd_sc_hd__fill_1
XFILLER_0_71_429 VPWR VGND VPWR VGND sky130_ef_sc_hd__decap_12
XFILLER_0_10_66 VGND VGND VPWR VPWR sky130_fd_sc_hd__fill_2
X_2420_ net88 VGND VGND VPWR VPWR _0585_ sky130_fd_sc_hd__clkbuf_1
XFILLER_0_51_186 VGND VGND VPWR VPWR sky130_fd_sc_hd__fill_1
X_2351_ IM0.addr\[6\] _0517_ VGND VGND VPWR VPWR _0486_ sky130_fd_sc_hd__xor2_1
X_4021_ _2084_ VGND VGND VPWR VPWR _0362_ sky130_fd_sc_hd__clkbuf_1
XFILLER_0_35_63 VGND VGND VPWR VPWR sky130_fd_sc_hd__fill_2
XFILLER_0_74_212 VGND VGND VPWR VPWR sky130_fd_sc_hd__decap_3
XFILLER_0_19_117 VGND VGND VPWR VPWR sky130_fd_sc_hd__fill_1
X_4854_ clknet_leaf_26_clk _0504_ _0248_ VGND VGND VPWR VPWR IM0.addr\[24\] sky130_fd_sc_hd__dfrtp_1
XFILLER_0_27_161 VGND VGND VPWR VPWR sky130_fd_sc_hd__decap_6
X_4785_ clknet_leaf_4_clk _0435_ _0179_ VGND VGND VPWR VPWR RF0.regs\[5\]\[19\] sky130_fd_sc_hd__dfrtp_1
X_3805_ _1473_ _1945_ VGND VGND VPWR VPWR _1946_ sky130_fd_sc_hd__and2_1
X_3736_ _1519_ _1515_ _1075_ VGND VGND VPWR VPWR _1877_ sky130_fd_sc_hd__mux2_1
XFILLER_0_42_153 VPWR VGND VPWR VGND sky130_ef_sc_hd__decap_12
X_3667_ _1300_ _1816_ _1291_ _1817_ VGND VGND VPWR VPWR _1818_ sky130_fd_sc_hd__a22o_1
X_3598_ _1735_ net8 _1748_ VGND VGND VPWR VPWR _1749_ sky130_fd_sc_hd__o21a_1
X_2618_ _0777_ _0778_ VGND VGND VPWR VPWR _0779_ sky130_fd_sc_hd__and2_1
X_2549_ _0709_ VGND VGND VPWR VPWR _0710_ sky130_fd_sc_hd__clkbuf_4
XTAP_TAPCELL_ROW_7_238 VGND VPWR sky130_fd_sc_hd__tapvpwrvgnd_1
X_4219_ _1988_ RF0.regs\[30\]\[13\] _2181_ VGND VGND VPWR VPWR _2190_ sky130_fd_sc_hd__mux2_1
XFILLER_0_65_223 VGND VGND VPWR VPWR sky130_fd_sc_hd__fill_1
XFILLER_0_38_448 VGND VGND VPWR VPWR sky130_fd_sc_hd__decap_6
XTAP_TAPCELL_ROW_41_527 VGND VPWR sky130_fd_sc_hd__tapvpwrvgnd_1
XFILLER_0_80_215 VGND VGND VPWR VPWR sky130_fd_sc_hd__decap_3
XFILLER_0_80_226 VGND VGND VPWR VPWR sky130_fd_sc_hd__decap_6
XFILLER_0_18_194 VGND VGND VPWR VPWR sky130_fd_sc_hd__fill_2
XFILLER_0_46_481 VGND VGND VPWR VPWR sky130_fd_sc_hd__fill_1
XFILLER_0_0_209 VPWR VGND VPWR VGND sky130_ef_sc_hd__decap_12
XFILLER_0_56_29 VPWR VGND VPWR VGND sky130_ef_sc_hd__decap_12
XTAP_TAPCELL_ROW_57_660 VGND VPWR sky130_fd_sc_hd__tapvpwrvgnd_1
XFILLER_0_8_309 VGND VGND VPWR VPWR sky130_fd_sc_hd__decap_4
XFILLER_0_56_245 VGND VGND VPWR VPWR sky130_fd_sc_hd__decap_6
X_4570_ _2284_ VGND VGND VPWR VPWR _0222_ sky130_fd_sc_hd__inv_2
XFILLER_0_37_481 VGND VGND VPWR VPWR sky130_fd_sc_hd__fill_1
X_3521_ _1673_ _1674_ _1675_ VGND VGND VPWR VPWR net12 sky130_fd_sc_hd__o21ai_1
XFILLER_0_24_153 VPWR VGND VPWR VGND sky130_ef_sc_hd__decap_12
XFILLER_0_52_451 VGND VGND VPWR VPWR sky130_fd_sc_hd__fill_1
XFILLER_0_24_197 VGND VGND VPWR VPWR sky130_fd_sc_hd__fill_1
X_3452_ _1202_ _1112_ VGND VGND VPWR VPWR _1608_ sky130_fd_sc_hd__nand2_1
X_2403_ _0576_ VGND VGND VPWR VPWR _0460_ sky130_fd_sc_hd__clkbuf_1
X_3383_ _0917_ _0837_ _0894_ VGND VGND VPWR VPWR _1540_ sky130_fd_sc_hd__nand3_1
X_2334_ IM0.addr\[15\] _0523_ net63 VGND VGND VPWR VPWR _0544_ sky130_fd_sc_hd__a21oi_1
XTAP_TAPCELL_ROW_4_208 VGND VPWR sky130_fd_sc_hd__tapvpwrvgnd_1
X_4004_ _2075_ VGND VGND VPWR VPWR _0370_ sky130_fd_sc_hd__clkbuf_1
XFILLER_0_1_53 VGND VGND VPWR VPWR sky130_fd_sc_hd__decap_3
XFILLER_0_47_223 VGND VGND VPWR VPWR sky130_fd_sc_hd__fill_1
XFILLER_0_62_61 VGND VGND VPWR VPWR sky130_fd_sc_hd__fill_2
X_4837_ clknet_leaf_27_clk _0487_ _0231_ VGND VGND VPWR VPWR IM0.addr\[7\] sky130_fd_sc_hd__dfrtp_1
XFILLER_0_47_289 VGND VGND VPWR VPWR sky130_fd_sc_hd__fill_2
XFILLER_0_28_481 VGND VGND VPWR VPWR sky130_fd_sc_hd__fill_1
X_4768_ clknet_leaf_24_clk _0418_ _0162_ VGND VGND VPWR VPWR RF0.regs\[5\]\[2\] sky130_fd_sc_hd__dfrtp_1
XFILLER_0_43_440 VGND VGND VPWR VPWR sky130_fd_sc_hd__decap_8
X_4699_ clknet_leaf_8_clk _0349_ _0093_ VGND VGND VPWR VPWR RF0.regs\[20\]\[29\] sky130_fd_sc_hd__dfrtp_1
X_3719_ _1860_ VGND VGND VPWR VPWR _0440_ sky130_fd_sc_hd__clkbuf_1
Xhold22 _0538_ VGND VGND VPWR VPWR net57 sky130_fd_sc_hd__dlygate4sd3_1
Xhold55 RF0.regs\[0\]\[29\] VGND VGND VPWR VPWR net90 sky130_fd_sc_hd__dlygate4sd3_1
Xhold33 IM0.addr\[15\] VGND VGND VPWR VPWR net68 sky130_fd_sc_hd__dlygate4sd3_1
Xhold44 IM0.addr\[28\] VGND VGND VPWR VPWR net79 sky130_fd_sc_hd__dlygate4sd3_1
Xhold66 RF0.regs\[0\]\[16\] VGND VGND VPWR VPWR net101 sky130_fd_sc_hd__dlygate4sd3_1
Xhold88 RF0.regs\[20\]\[20\] VGND VGND VPWR VPWR net123 sky130_fd_sc_hd__dlygate4sd3_1
Xhold77 RF0.regs\[0\]\[22\] VGND VGND VPWR VPWR net112 sky130_fd_sc_hd__dlygate4sd3_1
Xhold99 RF0.regs\[20\]\[26\] VGND VGND VPWR VPWR net134 sky130_fd_sc_hd__dlygate4sd3_1
XTAP_TAPCELL_ROW_26_398 VGND VPWR sky130_fd_sc_hd__tapvpwrvgnd_1
XFILLER_0_38_278 VGND VGND VPWR VPWR sky130_fd_sc_hd__decap_3
XFILLER_0_19_481 VGND VGND VPWR VPWR sky130_fd_sc_hd__fill_1
XFILLER_0_61_281 VPWR VGND VPWR VGND sky130_ef_sc_hd__decap_12
XFILLER_0_21_167 VGND VGND VPWR VPWR sky130_fd_sc_hd__fill_1
XFILLER_0_67_39 VPWR VGND VPWR VGND sky130_ef_sc_hd__decap_12
XTAP_TAPCELL_ROW_17_321 VGND VPWR sky130_fd_sc_hd__tapvpwrvgnd_1
X_2952_ _1106_ _1111_ _1062_ VGND VGND VPWR VPWR _1112_ sky130_fd_sc_hd__mux2_1
XFILLER_0_32_53 VPWR VGND VPWR VGND sky130_ef_sc_hd__decap_12
XTAP_TAPCELL_ROW_60_688 VGND VPWR sky130_fd_sc_hd__tapvpwrvgnd_1
X_2883_ _1042_ VGND VGND VPWR VPWR _1044_ sky130_fd_sc_hd__clkbuf_4
X_4622_ clknet_leaf_6_clk _0272_ _0016_ VGND VGND VPWR VPWR RF0.regs\[30\]\[16\] sky130_fd_sc_hd__dfrtp_1
X_4553_ _2282_ VGND VGND VPWR VPWR _0207_ sky130_fd_sc_hd__inv_2
XFILLER_0_52_281 VGND VGND VPWR VPWR sky130_fd_sc_hd__fill_1
X_3504_ _1096_ _1656_ _1657_ _1658_ _1433_ VGND VGND VPWR VPWR _1659_ sky130_fd_sc_hd__o32a_1
X_4484_ _2272_ VGND VGND VPWR VPWR _0148_ sky130_fd_sc_hd__inv_2
X_3435_ _1589_ _1590_ _1591_ VGND VGND VPWR VPWR _1592_ sky130_fd_sc_hd__and3_1
X_3366_ _0909_ _0913_ _1007_ VGND VGND VPWR VPWR _1523_ sky130_fd_sc_hd__mux2_1
X_2317_ net84 _0530_ VGND VGND VPWR VPWR _0537_ sky130_fd_sc_hd__nor2_1
X_3297_ _0948_ _0957_ _0967_ VGND VGND VPWR VPWR _1455_ sky130_fd_sc_hd__a21o_1
XFILLER_0_32_3 VPWR VGND VPWR VGND sky130_ef_sc_hd__decap_12
XTAP_TAPCELL_ROW_68_755 VGND VPWR sky130_fd_sc_hd__tapvpwrvgnd_1
XFILLER_0_67_329 VGND VGND VPWR VPWR sky130_fd_sc_hd__decap_6
XTAP_TAPCELL_ROW_51_611 VGND VPWR sky130_fd_sc_hd__tapvpwrvgnd_1
XTAP_TAPCELL_ROW_23_368 VGND VPWR sky130_fd_sc_hd__tapvpwrvgnd_1
XFILLER_0_16_473 VGND VGND VPWR VPWR sky130_fd_sc_hd__decap_3
XFILLER_0_43_281 VPWR VGND VPWR VGND sky130_ef_sc_hd__decap_12
Xoutput12 net12 VGND VGND VPWR VPWR Result[1] sky130_fd_sc_hd__buf_2
Xoutput23 net23 VGND VGND VPWR VPWR Result[2] sky130_fd_sc_hd__buf_2
XFILLER_0_58_307 VGND VGND VPWR VPWR sky130_fd_sc_hd__fill_1
XFILLER_0_66_362 VGND VGND VPWR VPWR sky130_fd_sc_hd__fill_2
XFILLER_0_41_229 VPWR VGND VPWR VGND sky130_ef_sc_hd__decap_12
XFILLER_0_78_27 VGND VGND VPWR VPWR sky130_fd_sc_hd__fill_1
X_3220_ _1378_ _1269_ VGND VGND VPWR VPWR _1379_ sky130_fd_sc_hd__nor2_1
X_3151_ _0783_ _0784_ VGND VGND VPWR VPWR _1310_ sky130_fd_sc_hd__nor2_1
XFILLER_0_27_53 VGND VGND VPWR VPWR sky130_fd_sc_hd__decap_3
X_3082_ _0982_ _0779_ _0980_ VGND VGND VPWR VPWR _1242_ sky130_fd_sc_hd__or3_1
XTAP_TAPCELL_ROW_65_725 VGND VPWR sky130_fd_sc_hd__tapvpwrvgnd_1
XFILLER_0_9_437 VGND VGND VPWR VPWR sky130_fd_sc_hd__decap_8
X_3984_ _1850_ RF0.regs\[15\]\[27\] _2060_ VGND VGND VPWR VPWR _2065_ sky130_fd_sc_hd__mux2_1
XFILLER_0_17_237 VGND VGND VPWR VPWR sky130_fd_sc_hd__decap_6
X_2935_ _0602_ _0648_ VGND VGND VPWR VPWR _1095_ sky130_fd_sc_hd__nand2_1
XFILLER_0_17_259 VGND VGND VPWR VPWR sky130_fd_sc_hd__fill_2
X_2866_ _1026_ VGND VGND VPWR VPWR _1027_ sky130_fd_sc_hd__inv_2
XFILLER_0_72_398 VGND VGND VPWR VPWR sky130_fd_sc_hd__decap_4
X_4605_ _2247_ VGND VGND VPWR VPWR _0255_ sky130_fd_sc_hd__inv_2
XTAP_TAPCELL_ROW_20_349 VGND VPWR sky130_fd_sc_hd__tapvpwrvgnd_1
XFILLER_0_32_207 VGND VGND VPWR VPWR sky130_fd_sc_hd__fill_1
X_2797_ _0694_ _0747_ _0692_ VGND VGND VPWR VPWR _0958_ sky130_fd_sc_hd__a21oi_1
XPHY_EDGE_ROW_15_Left_97 VGND VGND VPWR VPWR sky130_fd_sc_hd__decap_3
X_4536_ _2280_ VGND VGND VPWR VPWR _2281_ sky130_fd_sc_hd__clkbuf_4
XFILLER_0_7_41 VGND VGND VPWR VPWR sky130_fd_sc_hd__fill_2
X_4467_ _2270_ VGND VGND VPWR VPWR _0133_ sky130_fd_sc_hd__inv_2
X_3418_ RF0.regs\[15\]\[8\] _0609_ _0629_ RF0.regs\[10\]\[8\] VGND VGND VPWR VPWR
+ _1575_ sky130_fd_sc_hd__a22o_1
X_4398_ _2260_ VGND VGND VPWR VPWR _0074_ sky130_fd_sc_hd__inv_2
X_3349_ _1504_ _1505_ _1494_ VGND VGND VPWR VPWR _1506_ sky130_fd_sc_hd__mux2_1
XTAP_TAPCELL_ROW_28_416 VGND VPWR sky130_fd_sc_hd__tapvpwrvgnd_1
XTAP_TAPCELL_ROW_36_482 VGND VPWR sky130_fd_sc_hd__tapvpwrvgnd_1
XFILLER_0_48_362 VGND VGND VPWR VPWR sky130_fd_sc_hd__fill_2
XFILLER_0_48_384 VGND VGND VPWR VPWR sky130_fd_sc_hd__decap_4
XFILLER_0_8_481 VGND VGND VPWR VPWR sky130_fd_sc_hd__fill_1
XFILLER_0_63_332 VGND VGND VPWR VPWR sky130_fd_sc_hd__fill_1
XFILLER_0_31_240 VGND VGND VPWR VPWR sky130_fd_sc_hd__fill_1
XFILLER_0_64_29 VPWR VGND VPWR VGND sky130_ef_sc_hd__decap_12
XTAP_TAPCELL_ROW_62_706 VGND VPWR sky130_fd_sc_hd__tapvpwrvgnd_1
XTAP_TAPCELL_ROW_70_772 VGND VPWR sky130_fd_sc_hd__tapvpwrvgnd_1
X_2720_ _0880_ _0878_ VGND VGND VPWR VPWR _0881_ sky130_fd_sc_hd__nor2_1
X_2651_ _0807_ _0811_ VGND VGND VPWR VPWR _0812_ sky130_fd_sc_hd__and2b_1
XFILLER_0_54_365 VPWR VGND VPWR VGND sky130_ef_sc_hd__decap_12
XFILLER_0_54_398 VGND VGND VPWR VPWR sky130_fd_sc_hd__decap_3
XFILLER_0_22_251 VGND VGND VPWR VPWR sky130_fd_sc_hd__fill_1
X_2582_ _0657_ _0742_ VGND VGND VPWR VPWR _0743_ sky130_fd_sc_hd__and2_1
XFILLER_0_10_413 VGND VGND VPWR VPWR sky130_fd_sc_hd__decap_6
X_4321_ _2249_ VGND VGND VPWR VPWR _2250_ sky130_fd_sc_hd__buf_4
XFILLER_0_10_457 VPWR VGND VPWR VGND sky130_ef_sc_hd__decap_12
XFILLER_0_1_178 VGND VGND VPWR VPWR sky130_fd_sc_hd__decap_6
X_4252_ _1630_ _0882_ VGND VGND VPWR VPWR _2207_ sky130_fd_sc_hd__or2_1
X_3203_ _1158_ _1156_ _1073_ VGND VGND VPWR VPWR _1362_ sky130_fd_sc_hd__mux2_1
X_4183_ _2171_ VGND VGND VPWR VPWR _0287_ sky130_fd_sc_hd__clkbuf_1
X_3134_ _1292_ _1293_ _1048_ VGND VGND VPWR VPWR _1294_ sky130_fd_sc_hd__mux2_1
X_3065_ _0810_ _0834_ _1004_ VGND VGND VPWR VPWR _1225_ sky130_fd_sc_hd__mux2_1
X_3967_ _2055_ VGND VGND VPWR VPWR _0387_ sky130_fd_sc_hd__clkbuf_1
XFILLER_0_45_332 VGND VGND VPWR VPWR sky130_fd_sc_hd__decap_4
X_2918_ _1076_ _1078_ VGND VGND VPWR VPWR _1079_ sky130_fd_sc_hd__nand2_1
XFILLER_0_70_83 VGND VGND VPWR VPWR sky130_fd_sc_hd__fill_1
X_3898_ _2017_ _1686_ VGND VGND VPWR VPWR _2018_ sky130_fd_sc_hd__xnor2_2
XFILLER_0_5_473 VGND VGND VPWR VPWR sky130_fd_sc_hd__decap_8
X_2849_ _1009_ VGND VGND VPWR VPWR _1010_ sky130_fd_sc_hd__clkbuf_4
XFILLER_0_60_357 VGND VGND VPWR VPWR sky130_fd_sc_hd__decap_6
XFILLER_0_79_81 VGND VGND VPWR VPWR sky130_fd_sc_hd__decap_4
XFILLER_0_13_251 VGND VGND VPWR VPWR sky130_fd_sc_hd__decap_4
XFILLER_0_60_379 VGND VGND VPWR VPWR sky130_fd_sc_hd__decap_4
XFILLER_0_13_262 VGND VGND VPWR VPWR sky130_fd_sc_hd__decap_4
X_4519_ _2276_ VGND VGND VPWR VPWR _2278_ sky130_fd_sc_hd__buf_4
XFILLER_0_68_413 VGND VGND VPWR VPWR sky130_fd_sc_hd__decap_6
XFILLER_0_68_457 VPWR VGND VPWR VGND sky130_ef_sc_hd__decap_12
Xclkbuf_leaf_21_clk clknet_1_0__leaf_clk VGND VGND VPWR VPWR clknet_leaf_21_clk sky130_fd_sc_hd__clkbuf_8
XFILLER_0_36_365 VGND VGND VPWR VPWR sky130_fd_sc_hd__decap_4
XFILLER_0_51_313 VPWR VGND VPWR VGND sky130_ef_sc_hd__decap_12
XFILLER_0_51_346 VGND VGND VPWR VPWR sky130_fd_sc_hd__fill_2
XFILLER_0_75_39 VPWR VGND VPWR VGND sky130_ef_sc_hd__decap_12
XTAP_TAPCELL_ROW_47_577 VGND VPWR sky130_fd_sc_hd__tapvpwrvgnd_1
X_3821_ _1481_ _1934_ VGND VGND VPWR VPWR _1959_ sky130_fd_sc_hd__xnor2_2
Xclkbuf_leaf_12_clk clknet_1_1__leaf_clk VGND VGND VPWR VPWR clknet_leaf_12_clk sky130_fd_sc_hd__clkbuf_8
XTAP_TAPCELL_ROW_30_433 VGND VPWR sky130_fd_sc_hd__tapvpwrvgnd_1
X_3752_ _1291_ _1396_ _1743_ _1433_ VGND VGND VPWR VPWR _1893_ sky130_fd_sc_hd__o2bb2a_1
X_3683_ _1094_ _1147_ _1149_ _1831_ VGND VGND VPWR VPWR _1832_ sky130_fd_sc_hd__a22o_4
X_2703_ _0723_ _0862_ _0863_ VGND VGND VPWR VPWR _0864_ sky130_fd_sc_hd__nand3_1
XFILLER_0_27_398 VPWR VGND VPWR VGND sky130_ef_sc_hd__decap_12
XFILLER_0_2_421 VPWR VGND VPWR VGND sky130_ef_sc_hd__decap_12
XFILLER_0_42_357 VGND VGND VPWR VPWR sky130_fd_sc_hd__fill_1
X_2634_ _0624_ _0750_ _0794_ VGND VGND VPWR VPWR _0795_ sky130_fd_sc_hd__or3_1
X_2565_ _0656_ _0725_ VGND VGND VPWR VPWR _0726_ sky130_fd_sc_hd__and2_1
XFILLER_0_49_51 VGND VGND VPWR VPWR sky130_fd_sc_hd__decap_4
X_4304_ _1076_ _1189_ VGND VGND VPWR VPWR _2242_ sky130_fd_sc_hd__nand2_1
X_2496_ _0656_ VGND VGND VPWR VPWR _0657_ sky130_fd_sc_hd__clkbuf_2
X_4235_ _2198_ VGND VGND VPWR VPWR _0262_ sky130_fd_sc_hd__clkbuf_1
X_4166_ _2009_ RF0.regs\[25\]\[6\] _2156_ VGND VGND VPWR VPWR _2162_ sky130_fd_sc_hd__mux2_1
XFILLER_0_4_97 VGND VGND VPWR VPWR sky130_fd_sc_hd__fill_2
XPHY_EDGE_ROW_27_Left_109 VGND VGND VPWR VPWR sky130_fd_sc_hd__decap_3
XTAP_TAPCELL_ROW_38_500 VGND VPWR sky130_fd_sc_hd__tapvpwrvgnd_1
X_3117_ _0785_ _0979_ _0781_ VGND VGND VPWR VPWR _1277_ sky130_fd_sc_hd__a21o_1
X_4097_ _2125_ VGND VGND VPWR VPWR _0327_ sky130_fd_sc_hd__clkbuf_1
X_3048_ _0898_ _1006_ _1068_ VGND VGND VPWR VPWR _1208_ sky130_fd_sc_hd__mux2_1
XTAP_TAPCELL_ROW_81_867 VGND VPWR sky130_fd_sc_hd__tapvpwrvgnd_1
XFILLER_0_65_449 VPWR VGND VPWR VGND sky130_ef_sc_hd__decap_12
XPHY_EDGE_ROW_36_Left_118 VGND VGND VPWR VPWR sky130_fd_sc_hd__decap_3
XFILLER_0_5_281 VGND VGND VPWR VPWR sky130_fd_sc_hd__decap_3
XFILLER_0_41_390 VGND VGND VPWR VPWR sky130_fd_sc_hd__fill_2
XPHY_EDGE_ROW_45_Left_127 VGND VGND VPWR VPWR sky130_fd_sc_hd__decap_3
XTAP_TAPCELL_ROW_44_547 VGND VPWR sky130_fd_sc_hd__tapvpwrvgnd_1
XFILLER_0_68_265 VGND VGND VPWR VPWR sky130_fd_sc_hd__decap_4
XFILLER_0_68_298 VGND VGND VPWR VPWR sky130_fd_sc_hd__decap_6
XPHY_EDGE_ROW_54_Left_136 VGND VGND VPWR VPWR sky130_fd_sc_hd__decap_3
XFILLER_0_36_173 VGND VGND VPWR VPWR sky130_fd_sc_hd__fill_1
XFILLER_0_36_195 VGND VGND VPWR VPWR sky130_fd_sc_hd__fill_1
XFILLER_0_10_45 VGND VGND VPWR VPWR sky130_fd_sc_hd__fill_1
XFILLER_0_24_368 VGND VGND VPWR VPWR sky130_fd_sc_hd__fill_1
X_2350_ _0518_ net55 VGND VGND VPWR VPWR _0487_ sky130_fd_sc_hd__nor2_1
XPHY_EDGE_ROW_63_Left_145 VGND VGND VPWR VPWR sky130_fd_sc_hd__decap_3
X_4020_ _1997_ RF0.regs\[15\]\[10\] _2082_ VGND VGND VPWR VPWR _2084_ sky130_fd_sc_hd__mux2_1
Xclkbuf_leaf_1_clk clknet_1_0__leaf_clk VGND VGND VPWR VPWR clknet_leaf_1_clk sky130_fd_sc_hd__clkbuf_8
XFILLER_0_47_438 VGND VGND VPWR VPWR sky130_fd_sc_hd__decap_3
XFILLER_0_59_287 VGND VGND VPWR VPWR sky130_fd_sc_hd__fill_1
XPHY_EDGE_ROW_72_Left_154 VGND VGND VPWR VPWR sky130_fd_sc_hd__decap_3
X_4853_ clknet_leaf_25_clk _0503_ _0247_ VGND VGND VPWR VPWR IM0.addr\[23\] sky130_fd_sc_hd__dfrtp_1
XFILLER_0_47_449 VGND VGND VPWR VPWR sky130_fd_sc_hd__decap_6
X_4784_ clknet_leaf_5_clk _0434_ _0178_ VGND VGND VPWR VPWR RF0.regs\[5\]\[18\] sky130_fd_sc_hd__dfrtp_1
X_3804_ _0653_ _1455_ _1475_ _1944_ VGND VGND VPWR VPWR _1945_ sky130_fd_sc_hd__a31o_1
XFILLER_0_62_408 VGND VGND VPWR VPWR sky130_fd_sc_hd__fill_1
XFILLER_0_15_335 VGND VGND VPWR VPWR sky130_fd_sc_hd__fill_1
X_3735_ _1875_ VGND VGND VPWR VPWR _1876_ sky130_fd_sc_hd__inv_2
XFILLER_0_15_379 VGND VGND VPWR VPWR sky130_fd_sc_hd__decap_4
X_3666_ _1066_ _1399_ _1636_ VGND VGND VPWR VPWR _1817_ sky130_fd_sc_hd__a21oi_1
XFILLER_0_42_165 VGND VGND VPWR VPWR sky130_fd_sc_hd__decap_4
XFILLER_0_2_262 VGND VGND VPWR VPWR sky130_fd_sc_hd__fill_2
X_3597_ _1734_ _1747_ VGND VGND VPWR VPWR _1748_ sky130_fd_sc_hd__nand2_1
XFILLER_0_62_3 VPWR VGND VPWR VGND sky130_ef_sc_hd__decap_12
X_2617_ RF0.regs\[10\]\[26\] _0618_ _0675_ RF0.regs\[25\]\[26\] VGND VGND VPWR VPWR
+ _0778_ sky130_fd_sc_hd__a22o_1
XPHY_EDGE_ROW_81_Left_163 VGND VGND VPWR VPWR sky130_fd_sc_hd__decap_3
X_2548_ _0655_ net34 net40 _0648_ VGND VGND VPWR VPWR _0709_ sky130_fd_sc_hd__and4_1
XTAP_TAPCELL_ROW_7_239 VGND VPWR sky130_fd_sc_hd__tapvpwrvgnd_1
X_2479_ _0606_ VGND VGND VPWR VPWR _0640_ sky130_fd_sc_hd__clkbuf_4
X_4218_ _2189_ VGND VGND VPWR VPWR _0270_ sky130_fd_sc_hd__clkbuf_1
X_4149_ _1984_ RF0.regs\[25\]\[14\] _2145_ VGND VGND VPWR VPWR _2153_ sky130_fd_sc_hd__mux2_1
XTAP_TAPCELL_ROW_41_528 VGND VPWR sky130_fd_sc_hd__tapvpwrvgnd_1
XFILLER_0_80_205 VGND VGND VPWR VPWR sky130_fd_sc_hd__fill_2
XFILLER_0_18_184 VGND VGND VPWR VPWR sky130_fd_sc_hd__decap_3
XFILLER_0_33_110 VGND VGND VPWR VPWR sky130_fd_sc_hd__fill_2
Xclkload0 clknet_1_1__leaf_clk VGND VGND VPWR VPWR clkload0/Y sky130_fd_sc_hd__clkinv_4
XFILLER_0_21_305 VGND VGND VPWR VPWR sky130_fd_sc_hd__fill_2
XPHY_EDGE_ROW_3_Left_85 VGND VGND VPWR VPWR sky130_fd_sc_hd__decap_3
XTAP_TAPCELL_ROW_57_661 VGND VPWR sky130_fd_sc_hd__tapvpwrvgnd_1
XFILLER_0_72_29 VPWR VGND VPWR VGND sky130_ef_sc_hd__decap_12
XFILLER_0_29_405 VPWR VGND VPWR VGND sky130_ef_sc_hd__decap_12
XFILLER_0_29_427 VGND VGND VPWR VPWR sky130_fd_sc_hd__decap_3
XFILLER_0_29_449 VGND VGND VPWR VPWR sky130_fd_sc_hd__fill_2
XFILLER_0_21_55 VGND VGND VPWR VPWR sky130_fd_sc_hd__fill_1
XFILLER_0_24_121 VGND VGND VPWR VPWR sky130_fd_sc_hd__fill_1
XTAP_TAPCELL_ROW_12_274 VGND VPWR sky130_fd_sc_hd__tapvpwrvgnd_1
X_3520_ _1538_ _1153_ _1331_ VGND VGND VPWR VPWR _1675_ sky130_fd_sc_hd__nand3_1
X_3451_ _1590_ _1591_ _1589_ VGND VGND VPWR VPWR _1607_ sky130_fd_sc_hd__a21oi_1
X_3382_ _1538_ VGND VGND VPWR VPWR _1539_ sky130_fd_sc_hd__inv_2
X_2402_ net97 VGND VGND VPWR VPWR _0576_ sky130_fd_sc_hd__clkbuf_1
X_2333_ _0525_ _0543_ VGND VGND VPWR VPWR _0497_ sky130_fd_sc_hd__nor2_1
XTAP_TAPCELL_ROW_4_209 VGND VPWR sky130_fd_sc_hd__tapvpwrvgnd_1
XFILLER_0_46_41 VGND VGND VPWR VPWR sky130_fd_sc_hd__fill_1
X_4003_ _1968_ RF0.regs\[15\]\[18\] _2071_ VGND VGND VPWR VPWR _2075_ sky130_fd_sc_hd__mux2_1
X_4836_ clknet_leaf_27_clk net70 _0230_ VGND VGND VPWR VPWR IM0.addr\[6\] sky130_fd_sc_hd__dfrtp_1
XFILLER_0_15_110 VGND VGND VPWR VPWR sky130_fd_sc_hd__fill_2
XFILLER_0_7_343 VGND VGND VPWR VPWR sky130_fd_sc_hd__decap_6
X_4767_ clknet_leaf_25_clk _0417_ _0161_ VGND VGND VPWR VPWR RF0.regs\[5\]\[1\] sky130_fd_sc_hd__dfrtp_1
X_4698_ clknet_leaf_8_clk _0348_ _0092_ VGND VGND VPWR VPWR RF0.regs\[20\]\[28\] sky130_fd_sc_hd__dfrtp_1
X_3718_ _1859_ RF0.regs\[5\]\[24\] _1835_ VGND VGND VPWR VPWR _1860_ sky130_fd_sc_hd__mux2_1
X_3649_ _1756_ _1765_ _1770_ _1799_ VGND VGND VPWR VPWR _1800_ sky130_fd_sc_hd__a211o_1
XFILLER_0_11_393 VGND VGND VPWR VPWR sky130_fd_sc_hd__decap_3
Xhold23 IM0.addr\[24\] VGND VGND VPWR VPWR net58 sky130_fd_sc_hd__dlygate4sd3_1
Xhold45 IM0.addr\[12\] VGND VGND VPWR VPWR net80 sky130_fd_sc_hd__dlygate4sd3_1
Xhold56 RF0.regs\[0\]\[18\] VGND VGND VPWR VPWR net91 sky130_fd_sc_hd__dlygate4sd3_1
Xhold78 RF0.regs\[0\]\[5\] VGND VGND VPWR VPWR net113 sky130_fd_sc_hd__dlygate4sd3_1
Xhold89 RF0.regs\[20\]\[24\] VGND VGND VPWR VPWR net124 sky130_fd_sc_hd__dlygate4sd3_1
Xhold67 RF0.regs\[0\]\[25\] VGND VGND VPWR VPWR net102 sky130_fd_sc_hd__dlygate4sd3_1
XTAP_TAPCELL_ROW_54_631 VGND VPWR sky130_fd_sc_hd__tapvpwrvgnd_1
XTAP_TAPCELL_ROW_26_399 VGND VPWR sky130_fd_sc_hd__tapvpwrvgnd_1
XTAP_TAPCELL_ROW_17_322 VGND VPWR sky130_fd_sc_hd__tapvpwrvgnd_1
XFILLER_0_16_88 VGND VGND VPWR VPWR sky130_fd_sc_hd__fill_1
XFILLER_0_29_213 VGND VGND VPWR VPWR sky130_fd_sc_hd__decap_4
X_2951_ _1108_ _1110_ _1009_ VGND VGND VPWR VPWR _1111_ sky130_fd_sc_hd__mux2_1
XFILLER_0_29_279 VGND VGND VPWR VPWR sky130_fd_sc_hd__fill_1
XFILLER_0_32_65 VPWR VGND VPWR VGND sky130_ef_sc_hd__decap_12
X_4621_ clknet_leaf_1_clk _0271_ _0015_ VGND VGND VPWR VPWR RF0.regs\[30\]\[15\] sky130_fd_sc_hd__dfrtp_1
X_2882_ _0960_ _1041_ _1042_ VGND VGND VPWR VPWR _1043_ sky130_fd_sc_hd__mux2_1
XTAP_TAPCELL_ROW_60_689 VGND VPWR sky130_fd_sc_hd__tapvpwrvgnd_1
X_4552_ _2282_ VGND VGND VPWR VPWR _0206_ sky130_fd_sc_hd__inv_2
XFILLER_0_4_368 VGND VGND VPWR VPWR sky130_fd_sc_hd__decap_4
X_3503_ _1538_ _1361_ VGND VGND VPWR VPWR _1658_ sky130_fd_sc_hd__nand2_1
X_4483_ _2272_ VGND VGND VPWR VPWR _0147_ sky130_fd_sc_hd__inv_2
X_3434_ _0861_ _0882_ _0884_ _0885_ VGND VGND VPWR VPWR _1591_ sky130_fd_sc_hd__a211o_1
XFILLER_0_40_477 VGND VGND VPWR VPWR sky130_fd_sc_hd__fill_1
X_3365_ _0806_ _1119_ _1042_ VGND VGND VPWR VPWR _1522_ sky130_fd_sc_hd__mux2_1
XFILLER_0_57_51 VGND VGND VPWR VPWR sky130_fd_sc_hd__fill_1
X_2316_ net78 _0531_ VGND VGND VPWR VPWR _0507_ sky130_fd_sc_hd__xor2_1
X_3296_ _1451_ _1453_ VGND VGND VPWR VPWR _1454_ sky130_fd_sc_hd__nor2_1
XTAP_TAPCELL_ROW_68_756 VGND VPWR sky130_fd_sc_hd__tapvpwrvgnd_1
XFILLER_0_79_113 VGND VGND VPWR VPWR sky130_fd_sc_hd__fill_2
XFILLER_0_25_3 VGND VGND VPWR VPWR sky130_fd_sc_hd__decap_4
XTAP_TAPCELL_ROW_51_612 VGND VPWR sky130_fd_sc_hd__tapvpwrvgnd_1
XFILLER_0_75_363 VGND VGND VPWR VPWR sky130_fd_sc_hd__fill_1
XTAP_TAPCELL_ROW_23_369 VGND VPWR sky130_fd_sc_hd__tapvpwrvgnd_1
XFILLER_0_35_238 VGND VGND VPWR VPWR sky130_fd_sc_hd__decap_8
X_4819_ clknet_leaf_13_clk _0469_ _0213_ VGND VGND VPWR VPWR RF0.regs\[0\]\[21\] sky130_fd_sc_hd__dfrtp_1
XFILLER_0_43_293 VPWR VGND VPWR VGND sky130_ef_sc_hd__decap_12
XFILLER_0_31_477 VGND VGND VPWR VPWR sky130_fd_sc_hd__fill_1
Xoutput13 net13 VGND VGND VPWR VPWR Result[20] sky130_fd_sc_hd__buf_2
Xoutput24 net24 VGND VGND VPWR VPWR Result[30] sky130_fd_sc_hd__buf_2
XPHY_EDGE_ROW_19_Right_19 VGND VGND VPWR VPWR sky130_fd_sc_hd__decap_3
XFILLER_0_81_300 VGND VGND VPWR VPWR sky130_fd_sc_hd__decap_8
XFILLER_0_1_327 VGND VGND VPWR VPWR sky130_fd_sc_hd__fill_1
XFILLER_0_22_466 VGND VGND VPWR VPWR sky130_fd_sc_hd__decap_8
XFILLER_0_22_477 VGND VGND VPWR VPWR sky130_fd_sc_hd__decap_4
XPHY_EDGE_ROW_28_Right_28 VGND VGND VPWR VPWR sky130_fd_sc_hd__decap_3
X_3150_ _0792_ _0803_ _0976_ VGND VGND VPWR VPWR _1309_ sky130_fd_sc_hd__and3_1
X_3081_ RF0.regs\[0\]\[27\] _0605_ _1240_ VGND VGND VPWR VPWR _1241_ sky130_fd_sc_hd__o21ai_1
XPHY_EDGE_ROW_37_Right_37 VGND VGND VPWR VPWR sky130_fd_sc_hd__decap_3
XTAP_TAPCELL_ROW_65_726 VGND VPWR sky130_fd_sc_hd__tapvpwrvgnd_1
X_3983_ _2064_ VGND VGND VPWR VPWR _0380_ sky130_fd_sc_hd__clkbuf_1
XFILLER_0_9_449 VPWR VGND VPWR VGND sky130_ef_sc_hd__decap_12
X_2934_ _1089_ _1093_ VGND VGND VPWR VPWR _1094_ sky130_fd_sc_hd__or2_1
XFILLER_0_57_374 VPWR VGND VPWR VGND sky130_ef_sc_hd__decap_12
X_2865_ _1024_ _1025_ _1010_ VGND VGND VPWR VPWR _1026_ sky130_fd_sc_hd__mux2_1
X_4604_ _2247_ VGND VGND VPWR VPWR _0254_ sky130_fd_sc_hd__inv_2
XPHY_EDGE_ROW_46_Right_46 VGND VGND VPWR VPWR sky130_fd_sc_hd__decap_3
XFILLER_0_13_411 VPWR VGND VPWR VGND sky130_ef_sc_hd__decap_12
XFILLER_0_4_154 VGND VGND VPWR VPWR sky130_fd_sc_hd__decap_3
X_2796_ _0933_ _0938_ _0952_ _0955_ _0956_ VGND VGND VPWR VPWR _0957_ sky130_fd_sc_hd__o32a_1
X_4535_ reset VGND VGND VPWR VPWR _2280_ sky130_fd_sc_hd__clkbuf_4
X_4466_ _2270_ VGND VGND VPWR VPWR _0132_ sky130_fd_sc_hd__inv_2
XFILLER_0_68_61 VGND VGND VPWR VPWR sky130_fd_sc_hd__decap_3
XFILLER_0_0_360 VGND VGND VPWR VPWR sky130_fd_sc_hd__decap_4
XFILLER_0_0_371 VGND VGND VPWR VPWR sky130_fd_sc_hd__decap_3
X_3417_ RF0.regs\[5\]\[8\] _0633_ _0637_ RF0.regs\[30\]\[8\] _0640_ VGND VGND VPWR
+ VPWR _1574_ sky130_fd_sc_hd__a221o_1
X_4397_ _2260_ VGND VGND VPWR VPWR _0073_ sky130_fd_sc_hd__inv_2
XFILLER_0_0_393 VPWR VGND VPWR VGND sky130_ef_sc_hd__decap_12
X_3348_ RF0.regs\[0\]\[14\] _0604_ _1504_ VGND VGND VPWR VPWR _1505_ sky130_fd_sc_hd__o21ai_1
X_3279_ _1436_ VGND VGND VPWR VPWR _1437_ sky130_fd_sc_hd__inv_2
XPHY_EDGE_ROW_55_Right_55 VGND VGND VPWR VPWR sky130_fd_sc_hd__decap_3
XTAP_TAPCELL_ROW_28_417 VGND VPWR sky130_fd_sc_hd__tapvpwrvgnd_1
XFILLER_0_67_149 VGND VGND VPWR VPWR sky130_fd_sc_hd__decap_3
XTAP_TAPCELL_ROW_36_483 VGND VPWR sky130_fd_sc_hd__tapvpwrvgnd_1
XFILLER_0_75_160 VGND VGND VPWR VPWR sky130_fd_sc_hd__fill_2
XPHY_EDGE_ROW_64_Right_64 VGND VGND VPWR VPWR sky130_fd_sc_hd__decap_3
XPHY_EDGE_ROW_73_Right_73 VGND VGND VPWR VPWR sky130_fd_sc_hd__decap_3
XFILLER_0_80_29 VPWR VGND VPWR VGND sky130_ef_sc_hd__decap_12
XTAP_TAPCELL_ROW_62_707 VGND VPWR sky130_fd_sc_hd__tapvpwrvgnd_1
XTAP_TAPCELL_ROW_70_773 VGND VPWR sky130_fd_sc_hd__tapvpwrvgnd_1
XFILLER_0_81_141 VPWR VGND VPWR VGND sky130_ef_sc_hd__decap_12
X_2650_ _0622_ _0804_ _0805_ _0810_ VGND VGND VPWR VPWR _0811_ sky130_fd_sc_hd__o31ai_2
XFILLER_0_54_377 VGND VGND VPWR VPWR sky130_fd_sc_hd__decap_4
XFILLER_0_1_113 VGND VGND VPWR VPWR sky130_fd_sc_hd__decap_4
X_2581_ RF0.regs\[15\]\[13\] _0663_ _0668_ RF0.regs\[5\]\[13\] VGND VGND VPWR VPWR
+ _0742_ sky130_fd_sc_hd__a22o_1
X_4320_ _2246_ VGND VGND VPWR VPWR _2249_ sky130_fd_sc_hd__buf_1
XFILLER_0_10_469 VGND VGND VPWR VPWR sky130_fd_sc_hd__decap_6
XFILLER_0_22_296 VGND VGND VPWR VPWR sky130_fd_sc_hd__decap_8
X_4251_ _1300_ _1817_ VGND VGND VPWR VPWR _2206_ sky130_fd_sc_hd__nand2_1
X_3202_ _1061_ _1106_ VGND VGND VPWR VPWR _1361_ sky130_fd_sc_hd__and2_1
X_4182_ _1833_ RF0.regs\[30\]\[31\] _2170_ VGND VGND VPWR VPWR _2171_ sky130_fd_sc_hd__mux2_4
XTAP_TAPCELL_ROW_78_840 VGND VPWR sky130_fd_sc_hd__tapvpwrvgnd_1
X_3133_ _1030_ _0863_ _1014_ VGND VGND VPWR VPWR _1293_ sky130_fd_sc_hd__mux2_1
X_3064_ _1222_ _1223_ _1010_ VGND VGND VPWR VPWR _1224_ sky130_fd_sc_hd__mux2_1
XFILLER_0_54_41 VPWR VGND VPWR VGND sky130_ef_sc_hd__decap_12
XFILLER_0_77_447 VGND VGND VPWR VPWR sky130_fd_sc_hd__fill_1
X_3966_ _2015_ RF0.regs\[10\]\[3\] _2046_ VGND VGND VPWR VPWR _2055_ sky130_fd_sc_hd__mux2_1
XTAP_TAPCELL_ROW_33_453 VGND VPWR sky130_fd_sc_hd__tapvpwrvgnd_1
XFILLER_0_45_311 VGND VGND VPWR VPWR sky130_fd_sc_hd__decap_4
XFILLER_0_9_279 VGND VGND VPWR VPWR sky130_fd_sc_hd__fill_1
X_2917_ _0765_ _1077_ _1068_ VGND VGND VPWR VPWR _1078_ sky130_fd_sc_hd__mux2_1
X_3897_ _1655_ _1664_ _1665_ VGND VGND VPWR VPWR _2017_ sky130_fd_sc_hd__o21ai_1
XFILLER_0_45_366 VPWR VGND VPWR VGND sky130_ef_sc_hd__decap_12
X_2848_ _0716_ _0718_ VGND VGND VPWR VPWR _1009_ sky130_fd_sc_hd__nand2_2
X_2779_ _0939_ _0741_ _0895_ VGND VGND VPWR VPWR _0940_ sky130_fd_sc_hd__mux2_1
Xhold120 RF0.regs\[30\]\[10\] VGND VGND VPWR VPWR net155 sky130_fd_sc_hd__dlygate4sd3_1
X_4518_ _2277_ VGND VGND VPWR VPWR _0177_ sky130_fd_sc_hd__inv_2
X_4449_ _2266_ VGND VGND VPWR VPWR _0119_ sky130_fd_sc_hd__inv_2
XFILLER_0_68_469 VGND VGND VPWR VPWR sky130_fd_sc_hd__decap_6
XFILLER_0_48_171 VGND VGND VPWR VPWR sky130_fd_sc_hd__fill_1
XFILLER_0_48_193 VGND VGND VPWR VPWR sky130_fd_sc_hd__decap_3
XFILLER_0_36_377 VPWR VGND VPWR VGND sky130_ef_sc_hd__decap_12
XFILLER_0_51_325 VGND VGND VPWR VPWR sky130_fd_sc_hd__decap_8
XTAP_TAPCELL_ROW_75_810 VGND VPWR sky130_fd_sc_hd__tapvpwrvgnd_1
XTAP_TAPCELL_ROW_47_578 VGND VPWR sky130_fd_sc_hd__tapvpwrvgnd_1
XFILLER_0_24_99 VGND VGND VPWR VPWR sky130_fd_sc_hd__fill_1
X_3820_ _1958_ VGND VGND VPWR VPWR _0437_ sky130_fd_sc_hd__clkbuf_1
XFILLER_0_27_344 VGND VGND VPWR VPWR sky130_fd_sc_hd__decap_8
X_3751_ _1097_ _1557_ _1579_ VGND VGND VPWR VPWR _1892_ sky130_fd_sc_hd__nor3_1
X_2702_ RF0.regs\[10\]\[1\] _0613_ _0668_ RF0.regs\[25\]\[1\] VGND VGND VPWR VPWR
+ _0863_ sky130_fd_sc_hd__a22oi_4
XTAP_TAPCELL_ROW_30_434 VGND VPWR sky130_fd_sc_hd__tapvpwrvgnd_1
XFILLER_0_54_141 VGND VGND VPWR VPWR sky130_fd_sc_hd__decap_8
X_3682_ _1201_ _1236_ _1826_ _1830_ VGND VGND VPWR VPWR _1831_ sky130_fd_sc_hd__o31a_1
X_2633_ _0793_ _0749_ VGND VGND VPWR VPWR _0794_ sky130_fd_sc_hd__nor2_1
XFILLER_0_10_211 VPWR VGND VPWR VGND sky130_ef_sc_hd__decap_12
X_2564_ RF0.regs\[15\]\[5\] _0662_ _0667_ RF0.regs\[5\]\[5\] VGND VGND VPWR VPWR _0725_
+ sky130_fd_sc_hd__a22o_1
XFILLER_0_2_433 VPWR VGND VPWR VGND sky130_ef_sc_hd__decap_12
XFILLER_0_2_477 VGND VGND VPWR VPWR sky130_fd_sc_hd__decap_4
X_4303_ _1066_ _1279_ _1040_ VGND VGND VPWR VPWR _2241_ sky130_fd_sc_hd__o21a_1
X_2495_ _0655_ _0650_ VGND VGND VPWR VPWR _0656_ sky130_fd_sc_hd__nand2_2
XFILLER_0_4_21 VGND VGND VPWR VPWR sky130_fd_sc_hd__fill_1
X_4234_ _2009_ net159 _2192_ VGND VGND VPWR VPWR _2198_ sky130_fd_sc_hd__mux2_1
X_4165_ _2161_ VGND VGND VPWR VPWR _0295_ sky130_fd_sc_hd__clkbuf_1
XFILLER_0_65_51 VGND VGND VPWR VPWR sky130_fd_sc_hd__decap_4
XTAP_TAPCELL_ROW_38_501 VGND VPWR sky130_fd_sc_hd__tapvpwrvgnd_1
X_3116_ _0781_ _0785_ _0979_ VGND VGND VPWR VPWR _1276_ sky130_fd_sc_hd__nand3_1
X_4096_ net118 _2007_ _2120_ VGND VGND VPWR VPWR _2125_ sky130_fd_sc_hd__mux2_1
XFILLER_0_77_211 VPWR VGND VPWR VGND sky130_ef_sc_hd__decap_12
X_3047_ _1136_ _1206_ VGND VGND VPWR VPWR _1207_ sky130_fd_sc_hd__or2_1
XTAP_TAPCELL_ROW_81_868 VGND VPWR sky130_fd_sc_hd__tapvpwrvgnd_1
XFILLER_0_37_108 VGND VGND VPWR VPWR sky130_fd_sc_hd__decap_4
XFILLER_0_73_461 VPWR VGND VPWR VGND sky130_ef_sc_hd__decap_12
XFILLER_0_18_355 VGND VGND VPWR VPWR sky130_fd_sc_hd__decap_3
X_3949_ _2023_ VGND VGND VPWR VPWR _2046_ sky130_fd_sc_hd__buf_4
XFILLER_0_45_141 VGND VGND VPWR VPWR sky130_fd_sc_hd__fill_1
XFILLER_0_60_155 VGND VGND VPWR VPWR sky130_fd_sc_hd__fill_1
XTAP_TAPCELL_ROW_1_181 VGND VPWR sky130_fd_sc_hd__tapvpwrvgnd_1
XFILLER_0_68_233 VPWR VGND VPWR VGND sky130_ef_sc_hd__decap_12
XTAP_TAPCELL_ROW_44_548 VGND VPWR sky130_fd_sc_hd__tapvpwrvgnd_1
XFILLER_0_36_163 VGND VGND VPWR VPWR sky130_fd_sc_hd__fill_1
XFILLER_0_51_111 VGND VGND VPWR VPWR sky130_fd_sc_hd__fill_1
XFILLER_0_51_166 VGND VGND VPWR VPWR sky130_fd_sc_hd__fill_2
XFILLER_0_19_11 VGND VGND VPWR VPWR sky130_fd_sc_hd__fill_1
XFILLER_0_19_55 VGND VGND VPWR VPWR sky130_fd_sc_hd__fill_1
XFILLER_0_35_54 VGND VGND VPWR VPWR sky130_fd_sc_hd__fill_2
XFILLER_0_59_211 VGND VGND VPWR VPWR sky130_fd_sc_hd__fill_1
X_4852_ clknet_leaf_26_clk _0502_ _0246_ VGND VGND VPWR VPWR IM0.addr\[22\] sky130_fd_sc_hd__dfrtp_1
X_3803_ _1152_ _1638_ _1943_ VGND VGND VPWR VPWR _1944_ sky130_fd_sc_hd__a21oi_1
X_4783_ clknet_leaf_5_clk _0433_ _0177_ VGND VGND VPWR VPWR RF0.regs\[5\]\[17\] sky130_fd_sc_hd__dfrtp_1
XFILLER_0_15_314 VGND VGND VPWR VPWR sky130_fd_sc_hd__fill_2
X_3734_ _1029_ _1514_ _1047_ VGND VGND VPWR VPWR _1875_ sky130_fd_sc_hd__mux2_1
XFILLER_0_27_196 VGND VGND VPWR VPWR sky130_fd_sc_hd__decap_3
X_3665_ _1385_ _1397_ _1058_ VGND VGND VPWR VPWR _1816_ sky130_fd_sc_hd__mux2_1
XFILLER_0_30_306 VGND VGND VPWR VPWR sky130_fd_sc_hd__fill_2
X_2616_ _0753_ _0776_ VGND VGND VPWR VPWR _0777_ sky130_fd_sc_hd__or2_1
XFILLER_0_70_475 VGND VGND VPWR VPWR sky130_fd_sc_hd__fill_1
XFILLER_0_23_391 VGND VGND VPWR VPWR sky130_fd_sc_hd__fill_1
X_3596_ _0652_ _1719_ _1736_ _1738_ _1746_ VGND VGND VPWR VPWR _1747_ sky130_fd_sc_hd__a32o_1
X_2547_ RF0.regs\[5\]\[4\] _0666_ VGND VGND VPWR VPWR _0708_ sky130_fd_sc_hd__nand2_1
XFILLER_0_55_3 VPWR VGND VPWR VGND sky130_ef_sc_hd__decap_12
X_2478_ _0638_ VGND VGND VPWR VPWR _0639_ sky130_fd_sc_hd__buf_2
X_4217_ _1984_ RF0.regs\[30\]\[14\] _2181_ VGND VGND VPWR VPWR _2189_ sky130_fd_sc_hd__mux2_1
X_4148_ _2152_ VGND VGND VPWR VPWR _0303_ sky130_fd_sc_hd__clkbuf_1
X_4079_ RF0.regs\[20\]\[15\] _1981_ _2109_ VGND VGND VPWR VPWR _2116_ sky130_fd_sc_hd__mux2_1
XFILLER_0_65_225 VPWR VGND VPWR VGND sky130_ef_sc_hd__decap_12
XFILLER_0_18_141 VGND VGND VPWR VPWR sky130_fd_sc_hd__decap_8
Xclkload1 clknet_leaf_0_clk VGND VGND VPWR VPWR clkload1/X sky130_fd_sc_hd__clkbuf_4
XFILLER_0_46_472 VGND VGND VPWR VPWR sky130_fd_sc_hd__decap_4
XFILLER_0_33_122 VGND VGND VPWR VPWR sky130_fd_sc_hd__decap_3
XFILLER_0_33_177 VPWR VGND VPWR VGND sky130_ef_sc_hd__decap_12
XFILLER_0_33_199 VGND VGND VPWR VPWR sky130_fd_sc_hd__fill_2
XTAP_TAPCELL_ROW_57_662 VGND VPWR sky130_fd_sc_hd__tapvpwrvgnd_1
XFILLER_0_29_417 VGND VGND VPWR VPWR sky130_fd_sc_hd__decap_6
XFILLER_0_29_439 VGND VGND VPWR VPWR sky130_fd_sc_hd__decap_6
XTAP_TAPCELL_ROW_12_275 VGND VPWR sky130_fd_sc_hd__tapvpwrvgnd_1
X_3450_ _1603_ _1605_ VGND VGND VPWR VPWR _1606_ sky130_fd_sc_hd__nor2_1
X_3381_ _0606_ _0711_ VGND VGND VPWR VPWR _1538_ sky130_fd_sc_hd__nor2_2
XFILLER_0_20_361 VGND VGND VPWR VPWR sky130_fd_sc_hd__decap_3
X_2401_ _0575_ VGND VGND VPWR VPWR _0461_ sky130_fd_sc_hd__clkbuf_1
X_2332_ net73 _0524_ VGND VGND VPWR VPWR _0543_ sky130_fd_sc_hd__nor2_1
X_4002_ _2074_ VGND VGND VPWR VPWR _0371_ sky130_fd_sc_hd__clkbuf_1
XFILLER_0_62_41 VPWR VGND VPWR VGND sky130_ef_sc_hd__decap_12
XFILLER_0_62_85 VPWR VGND VPWR VGND sky130_ef_sc_hd__decap_12
X_4835_ clknet_leaf_27_clk _0485_ _0229_ VGND VGND VPWR VPWR IM0.addr\[5\] sky130_fd_sc_hd__dfrtp_1
XFILLER_0_7_333 VGND VGND VPWR VPWR sky130_fd_sc_hd__decap_3
XFILLER_0_7_311 VGND VGND VPWR VPWR sky130_fd_sc_hd__decap_6
X_4766_ clknet_leaf_22_clk _0416_ _0160_ VGND VGND VPWR VPWR RF0.regs\[5\]\[0\] sky130_fd_sc_hd__dfrtp_1
XFILLER_0_62_239 VPWR VGND VPWR VGND sky130_ef_sc_hd__decap_12
X_3717_ _1404_ _1813_ VGND VGND VPWR VPWR _1859_ sky130_fd_sc_hd__xor2_4
X_4697_ clknet_leaf_8_clk _0347_ _0091_ VGND VGND VPWR VPWR RF0.regs\[20\]\[27\] sky130_fd_sc_hd__dfrtp_1
XFILLER_0_30_136 VGND VGND VPWR VPWR sky130_fd_sc_hd__fill_1
X_3648_ _1097_ net48 _1772_ _1796_ _1798_ VGND VGND VPWR VPWR _1799_ sky130_fd_sc_hd__o32a_1
X_3579_ RF0.regs\[5\]\[16\] _0635_ _0639_ RF0.regs\[30\]\[16\] _0642_ VGND VGND VPWR
+ VPWR _1731_ sky130_fd_sc_hd__a221o_1
XFILLER_0_11_361 VGND VGND VPWR VPWR sky130_fd_sc_hd__decap_6
Xhold24 IM0.addr\[3\] VGND VGND VPWR VPWR net59 sky130_fd_sc_hd__dlygate4sd3_1
Xhold35 _0486_ VGND VGND VPWR VPWR net70 sky130_fd_sc_hd__dlygate4sd3_1
Xhold46 IM0.addr\[21\] VGND VGND VPWR VPWR net81 sky130_fd_sc_hd__dlygate4sd3_1
Xhold79 RF0.regs\[5\]\[0\] VGND VGND VPWR VPWR net114 sky130_fd_sc_hd__dlygate4sd3_1
Xhold68 RF0.regs\[0\]\[2\] VGND VGND VPWR VPWR net103 sky130_fd_sc_hd__dlygate4sd3_1
Xhold57 RF0.regs\[0\]\[14\] VGND VGND VPWR VPWR net92 sky130_fd_sc_hd__dlygate4sd3_1
XTAP_TAPCELL_ROW_54_632 VGND VPWR sky130_fd_sc_hd__tapvpwrvgnd_1
XFILLER_0_19_461 VPWR VGND VPWR VGND sky130_ef_sc_hd__decap_12
XFILLER_0_53_217 VGND VGND VPWR VPWR sky130_fd_sc_hd__decap_6
XFILLER_0_34_475 VGND VGND VPWR VPWR sky130_fd_sc_hd__fill_1
XFILLER_0_21_169 VPWR VGND VPWR VGND sky130_ef_sc_hd__decap_12
XFILLER_0_76_309 VPWR VGND VPWR VGND sky130_ef_sc_hd__decap_12
XTAP_TAPCELL_ROW_17_323 VGND VPWR sky130_fd_sc_hd__tapvpwrvgnd_1
XFILLER_0_69_350 VGND VGND VPWR VPWR sky130_fd_sc_hd__fill_2
X_2950_ _0887_ _1109_ _1003_ VGND VGND VPWR VPWR _1110_ sky130_fd_sc_hd__mux2_1
XFILLER_0_32_44 VGND VGND VPWR VPWR sky130_fd_sc_hd__decap_6
X_2881_ _1007_ VGND VGND VPWR VPWR _1042_ sky130_fd_sc_hd__clkbuf_4
XFILLER_0_32_77 VGND VGND VPWR VPWR sky130_fd_sc_hd__decap_6
X_4620_ clknet_leaf_1_clk _0270_ _0014_ VGND VGND VPWR VPWR RF0.regs\[30\]\[14\] sky130_fd_sc_hd__dfrtp_1
XFILLER_0_25_464 VPWR VGND VPWR VGND sky130_ef_sc_hd__decap_12
X_4551_ _2282_ VGND VGND VPWR VPWR _0205_ sky130_fd_sc_hd__inv_2
X_3502_ _0874_ _0873_ _0870_ VGND VGND VPWR VPWR _1657_ sky130_fd_sc_hd__a21oi_1
XFILLER_0_52_294 VGND VGND VPWR VPWR sky130_fd_sc_hd__decap_6
X_4482_ _2272_ VGND VGND VPWR VPWR _0146_ sky130_fd_sc_hd__inv_2
X_3433_ _0854_ _0855_ VGND VGND VPWR VPWR _1590_ sky130_fd_sc_hd__nand2_1
X_3364_ _1519_ _1520_ _1047_ VGND VGND VPWR VPWR _1521_ sky130_fd_sc_hd__mux2_1
X_2315_ _0532_ _0536_ VGND VGND VPWR VPWR _0508_ sky130_fd_sc_hd__nor2_1
X_3295_ RF0.regs\[20\]\[21\] _0626_ _0630_ RF0.regs\[10\]\[21\] _1452_ VGND VGND VPWR
+ VPWR _1453_ sky130_fd_sc_hd__a221o_1
XTAP_TAPCELL_ROW_68_757 VGND VPWR sky130_fd_sc_hd__tapvpwrvgnd_1
XFILLER_0_73_51 VGND VGND VPWR VPWR sky130_fd_sc_hd__decap_4
XFILLER_0_73_95 VGND VGND VPWR VPWR sky130_fd_sc_hd__decap_8
XTAP_TAPCELL_ROW_51_613 VGND VPWR sky130_fd_sc_hd__tapvpwrvgnd_1
XFILLER_0_75_386 VGND VGND VPWR VPWR sky130_fd_sc_hd__decap_6
X_4818_ clknet_leaf_11_clk _0468_ _0212_ VGND VGND VPWR VPWR RF0.regs\[0\]\[20\] sky130_fd_sc_hd__dfrtp_1
XFILLER_0_31_401 VGND VGND VPWR VPWR sky130_fd_sc_hd__decap_3
X_4749_ clknet_leaf_2_clk _0399_ _0143_ VGND VGND VPWR VPWR RF0.regs\[10\]\[15\] sky130_fd_sc_hd__dfrtp_2
XFILLER_0_43_261 VGND VGND VPWR VPWR sky130_fd_sc_hd__decap_4
XFILLER_0_31_412 VGND VGND VPWR VPWR sky130_fd_sc_hd__fill_1
Xoutput25 net25 VGND VGND VPWR VPWR Result[31] sky130_fd_sc_hd__clkbuf_4
Xoutput14 net14 VGND VGND VPWR VPWR Result[21] sky130_fd_sc_hd__clkbuf_4
XFILLER_0_66_342 VPWR VGND VPWR VGND sky130_ef_sc_hd__decap_12
XFILLER_0_81_345 VGND VGND VPWR VPWR sky130_fd_sc_hd__fill_1
XFILLER_0_81_389 VGND VGND VPWR VPWR sky130_fd_sc_hd__decap_3
XFILLER_0_78_29 VPWR VGND VPWR VGND sky130_ef_sc_hd__decap_12
XFILLER_0_27_11 VGND VGND VPWR VPWR sky130_fd_sc_hd__fill_2
X_3080_ _1237_ _1239_ VGND VGND VPWR VPWR _1240_ sky130_fd_sc_hd__or2_2
XTAP_TAPCELL_ROW_65_727 VGND VPWR sky130_fd_sc_hd__tapvpwrvgnd_1
X_3982_ _1845_ RF0.regs\[15\]\[28\] _2060_ VGND VGND VPWR VPWR _2064_ sky130_fd_sc_hd__mux2_1
XFILLER_0_57_320 VGND VGND VPWR VPWR sky130_fd_sc_hd__decap_3
X_2933_ RF0.regs\[20\]\[30\] _0627_ _1091_ RF0.regs\[25\]\[30\] _1092_ VGND VGND VPWR
+ VPWR _1093_ sky130_fd_sc_hd__a221o_1
XTAP_TAPCELL_ROW_73_793 VGND VPWR sky130_fd_sc_hd__tapvpwrvgnd_1
XFILLER_0_57_386 VGND VGND VPWR VPWR sky130_fd_sc_hd__decap_6
X_2864_ _0845_ _0851_ _1003_ VGND VGND VPWR VPWR _1025_ sky130_fd_sc_hd__mux2_1
X_4603_ _2247_ VGND VGND VPWR VPWR _0253_ sky130_fd_sc_hd__inv_2
X_2795_ _0930_ _0932_ VGND VGND VPWR VPWR _0956_ sky130_fd_sc_hd__nor2_1
X_4534_ _2279_ VGND VGND VPWR VPWR _0191_ sky130_fd_sc_hd__inv_2
XFILLER_0_13_423 VPWR VGND VPWR VGND sky130_ef_sc_hd__decap_12
XFILLER_0_25_272 VGND VGND VPWR VPWR sky130_fd_sc_hd__decap_8
XFILLER_0_40_220 VGND VGND VPWR VPWR sky130_fd_sc_hd__decap_3
XFILLER_0_4_177 VPWR VGND VPWR VGND sky130_ef_sc_hd__decap_12
XFILLER_0_40_253 VGND VGND VPWR VPWR sky130_fd_sc_hd__decap_3
X_4465_ _2270_ VGND VGND VPWR VPWR _0131_ sky130_fd_sc_hd__inv_2
X_4396_ _2260_ VGND VGND VPWR VPWR _0072_ sky130_fd_sc_hd__inv_2
X_3416_ _1562_ _1570_ _1572_ VGND VGND VPWR VPWR _1573_ sky130_fd_sc_hd__o21ai_1
X_3347_ _1484_ _1486_ VGND VGND VPWR VPWR _1504_ sky130_fd_sc_hd__or2_1
X_3278_ _0838_ _0845_ _1014_ VGND VGND VPWR VPWR _1436_ sky130_fd_sc_hd__mux2_1
XTAP_TAPCELL_ROW_28_418 VGND VPWR sky130_fd_sc_hd__tapvpwrvgnd_1
XFILLER_0_67_106 VGND VGND VPWR VPWR sky130_fd_sc_hd__decap_6
XTAP_TAPCELL_ROW_36_484 VGND VPWR sky130_fd_sc_hd__tapvpwrvgnd_1
XFILLER_0_7_3 VPWR VGND VPWR VGND sky130_ef_sc_hd__decap_12
XFILLER_0_39_353 VGND VGND VPWR VPWR sky130_fd_sc_hd__decap_6
XFILLER_0_39_375 VGND VGND VPWR VPWR sky130_fd_sc_hd__decap_4
XFILLER_0_6_409 VGND VGND VPWR VPWR sky130_fd_sc_hd__decap_8
XFILLER_0_66_183 VGND VGND VPWR VPWR sky130_fd_sc_hd__fill_1
XTAP_TAPCELL_ROW_70_774 VGND VPWR sky130_fd_sc_hd__tapvpwrvgnd_1
XFILLER_0_81_153 VPWR VGND VPWR VGND sky130_ef_sc_hd__decap_12
XFILLER_0_14_209 VGND VGND VPWR VPWR sky130_fd_sc_hd__decap_3
XFILLER_0_81_197 VPWR VGND VPWR VGND sky130_ef_sc_hd__decap_12
XFILLER_0_22_231 VPWR VGND VPWR VGND sky130_ef_sc_hd__decap_12
XFILLER_0_22_253 VGND VGND VPWR VPWR sky130_fd_sc_hd__decap_4
X_2580_ _0657_ _0740_ VGND VGND VPWR VPWR _0741_ sky130_fd_sc_hd__nand2_1
XFILLER_0_1_147 VGND VGND VPWR VPWR sky130_fd_sc_hd__fill_1
XFILLER_0_22_264 VGND VGND VPWR VPWR sky130_fd_sc_hd__decap_6
X_4250_ _1538_ _1773_ _2205_ VGND VGND VPWR VPWR net23 sky130_fd_sc_hd__a21bo_1
XFILLER_0_38_43 VGND VGND VPWR VPWR sky130_fd_sc_hd__decap_3
X_4181_ _2169_ VGND VGND VPWR VPWR _2170_ sky130_fd_sc_hd__clkbuf_4
X_3201_ _1308_ _1325_ _1344_ _1359_ VGND VGND VPWR VPWR _1360_ sky130_fd_sc_hd__o22ai_2
X_3132_ _0722_ _1028_ VGND VGND VPWR VPWR _1292_ sky130_fd_sc_hd__or2_1
XFILLER_0_38_76 VGND VGND VPWR VPWR sky130_fd_sc_hd__fill_2
XTAP_TAPCELL_ROW_78_841 VGND VPWR sky130_fd_sc_hd__tapvpwrvgnd_1
X_3063_ _0831_ _0829_ _1004_ VGND VGND VPWR VPWR _1223_ sky130_fd_sc_hd__mux2_1
XFILLER_0_54_53 VPWR VGND VPWR VGND sky130_ef_sc_hd__decap_12
XFILLER_0_9_225 VGND VGND VPWR VPWR sky130_fd_sc_hd__fill_1
XFILLER_0_9_236 VGND VGND VPWR VPWR sky130_fd_sc_hd__fill_1
X_3965_ _2054_ VGND VGND VPWR VPWR _0388_ sky130_fd_sc_hd__clkbuf_1
XTAP_TAPCELL_ROW_33_454 VGND VPWR sky130_fd_sc_hd__tapvpwrvgnd_1
XFILLER_0_70_41 VPWR VGND VPWR VGND sky130_ef_sc_hd__decap_12
X_2916_ RF0.regs\[10\]\[28\] _0618_ _0676_ RF0.regs\[25\]\[28\] VGND VGND VPWR VPWR
+ _1077_ sky130_fd_sc_hd__a22o_1
X_3896_ _2016_ VGND VGND VPWR VPWR _0419_ sky130_fd_sc_hd__clkbuf_1
X_2847_ _0898_ _1006_ _1007_ VGND VGND VPWR VPWR _1008_ sky130_fd_sc_hd__mux2_1
XFILLER_0_45_378 VGND VGND VPWR VPWR sky130_fd_sc_hd__decap_4
XFILLER_0_72_197 VGND VGND VPWR VPWR sky130_fd_sc_hd__decap_6
Xhold110 RF0.regs\[20\]\[2\] VGND VGND VPWR VPWR net145 sky130_fd_sc_hd__dlygate4sd3_1
X_2778_ _0771_ _0741_ VGND VGND VPWR VPWR _0939_ sky130_fd_sc_hd__nand2_1
Xhold121 RF0.regs\[30\]\[9\] VGND VGND VPWR VPWR net156 sky130_fd_sc_hd__dlygate4sd3_1
X_4517_ _2277_ VGND VGND VPWR VPWR _0176_ sky130_fd_sc_hd__inv_2
X_4448_ _2266_ VGND VGND VPWR VPWR _0118_ sky130_fd_sc_hd__inv_2
X_4379_ _2256_ VGND VGND VPWR VPWR _0059_ sky130_fd_sc_hd__inv_2
XFILLER_0_68_404 VGND VGND VPWR VPWR sky130_fd_sc_hd__fill_1
XFILLER_0_76_481 VGND VGND VPWR VPWR sky130_fd_sc_hd__fill_1
XFILLER_0_36_323 VPWR VGND VPWR VGND sky130_ef_sc_hd__decap_12
XFILLER_0_51_337 VGND VGND VPWR VPWR sky130_fd_sc_hd__decap_4
XTAP_TAPCELL_ROW_75_811 VGND VPWR sky130_fd_sc_hd__tapvpwrvgnd_1
XTAP_TAPCELL_ROW_47_579 VGND VPWR sky130_fd_sc_hd__tapvpwrvgnd_1
X_3750_ _1588_ _1879_ _1602_ _1890_ VGND VGND VPWR VPWR _1891_ sky130_fd_sc_hd__a22o_1
XFILLER_0_27_312 VGND VGND VPWR VPWR sky130_fd_sc_hd__fill_1
XFILLER_0_67_481 VGND VGND VPWR VPWR sky130_fd_sc_hd__fill_1
X_2701_ _0718_ _0722_ _0622_ VGND VGND VPWR VPWR _0862_ sky130_fd_sc_hd__a21oi_1
XFILLER_0_27_367 VGND VGND VPWR VPWR sky130_fd_sc_hd__fill_2
XFILLER_0_27_378 VPWR VGND VPWR VGND sky130_ef_sc_hd__decap_12
XTAP_TAPCELL_ROW_30_435 VGND VPWR sky130_fd_sc_hd__tapvpwrvgnd_1
X_3681_ _1827_ net22 VGND VGND VPWR VPWR _1830_ sky130_fd_sc_hd__or2_1
XFILLER_0_54_175 VGND VGND VPWR VPWR sky130_fd_sc_hd__decap_8
XFILLER_0_54_197 VGND VGND VPWR VPWR sky130_fd_sc_hd__decap_6
X_2632_ _0692_ _0694_ _0747_ VGND VGND VPWR VPWR _0793_ sky130_fd_sc_hd__and3_1
X_2563_ _0711_ _0713_ _0715_ _0723_ VGND VGND VPWR VPWR _0724_ sky130_fd_sc_hd__or4_4
XFILLER_0_2_445 VPWR VGND VPWR VGND sky130_ef_sc_hd__decap_12
XFILLER_0_10_234 VPWR VGND VPWR VGND sky130_ef_sc_hd__decap_12
XFILLER_0_10_223 VGND VGND VPWR VPWR sky130_fd_sc_hd__decap_4
X_4302_ _0654_ _0983_ _1242_ _2240_ VGND VGND VPWR VPWR net20 sky130_fd_sc_hd__a31o_1
X_4233_ _2197_ VGND VGND VPWR VPWR _0263_ sky130_fd_sc_hd__clkbuf_1
X_2494_ IM0.addr\[0\] IM0.addr\[1\] VGND VGND VPWR VPWR _0655_ sky130_fd_sc_hd__or2b_1
XFILLER_0_4_66 VPWR VGND VPWR VGND sky130_ef_sc_hd__decap_12
X_4164_ _2007_ RF0.regs\[25\]\[7\] _2156_ VGND VGND VPWR VPWR _2161_ sky130_fd_sc_hd__mux2_1
X_4095_ _2124_ VGND VGND VPWR VPWR _0328_ sky130_fd_sc_hd__clkbuf_1
XTAP_TAPCELL_ROW_38_502 VGND VPWR sky130_fd_sc_hd__tapvpwrvgnd_1
X_3115_ RF0.regs\[0\]\[26\] _0605_ _1274_ VGND VGND VPWR VPWR _1275_ sky130_fd_sc_hd__o21ai_1
X_3046_ _1045_ _1067_ _1069_ _1078_ _1049_ _1066_ VGND VGND VPWR VPWR _1206_ sky130_fd_sc_hd__mux4_1
XFILLER_0_65_96 VPWR VGND VPWR VGND sky130_ef_sc_hd__decap_12
XFILLER_0_77_223 VGND VGND VPWR VPWR sky130_fd_sc_hd__fill_1
XTAP_TAPCELL_ROW_81_869 VGND VPWR sky130_fd_sc_hd__tapvpwrvgnd_1
XFILLER_0_58_481 VGND VGND VPWR VPWR sky130_fd_sc_hd__fill_1
X_3948_ _2045_ VGND VGND VPWR VPWR _0396_ sky130_fd_sc_hd__clkbuf_1
XFILLER_0_33_304 VPWR VGND VPWR VGND sky130_ef_sc_hd__decap_12
XFILLER_0_45_131 VGND VGND VPWR VPWR sky130_fd_sc_hd__fill_1
XFILLER_0_73_473 VGND VGND VPWR VPWR sky130_fd_sc_hd__decap_8
X_3879_ _2003_ _2004_ VGND VGND VPWR VPWR _2005_ sky130_fd_sc_hd__nor2_1
XFILLER_0_33_359 VPWR VGND VPWR VGND sky130_ef_sc_hd__decap_12
XTAP_TAPCELL_ROW_1_182 VGND VPWR sky130_fd_sc_hd__tapvpwrvgnd_1
XFILLER_0_68_245 VGND VGND VPWR VPWR sky130_fd_sc_hd__decap_6
XTAP_TAPCELL_ROW_44_549 VGND VPWR sky130_fd_sc_hd__tapvpwrvgnd_1
XFILLER_0_68_289 VGND VGND VPWR VPWR sky130_fd_sc_hd__fill_2
XFILLER_0_49_481 VGND VGND VPWR VPWR sky130_fd_sc_hd__fill_1
XFILLER_0_64_462 VPWR VGND VPWR VGND sky130_ef_sc_hd__decap_12
XFILLER_0_51_178 VGND VGND VPWR VPWR sky130_fd_sc_hd__decap_8
XFILLER_0_19_45 VGND VGND VPWR VPWR sky130_fd_sc_hd__fill_2
XFILLER_0_35_33 VGND VGND VPWR VPWR sky130_fd_sc_hd__fill_1
XFILLER_0_35_44 VGND VGND VPWR VPWR sky130_fd_sc_hd__fill_1
XFILLER_0_35_99 VGND VGND VPWR VPWR sky130_fd_sc_hd__fill_1
XFILLER_0_59_223 VGND VGND VPWR VPWR sky130_fd_sc_hd__fill_1
X_4851_ clknet_leaf_26_clk _0501_ _0245_ VGND VGND VPWR VPWR IM0.addr\[21\] sky130_fd_sc_hd__dfrtp_1
XFILLER_0_47_418 VGND VGND VPWR VPWR sky130_fd_sc_hd__decap_4
XFILLER_0_51_54 VGND VGND VPWR VPWR sky130_fd_sc_hd__fill_2
X_3802_ _1136_ _1941_ _1942_ _1085_ VGND VGND VPWR VPWR _1943_ sky130_fd_sc_hd__o211a_1
X_4782_ clknet_leaf_5_clk _0432_ _0176_ VGND VGND VPWR VPWR RF0.regs\[5\]\[16\] sky130_fd_sc_hd__dfrtp_1
X_3733_ _0653_ _1698_ _1699_ _1204_ _1873_ VGND VGND VPWR VPWR _1874_ sky130_fd_sc_hd__a32o_1
XFILLER_0_70_421 VPWR VGND VPWR VGND sky130_ef_sc_hd__decap_12
X_3664_ RF0.regs\[0\]\[28\] _0605_ _1200_ VGND VGND VPWR VPWR _1815_ sky130_fd_sc_hd__o21ai_1
XFILLER_0_15_337 VGND VGND VPWR VPWR sky130_fd_sc_hd__fill_2
XFILLER_0_30_329 VGND VGND VPWR VPWR sky130_fd_sc_hd__decap_3
XFILLER_0_42_178 VPWR VGND VPWR VGND sky130_ef_sc_hd__decap_12
X_2615_ _0684_ _0752_ _0625_ VGND VGND VPWR VPWR _0776_ sky130_fd_sc_hd__a21o_1
X_3595_ _1039_ _1743_ _1745_ VGND VGND VPWR VPWR _1746_ sky130_fd_sc_hd__o21ai_1
X_2546_ RF0.regs\[15\]\[4\] _0662_ VGND VGND VPWR VPWR _0707_ sky130_fd_sc_hd__nand2_1
X_2477_ _0637_ VGND VGND VPWR VPWR _0638_ sky130_fd_sc_hd__buf_2
X_4216_ _2188_ VGND VGND VPWR VPWR _0271_ sky130_fd_sc_hd__clkbuf_1
XFILLER_0_48_3 VPWR VGND VPWR VGND sky130_ef_sc_hd__decap_12
X_4147_ _1981_ RF0.regs\[25\]\[15\] _2145_ VGND VGND VPWR VPWR _2152_ sky130_fd_sc_hd__mux2_1
X_4078_ _2115_ VGND VGND VPWR VPWR _0336_ sky130_fd_sc_hd__clkbuf_1
X_3029_ _1077_ _0774_ _1068_ VGND VGND VPWR VPWR _1189_ sky130_fd_sc_hd__mux2_1
XFILLER_0_65_237 VGND VGND VPWR VPWR sky130_fd_sc_hd__decap_6
XFILLER_0_18_153 VGND VGND VPWR VPWR sky130_fd_sc_hd__decap_3
XFILLER_0_46_462 VGND VGND VPWR VPWR sky130_fd_sc_hd__fill_1
XFILLER_0_73_281 VGND VGND VPWR VPWR sky130_fd_sc_hd__decap_6
Xclkload2 clknet_leaf_1_clk VGND VGND VPWR VPWR clkload2/X sky130_fd_sc_hd__clkbuf_4
XFILLER_0_18_197 VGND VGND VPWR VPWR sky130_fd_sc_hd__decap_8
XFILLER_0_33_167 VGND VGND VPWR VPWR sky130_fd_sc_hd__fill_1
XFILLER_0_14_392 VGND VGND VPWR VPWR sky130_fd_sc_hd__decap_4
XFILLER_0_33_189 VGND VGND VPWR VPWR sky130_fd_sc_hd__decap_6
XTAP_TAPCELL_ROW_6_230 VGND VPWR sky130_fd_sc_hd__tapvpwrvgnd_1
XTAP_TAPCELL_ROW_57_663 VGND VPWR sky130_fd_sc_hd__tapvpwrvgnd_1
XFILLER_0_24_112 VGND VGND VPWR VPWR sky130_fd_sc_hd__fill_2
XFILLER_0_52_421 VGND VGND VPWR VPWR sky130_fd_sc_hd__decap_4
XFILLER_0_71_218 VGND VGND VPWR VPWR sky130_fd_sc_hd__decap_6
XTAP_TAPCELL_ROW_12_276 VGND VPWR sky130_fd_sc_hd__tapvpwrvgnd_1
XFILLER_0_21_57 VGND VGND VPWR VPWR sky130_fd_sc_hd__decap_4
XFILLER_0_12_307 VGND VGND VPWR VPWR sky130_fd_sc_hd__fill_1
XFILLER_0_12_329 VGND VGND VPWR VPWR sky130_fd_sc_hd__decap_3
X_2400_ net87 VGND VGND VPWR VPWR _0575_ sky130_fd_sc_hd__clkbuf_1
X_3380_ _1534_ _1536_ VGND VGND VPWR VPWR _1537_ sky130_fd_sc_hd__or2_1
X_2331_ net65 _0525_ VGND VGND VPWR VPWR _0498_ sky130_fd_sc_hd__xor2_1
X_4001_ _1965_ RF0.regs\[15\]\[19\] _2071_ VGND VGND VPWR VPWR _2074_ sky130_fd_sc_hd__mux2_1
XFILLER_0_62_53 VGND VGND VPWR VPWR sky130_fd_sc_hd__decap_8
XFILLER_0_62_97 VGND VGND VPWR VPWR sky130_fd_sc_hd__decap_8
X_4834_ clknet_leaf_27_clk _0484_ _0228_ VGND VGND VPWR VPWR IM0.addr\[4\] sky130_fd_sc_hd__dfrtp_1
XFILLER_0_28_451 VGND VGND VPWR VPWR sky130_fd_sc_hd__fill_1
X_4765_ clknet_leaf_12_clk _0415_ _0159_ VGND VGND VPWR VPWR RF0.regs\[10\]\[31\]
+ sky130_fd_sc_hd__dfrtp_2
XFILLER_0_15_101 VGND VGND VPWR VPWR sky130_fd_sc_hd__decap_6
XFILLER_0_7_378 VPWR VGND VPWR VGND sky130_ef_sc_hd__decap_12
X_3716_ _1858_ VGND VGND VPWR VPWR _0441_ sky130_fd_sc_hd__clkbuf_1
XFILLER_0_15_178 VGND VGND VPWR VPWR sky130_fd_sc_hd__fill_1
XFILLER_0_70_273 VGND VGND VPWR VPWR sky130_fd_sc_hd__fill_1
X_4696_ clknet_leaf_7_clk _0346_ _0090_ VGND VGND VPWR VPWR RF0.regs\[20\]\[26\] sky130_fd_sc_hd__dfrtp_1
X_3647_ _1000_ _1797_ VGND VGND VPWR VPWR _1798_ sky130_fd_sc_hd__nor2_1
X_3578_ _1717_ _1729_ VGND VGND VPWR VPWR _1730_ sky130_fd_sc_hd__nand2_1
X_2529_ _0659_ _0689_ VGND VGND VPWR VPWR _0690_ sky130_fd_sc_hd__nand2_1
Xhold36 IM0.addr\[29\] VGND VGND VPWR VPWR net71 sky130_fd_sc_hd__dlygate4sd3_1
XTAP_TAPCELL_ROW_3_200 VGND VPWR sky130_fd_sc_hd__tapvpwrvgnd_1
Xhold47 IM0.addr\[20\] VGND VGND VPWR VPWR net82 sky130_fd_sc_hd__dlygate4sd3_1
Xhold25 IM0.addr\[8\] VGND VGND VPWR VPWR net60 sky130_fd_sc_hd__dlygate4sd3_1
Xhold58 RF0.regs\[0\]\[9\] VGND VGND VPWR VPWR net93 sky130_fd_sc_hd__dlygate4sd3_1
Xhold69 RF0.regs\[0\]\[23\] VGND VGND VPWR VPWR net104 sky130_fd_sc_hd__dlygate4sd3_1
XTAP_TAPCELL_ROW_54_633 VGND VPWR sky130_fd_sc_hd__tapvpwrvgnd_1
XFILLER_0_38_248 VGND VGND VPWR VPWR sky130_fd_sc_hd__decap_4
XFILLER_0_19_473 VGND VGND VPWR VPWR sky130_fd_sc_hd__decap_8
XFILLER_0_34_421 VPWR VGND VPWR VGND sky130_ef_sc_hd__decap_12
XFILLER_0_46_281 VGND VGND VPWR VPWR sky130_fd_sc_hd__fill_1
XTAP_TAPCELL_ROW_17_324 VGND VPWR sky130_fd_sc_hd__tapvpwrvgnd_1
XFILLER_0_69_362 VGND VGND VPWR VPWR sky130_fd_sc_hd__fill_2
XFILLER_0_29_237 VPWR VGND VPWR VGND sky130_ef_sc_hd__decap_12
X_2880_ RF0.regs\[10\]\[20\] _0617_ _0674_ RF0.regs\[25\]\[20\] VGND VGND VPWR VPWR
+ _1041_ sky130_fd_sc_hd__a22oi_4
XTAP_TAPCELL_ROW_25_390 VGND VPWR sky130_fd_sc_hd__tapvpwrvgnd_1
XFILLER_0_44_218 VGND VGND VPWR VPWR sky130_fd_sc_hd__fill_2
XFILLER_0_25_476 VGND VGND VPWR VPWR sky130_fd_sc_hd__fill_2
X_4550_ _2282_ VGND VGND VPWR VPWR _0204_ sky130_fd_sc_hd__inv_2
X_3501_ _0874_ _0870_ _0873_ VGND VGND VPWR VPWR _1656_ sky130_fd_sc_hd__and3_1
X_4481_ _2269_ VGND VGND VPWR VPWR _2272_ sky130_fd_sc_hd__buf_4
X_3432_ _0850_ _0851_ VGND VGND VPWR VPWR _1589_ sky130_fd_sc_hd__xor2_1
XFILLER_0_40_446 VPWR VGND VPWR VGND sky130_ef_sc_hd__decap_12
X_3363_ _0891_ _0838_ _1042_ VGND VGND VPWR VPWR _1520_ sky130_fd_sc_hd__mux2_1
XFILLER_0_20_192 VGND VGND VPWR VPWR sky130_fd_sc_hd__fill_1
X_2314_ net78 _0531_ net79 VGND VGND VPWR VPWR _0536_ sky130_fd_sc_hd__a21oi_1
X_3294_ RF0.regs\[5\]\[21\] _0634_ _0638_ RF0.regs\[30\]\[21\] _0641_ VGND VGND VPWR
+ VPWR _1452_ sky130_fd_sc_hd__a221o_1
XTAP_TAPCELL_ROW_68_758 VGND VPWR sky130_fd_sc_hd__tapvpwrvgnd_1
XPHY_EDGE_ROW_69_Left_151 VGND VGND VPWR VPWR sky130_fd_sc_hd__decap_3
XFILLER_0_75_321 VGND VGND VPWR VPWR sky130_fd_sc_hd__fill_1
X_4817_ clknet_leaf_10_clk _0467_ _0211_ VGND VGND VPWR VPWR RF0.regs\[0\]\[19\] sky130_fd_sc_hd__dfrtp_1
XFILLER_0_16_421 VGND VGND VPWR VPWR sky130_fd_sc_hd__fill_1
XPHY_EDGE_ROW_78_Left_160 VGND VGND VPWR VPWR sky130_fd_sc_hd__decap_3
XFILLER_0_7_186 VGND VGND VPWR VPWR sky130_fd_sc_hd__decap_8
X_4748_ clknet_leaf_3_clk _0398_ _0142_ VGND VGND VPWR VPWR RF0.regs\[10\]\[14\] sky130_fd_sc_hd__dfrtp_4
X_4679_ clknet_leaf_22_clk _0329_ _0073_ VGND VGND VPWR VPWR RF0.regs\[20\]\[9\] sky130_fd_sc_hd__dfrtp_1
XPHY_EDGE_ROW_1_Right_1 VGND VGND VPWR VPWR sky130_fd_sc_hd__decap_3
Xoutput15 net15 VGND VGND VPWR VPWR Result[22] sky130_fd_sc_hd__buf_2
Xoutput26 net26 VGND VGND VPWR VPWR Result[3] sky130_fd_sc_hd__buf_2
XFILLER_0_66_321 VPWR VGND VPWR VGND sky130_ef_sc_hd__decap_12
XFILLER_0_66_354 VGND VGND VPWR VPWR sky130_fd_sc_hd__decap_8
XFILLER_0_26_207 VGND VGND VPWR VPWR sky130_fd_sc_hd__fill_1
XFILLER_0_66_387 VGND VGND VPWR VPWR sky130_fd_sc_hd__decap_3
XTAP_TAPCELL_ROW_22_360 VGND VPWR sky130_fd_sc_hd__tapvpwrvgnd_1
XFILLER_0_34_251 VGND VGND VPWR VPWR sky130_fd_sc_hd__fill_1
XFILLER_0_34_273 VGND VGND VPWR VPWR sky130_fd_sc_hd__fill_2
XFILLER_0_27_45 VGND VGND VPWR VPWR sky130_fd_sc_hd__decap_8
XTAP_TAPCELL_ROW_65_728 VGND VPWR sky130_fd_sc_hd__tapvpwrvgnd_1
XFILLER_0_76_107 VGND VGND VPWR VPWR sky130_fd_sc_hd__decap_6
XFILLER_0_76_129 VGND VGND VPWR VPWR sky130_fd_sc_hd__decap_4
X_3981_ _2063_ VGND VGND VPWR VPWR _0381_ sky130_fd_sc_hd__clkbuf_1
XFILLER_0_43_55 VGND VGND VPWR VPWR sky130_fd_sc_hd__fill_1
X_2932_ RF0.regs\[15\]\[30\] _0611_ _0631_ RF0.regs\[10\]\[30\] VGND VGND VPWR VPWR
+ _1092_ sky130_fd_sc_hd__a22o_1
XFILLER_0_43_88 VPWR VGND VPWR VGND sky130_ef_sc_hd__decap_12
XTAP_TAPCELL_ROW_73_794 VGND VPWR sky130_fd_sc_hd__tapvpwrvgnd_1
XFILLER_0_17_207 VGND VGND VPWR VPWR sky130_fd_sc_hd__fill_2
XFILLER_0_72_324 VGND VGND VPWR VPWR sky130_fd_sc_hd__fill_1
X_2863_ _1022_ _1023_ _1003_ VGND VGND VPWR VPWR _1024_ sky130_fd_sc_hd__mux2_1
X_4602_ _2247_ VGND VGND VPWR VPWR _0252_ sky130_fd_sc_hd__inv_2
X_2794_ _0953_ _0954_ VGND VGND VPWR VPWR _0955_ sky130_fd_sc_hd__nor2_1
X_4533_ _2279_ VGND VGND VPWR VPWR _0190_ sky130_fd_sc_hd__inv_2
XFILLER_0_13_435 VPWR VGND VPWR VGND sky130_ef_sc_hd__decap_12
XFILLER_0_25_295 VGND VGND VPWR VPWR sky130_fd_sc_hd__decap_4
XFILLER_0_40_210 VGND VGND VPWR VPWR sky130_fd_sc_hd__fill_1
XFILLER_0_4_189 VGND VGND VPWR VPWR sky130_fd_sc_hd__decap_3
XFILLER_0_7_77 VGND VGND VPWR VPWR sky130_fd_sc_hd__decap_3
X_4464_ _2270_ VGND VGND VPWR VPWR _0130_ sky130_fd_sc_hd__inv_2
XFILLER_0_68_41 VPWR VGND VPWR VGND sky130_ef_sc_hd__decap_12
XFILLER_0_0_340 VPWR VGND VPWR VGND sky130_ef_sc_hd__decap_12
X_4395_ _2258_ VGND VGND VPWR VPWR _2260_ sky130_fd_sc_hd__buf_4
X_3415_ _1566_ _1571_ _1569_ VGND VGND VPWR VPWR _1572_ sky130_fd_sc_hd__o21ai_2
X_3346_ _1500_ net7 VGND VGND VPWR VPWR _1503_ sky130_fd_sc_hd__or2_1
X_3277_ _0823_ _0816_ _1080_ VGND VGND VPWR VPWR _1435_ sky130_fd_sc_hd__mux2_1
XFILLER_0_30_3 VPWR VGND VPWR VGND sky130_ef_sc_hd__decap_12
XTAP_TAPCELL_ROW_36_485 VGND VPWR sky130_fd_sc_hd__tapvpwrvgnd_1
XFILLER_0_48_365 VGND VGND VPWR VPWR sky130_fd_sc_hd__decap_3
XFILLER_0_48_398 VPWR VGND VPWR VGND sky130_ef_sc_hd__decap_12
XFILLER_0_58_129 VGND VGND VPWR VPWR sky130_fd_sc_hd__fill_2
XFILLER_0_13_36 VGND VGND VPWR VPWR sky130_fd_sc_hd__decap_3
Xclkbuf_leaf_24_clk clknet_1_0__leaf_clk VGND VGND VPWR VPWR clknet_leaf_24_clk sky130_fd_sc_hd__clkbuf_8
XFILLER_0_66_162 VGND VGND VPWR VPWR sky130_fd_sc_hd__decap_3
XTAP_TAPCELL_ROW_70_775 VGND VPWR sky130_fd_sc_hd__tapvpwrvgnd_1
XFILLER_0_81_165 VGND VGND VPWR VPWR sky130_fd_sc_hd__decap_3
XFILLER_0_22_243 VGND VGND VPWR VPWR sky130_fd_sc_hd__decap_8
X_4180_ _0512_ _1150_ VGND VGND VPWR VPWR _2169_ sky130_fd_sc_hd__nand2_2
X_3200_ _1352_ _1354_ _1358_ VGND VGND VPWR VPWR _1359_ sky130_fd_sc_hd__o21ai_2
X_3131_ _1038_ _1101_ VGND VGND VPWR VPWR _1291_ sky130_fd_sc_hd__nor2_2
XTAP_TAPCELL_ROW_78_842 VGND VPWR sky130_fd_sc_hd__tapvpwrvgnd_1
X_3062_ _1155_ _0887_ _1004_ VGND VGND VPWR VPWR _1222_ sky130_fd_sc_hd__mux2_1
XFILLER_0_77_405 VPWR VGND VPWR VGND sky130_ef_sc_hd__decap_12
XFILLER_0_54_65 VGND VGND VPWR VPWR sky130_fd_sc_hd__fill_1
XFILLER_0_77_449 VPWR VGND VPWR VGND sky130_ef_sc_hd__decap_12
X_3964_ _2013_ RF0.regs\[10\]\[4\] _2046_ VGND VGND VPWR VPWR _2054_ sky130_fd_sc_hd__mux2_1
XFILLER_0_70_53 VPWR VGND VPWR VGND sky130_ef_sc_hd__decap_12
X_3895_ _2015_ RF0.regs\[5\]\[3\] _1994_ VGND VGND VPWR VPWR _2016_ sky130_fd_sc_hd__mux2_1
XTAP_TAPCELL_ROW_33_455 VGND VPWR sky130_fd_sc_hd__tapvpwrvgnd_1
X_2915_ _1075_ VGND VGND VPWR VPWR _1076_ sky130_fd_sc_hd__buf_2
X_2846_ _1004_ VGND VGND VPWR VPWR _1007_ sky130_fd_sc_hd__clkbuf_4
XFILLER_0_45_357 VGND VGND VPWR VPWR sky130_fd_sc_hd__fill_1
XFILLER_0_79_51 VGND VGND VPWR VPWR sky130_fd_sc_hd__decap_4
XFILLER_0_78_3 VPWR VGND VPWR VGND sky130_ef_sc_hd__decap_12
Xhold100 RF0.regs\[30\]\[1\] VGND VGND VPWR VPWR net135 sky130_fd_sc_hd__dlygate4sd3_1
X_2777_ _0936_ _0937_ VGND VGND VPWR VPWR _0938_ sky130_fd_sc_hd__xnor2_2
XFILLER_0_13_276 VGND VGND VPWR VPWR sky130_fd_sc_hd__decap_4
X_4516_ _2277_ VGND VGND VPWR VPWR _0175_ sky130_fd_sc_hd__inv_2
Xhold122 RF0.regs\[30\]\[21\] VGND VGND VPWR VPWR net157 sky130_fd_sc_hd__dlygate4sd3_1
Xhold111 RF0.regs\[30\]\[22\] VGND VGND VPWR VPWR net146 sky130_fd_sc_hd__dlygate4sd3_1
X_4447_ _2266_ VGND VGND VPWR VPWR _0117_ sky130_fd_sc_hd__inv_2
XFILLER_0_0_181 VPWR VGND VPWR VGND sky130_ef_sc_hd__decap_12
X_4378_ _2256_ VGND VGND VPWR VPWR _0058_ sky130_fd_sc_hd__inv_2
X_3329_ _1484_ _1486_ VGND VGND VPWR VPWR _1487_ sky130_fd_sc_hd__nor2_1
XFILLER_0_36_335 VGND VGND VPWR VPWR sky130_fd_sc_hd__fill_1
XFILLER_0_8_281 VGND VGND VPWR VPWR sky130_fd_sc_hd__decap_3
XFILLER_0_36_357 VGND VGND VPWR VPWR sky130_fd_sc_hd__fill_1
XTAP_TAPCELL_ROW_75_812 VGND VPWR sky130_fd_sc_hd__tapvpwrvgnd_1
XFILLER_0_59_416 VGND VGND VPWR VPWR sky130_fd_sc_hd__decap_4
XFILLER_0_59_449 VGND VGND VPWR VPWR sky130_fd_sc_hd__decap_8
XFILLER_0_74_419 VGND VGND VPWR VPWR sky130_fd_sc_hd__fill_1
XFILLER_0_39_162 VGND VGND VPWR VPWR sky130_fd_sc_hd__fill_1
X_2700_ _0859_ _0860_ VGND VGND VPWR VPWR _0861_ sky130_fd_sc_hd__nand2_1
XFILLER_0_54_154 VPWR VGND VPWR VGND sky130_ef_sc_hd__decap_12
X_3680_ _0654_ _0989_ _1215_ _1829_ VGND VGND VPWR VPWR net22 sky130_fd_sc_hd__a31o_1
XFILLER_0_42_305 VGND VGND VPWR VPWR sky130_fd_sc_hd__decap_3
X_2631_ _0790_ _0791_ VGND VGND VPWR VPWR _0792_ sky130_fd_sc_hd__nor2_1
X_2562_ _0716_ _0718_ _0722_ VGND VGND VPWR VPWR _0723_ sky130_fd_sc_hd__a21o_4
XFILLER_0_2_457 VPWR VGND VPWR VGND sky130_ef_sc_hd__decap_12
X_4301_ _1205_ _2239_ _2217_ _1333_ VGND VGND VPWR VPWR _2240_ sky130_fd_sc_hd__a22o_1
XFILLER_0_10_246 VGND VGND VPWR VPWR sky130_fd_sc_hd__fill_1
X_4232_ _2007_ net142 _2192_ VGND VGND VPWR VPWR _2197_ sky130_fd_sc_hd__mux2_1
X_2493_ _0653_ VGND VGND VPWR VPWR _0654_ sky130_fd_sc_hd__clkbuf_4
Xclkbuf_leaf_4_clk clknet_1_1__leaf_clk VGND VGND VPWR VPWR clknet_leaf_4_clk sky130_fd_sc_hd__clkbuf_8
X_4163_ _2160_ VGND VGND VPWR VPWR _0296_ sky130_fd_sc_hd__clkbuf_1
XFILLER_0_4_78 VGND VGND VPWR VPWR sky130_fd_sc_hd__decap_6
X_4094_ net138 _2005_ _2120_ VGND VGND VPWR VPWR _2124_ sky130_fd_sc_hd__mux2_1
XTAP_TAPCELL_ROW_38_503 VGND VPWR sky130_fd_sc_hd__tapvpwrvgnd_1
X_3114_ _1271_ _1273_ VGND VGND VPWR VPWR _1274_ sky130_fd_sc_hd__or2_1
X_3045_ _1204_ VGND VGND VPWR VPWR _1205_ sky130_fd_sc_hd__buf_2
XFILLER_0_81_41 VPWR VGND VPWR VGND sky130_ef_sc_hd__decap_12
XFILLER_0_81_85 VPWR VGND VPWR VGND sky130_ef_sc_hd__decap_12
XFILLER_0_77_279 VGND VGND VPWR VPWR sky130_fd_sc_hd__fill_1
XFILLER_0_65_419 VGND VGND VPWR VPWR sky130_fd_sc_hd__decap_8
X_3947_ _1990_ RF0.regs\[10\]\[12\] _2035_ VGND VGND VPWR VPWR _2045_ sky130_fd_sc_hd__mux2_1
X_3878_ _1584_ _1693_ VGND VGND VPWR VPWR _2004_ sky130_fd_sc_hd__and2_1
XFILLER_0_33_316 VPWR VGND VPWR VGND sky130_ef_sc_hd__decap_12
X_2829_ _0760_ _0761_ VGND VGND VPWR VPWR _0990_ sky130_fd_sc_hd__and2_1
XFILLER_0_60_179 VGND VGND VPWR VPWR sky130_fd_sc_hd__fill_2
XFILLER_0_68_213 VGND VGND VPWR VPWR sky130_fd_sc_hd__decap_4
XTAP_TAPCELL_ROW_1_183 VGND VPWR sky130_fd_sc_hd__tapvpwrvgnd_1
XFILLER_0_51_113 VGND VGND VPWR VPWR sky130_fd_sc_hd__decap_6
XFILLER_0_64_474 VGND VGND VPWR VPWR sky130_fd_sc_hd__fill_2
XFILLER_0_10_15 VPWR VGND VPWR VGND sky130_ef_sc_hd__decap_12
XPHY_EDGE_ROW_23_Left_105 VGND VGND VPWR VPWR sky130_fd_sc_hd__decap_3
XTAP_TAPCELL_ROW_9_250 VGND VPWR sky130_fd_sc_hd__tapvpwrvgnd_1
XPHY_EDGE_ROW_32_Left_114 VGND VGND VPWR VPWR sky130_fd_sc_hd__decap_3
XFILLER_0_59_235 VGND VGND VPWR VPWR sky130_fd_sc_hd__decap_3
X_4850_ clknet_leaf_26_clk _0500_ _0244_ VGND VGND VPWR VPWR IM0.addr\[20\] sky130_fd_sc_hd__dfrtp_1
XFILLER_0_27_110 VGND VGND VPWR VPWR sky130_fd_sc_hd__fill_2
X_3801_ _1136_ _1868_ VGND VGND VPWR VPWR _1942_ sky130_fd_sc_hd__nand2_1
X_4781_ clknet_leaf_1_clk _0431_ _0175_ VGND VGND VPWR VPWR RF0.regs\[5\]\[15\] sky130_fd_sc_hd__dfrtp_1
XFILLER_0_55_441 VGND VGND VPWR VPWR sky130_fd_sc_hd__decap_6
X_3732_ _1331_ _1872_ _1038_ VGND VGND VPWR VPWR _1873_ sky130_fd_sc_hd__mux2_1
XFILLER_0_55_474 VGND VGND VPWR VPWR sky130_fd_sc_hd__decap_8
X_3663_ _1381_ _1303_ _1405_ _1813_ VGND VGND VPWR VPWR _1814_ sky130_fd_sc_hd__or4_4
XPHY_EDGE_ROW_41_Left_123 VGND VGND VPWR VPWR sky130_fd_sc_hd__decap_3
Xclkload20 clknet_leaf_10_clk VGND VGND VPWR VPWR clkload20/Y sky130_fd_sc_hd__inv_6
XFILLER_0_70_433 VPWR VGND VPWR VGND sky130_ef_sc_hd__decap_12
X_2614_ _0773_ _0774_ VGND VGND VPWR VPWR _0775_ sky130_fd_sc_hd__nand2_1
XFILLER_0_70_477 VGND VGND VPWR VPWR sky130_fd_sc_hd__decap_4
X_3594_ _1134_ _1744_ _1084_ VGND VGND VPWR VPWR _1745_ sky130_fd_sc_hd__o21a_1
X_2545_ RF0.regs\[15\]\[7\] _0662_ _0667_ RF0.regs\[5\]\[7\] VGND VGND VPWR VPWR _0706_
+ sky130_fd_sc_hd__a22o_1
XFILLER_0_76_41 VPWR VGND VPWR VGND sky130_ef_sc_hd__decap_12
X_2476_ _0636_ VGND VGND VPWR VPWR _0637_ sky130_fd_sc_hd__clkbuf_4
XFILLER_0_76_85 VGND VGND VPWR VPWR sky130_fd_sc_hd__fill_1
X_4215_ _1981_ RF0.regs\[30\]\[15\] _2181_ VGND VGND VPWR VPWR _2188_ sky130_fd_sc_hd__mux2_1
X_4146_ _2151_ VGND VGND VPWR VPWR _0304_ sky130_fd_sc_hd__clkbuf_1
XPHY_EDGE_ROW_50_Left_132 VGND VGND VPWR VPWR sky130_fd_sc_hd__decap_3
X_4077_ RF0.regs\[20\]\[16\] _1975_ _2109_ VGND VGND VPWR VPWR _2115_ sky130_fd_sc_hd__mux2_1
X_3028_ _1049_ _1187_ VGND VGND VPWR VPWR _1188_ sky130_fd_sc_hd__or2_1
XFILLER_0_18_176 VGND VGND VPWR VPWR sky130_fd_sc_hd__decap_8
Xclkload3 clknet_leaf_2_clk VGND VGND VPWR VPWR clkload3/Y sky130_fd_sc_hd__bufinv_16
XFILLER_0_33_113 VGND VGND VPWR VPWR sky130_fd_sc_hd__fill_2
XFILLER_0_33_146 VPWR VGND VPWR VGND sky130_ef_sc_hd__decap_12
XFILLER_0_61_455 VGND VGND VPWR VPWR sky130_fd_sc_hd__fill_1
XTAP_TAPCELL_ROW_6_231 VGND VPWR sky130_fd_sc_hd__tapvpwrvgnd_1
XTAP_TAPCELL_ROW_57_664 VGND VPWR sky130_fd_sc_hd__tapvpwrvgnd_1
XFILLER_0_56_238 VGND VGND VPWR VPWR sky130_fd_sc_hd__decap_3
XTAP_TAPCELL_ROW_40_520 VGND VPWR sky130_fd_sc_hd__tapvpwrvgnd_1
XTAP_TAPCELL_ROW_12_277 VGND VPWR sky130_fd_sc_hd__tapvpwrvgnd_1
XFILLER_0_52_477 VGND VGND VPWR VPWR sky130_fd_sc_hd__fill_1
XFILLER_0_20_330 VGND VGND VPWR VPWR sky130_fd_sc_hd__fill_2
XFILLER_0_20_341 VPWR VGND VPWR VGND sky130_ef_sc_hd__decap_12
X_2330_ _0526_ net62 VGND VGND VPWR VPWR _0499_ sky130_fd_sc_hd__nor2_1
X_4000_ _2073_ VGND VGND VPWR VPWR _0372_ sky130_fd_sc_hd__clkbuf_1
XFILLER_0_1_57 VPWR VGND VPWR VGND sky130_ef_sc_hd__decap_12
XFILLER_0_47_205 VPWR VGND VPWR VGND sky130_ef_sc_hd__decap_12
XFILLER_0_47_238 VPWR VGND VPWR VGND sky130_ef_sc_hd__decap_12
X_4833_ clknet_leaf_27_clk _0483_ _0227_ VGND VGND VPWR VPWR IM0.addr\[3\] sky130_fd_sc_hd__dfrtp_1
X_4764_ clknet_leaf_12_clk _0414_ _0158_ VGND VGND VPWR VPWR RF0.regs\[10\]\[30\]
+ sky130_fd_sc_hd__dfrtp_1
XFILLER_0_55_260 VGND VGND VPWR VPWR sky130_fd_sc_hd__fill_2
XFILLER_0_15_113 VGND VGND VPWR VPWR sky130_fd_sc_hd__decap_6
X_3715_ _1857_ RF0.regs\[5\]\[25\] _1835_ VGND VGND VPWR VPWR _1858_ sky130_fd_sc_hd__mux2_1
X_4695_ clknet_leaf_8_clk _0345_ _0089_ VGND VGND VPWR VPWR RF0.regs\[20\]\[25\] sky130_fd_sc_hd__dfrtp_1
X_3646_ _1363_ _1372_ _1038_ VGND VGND VPWR VPWR _1797_ sky130_fd_sc_hd__mux2_1
X_3577_ _0652_ _1720_ _1721_ _1728_ VGND VGND VPWR VPWR _1729_ sky130_fd_sc_hd__a31o_1
XFILLER_0_60_3 VPWR VGND VPWR VGND sky130_ef_sc_hd__decap_12
X_2528_ RF0.regs\[15\]\[23\] _0664_ _0673_ RF0.regs\[5\]\[23\] VGND VGND VPWR VPWR
+ _0689_ sky130_fd_sc_hd__a22o_1
X_2459_ RF0.regs\[15\]\[31\] _0611_ _0619_ RF0.regs\[25\]\[31\] VGND VGND VPWR VPWR
+ _0620_ sky130_fd_sc_hd__a22o_1
Xhold37 IM0.addr\[5\] VGND VGND VPWR VPWR net72 sky130_fd_sc_hd__dlygate4sd3_1
Xhold26 IM0.addr\[19\] VGND VGND VPWR VPWR net61 sky130_fd_sc_hd__dlygate4sd3_1
XTAP_TAPCELL_ROW_3_201 VGND VPWR sky130_fd_sc_hd__tapvpwrvgnd_1
Xhold48 IM0.addr\[11\] VGND VGND VPWR VPWR net83 sky130_fd_sc_hd__dlygate4sd3_1
Xhold59 RF0.regs\[0\]\[19\] VGND VGND VPWR VPWR net94 sky130_fd_sc_hd__dlygate4sd3_1
X_4129_ _2142_ VGND VGND VPWR VPWR _0312_ sky130_fd_sc_hd__clkbuf_1
XTAP_TAPCELL_ROW_54_634 VGND VPWR sky130_fd_sc_hd__tapvpwrvgnd_1
XFILLER_0_19_441 VGND VGND VPWR VPWR sky130_fd_sc_hd__decap_6
XPHY_EDGE_ROW_7_Left_89 VGND VGND VPWR VPWR sky130_fd_sc_hd__decap_3
XFILLER_0_21_116 VPWR VGND VPWR VGND sky130_ef_sc_hd__decap_12
XFILLER_0_61_296 VPWR VGND VPWR VGND sky130_ef_sc_hd__decap_12
XFILLER_0_16_69 VGND VGND VPWR VPWR sky130_fd_sc_hd__fill_2
XFILLER_0_29_249 VGND VGND VPWR VPWR sky130_fd_sc_hd__decap_4
XTAP_TAPCELL_ROW_25_391 VGND VPWR sky130_fd_sc_hd__tapvpwrvgnd_1
XFILLER_0_37_260 VPWR VGND VPWR VGND sky130_ef_sc_hd__decap_12
XFILLER_0_25_411 VGND VGND VPWR VPWR sky130_fd_sc_hd__decap_6
XFILLER_0_25_433 VPWR VGND VPWR VGND sky130_ef_sc_hd__decap_12
X_3500_ _1652_ _1654_ VGND VGND VPWR VPWR _1655_ sky130_fd_sc_hd__nor2_1
XFILLER_0_4_338 VGND VGND VPWR VPWR sky130_fd_sc_hd__fill_1
XFILLER_0_52_241 VGND VGND VPWR VPWR sky130_fd_sc_hd__decap_8
XFILLER_0_40_436 VGND VGND VPWR VPWR sky130_fd_sc_hd__fill_1
X_4480_ _2271_ VGND VGND VPWR VPWR _0145_ sky130_fd_sc_hd__inv_2
X_3431_ _1585_ _1587_ VGND VGND VPWR VPWR _1588_ sky130_fd_sc_hd__or2_2
XFILLER_0_40_458 VPWR VGND VPWR VGND sky130_ef_sc_hd__decap_12
X_3362_ _0845_ _0851_ _1042_ VGND VGND VPWR VPWR _1519_ sky130_fd_sc_hd__mux2_1
X_2313_ net71 _0532_ VGND VGND VPWR VPWR _0509_ sky130_fd_sc_hd__xor2_1
X_3293_ RF0.regs\[15\]\[21\] _0610_ _0618_ RF0.regs\[25\]\[21\] VGND VGND VPWR VPWR
+ _1451_ sky130_fd_sc_hd__a22o_1
XFILLER_0_79_105 VGND VGND VPWR VPWR sky130_fd_sc_hd__decap_4
XFILLER_0_79_138 VGND VGND VPWR VPWR sky130_fd_sc_hd__decap_6
XFILLER_0_75_355 VGND VGND VPWR VPWR sky130_fd_sc_hd__decap_8
X_4816_ clknet_leaf_11_clk _0466_ _0210_ VGND VGND VPWR VPWR RF0.regs\[0\]\[18\] sky130_fd_sc_hd__dfrtp_1
XFILLER_0_28_271 VGND VGND VPWR VPWR sky130_fd_sc_hd__decap_8
XFILLER_0_16_477 VGND VGND VPWR VPWR sky130_fd_sc_hd__decap_4
X_4747_ clknet_leaf_3_clk _0397_ _0141_ VGND VGND VPWR VPWR RF0.regs\[10\]\[13\] sky130_fd_sc_hd__dfrtp_2
X_4678_ clknet_leaf_22_clk _0328_ _0072_ VGND VGND VPWR VPWR RF0.regs\[20\]\[8\] sky130_fd_sc_hd__dfrtp_1
XFILLER_0_3_371 VGND VGND VPWR VPWR sky130_fd_sc_hd__fill_1
X_3629_ _1778_ _1436_ _1430_ _1779_ _1074_ _1020_ VGND VGND VPWR VPWR _1780_ sky130_fd_sc_hd__mux4_1
Xoutput27 net27 VGND VGND VPWR VPWR Result[4] sky130_fd_sc_hd__buf_2
Xoutput16 net16 VGND VGND VPWR VPWR Result[23] sky130_fd_sc_hd__buf_2
XFILLER_0_66_333 VGND VGND VPWR VPWR sky130_fd_sc_hd__fill_1
XFILLER_0_26_219 VGND VGND VPWR VPWR sky130_fd_sc_hd__decap_6
XTAP_TAPCELL_ROW_22_361 VGND VPWR sky130_fd_sc_hd__tapvpwrvgnd_1
XFILLER_0_66_399 VGND VGND VPWR VPWR sky130_fd_sc_hd__decap_6
XFILLER_0_34_285 VPWR VGND VPWR VGND sky130_ef_sc_hd__decap_12
XFILLER_0_27_57 VPWR VGND VPWR VGND sky130_ef_sc_hd__decap_12
XTAP_TAPCELL_ROW_65_729 VGND VPWR sky130_fd_sc_hd__tapvpwrvgnd_1
X_3980_ _1842_ RF0.regs\[15\]\[29\] _2060_ VGND VGND VPWR VPWR _2063_ sky130_fd_sc_hd__mux2_1
XFILLER_0_57_300 VPWR VGND VPWR VGND sky130_ef_sc_hd__decap_12
X_2931_ _1090_ VGND VGND VPWR VPWR _1091_ sky130_fd_sc_hd__clkbuf_4
XTAP_TAPCELL_ROW_73_795 VGND VPWR sky130_fd_sc_hd__tapvpwrvgnd_1
Xclkbuf_0_clk clk VGND VGND VPWR VPWR clknet_0_clk sky130_fd_sc_hd__clkbuf_16
XFILLER_0_72_336 VGND VGND VPWR VPWR sky130_fd_sc_hd__fill_1
X_2862_ RF0.regs\[10\]\[4\] _0614_ _0671_ RF0.regs\[25\]\[4\] VGND VGND VPWR VPWR
+ _1023_ sky130_fd_sc_hd__a22o_1
X_4601_ _2247_ VGND VGND VPWR VPWR _0251_ sky130_fd_sc_hd__inv_2
XFILLER_0_4_102 VGND VGND VPWR VPWR sky130_fd_sc_hd__decap_6
X_2793_ _0936_ _0937_ VGND VGND VPWR VPWR _0954_ sky130_fd_sc_hd__nor2_1
X_4532_ _2279_ VGND VGND VPWR VPWR _0189_ sky130_fd_sc_hd__inv_2
X_4463_ _2270_ VGND VGND VPWR VPWR _0129_ sky130_fd_sc_hd__inv_2
XFILLER_0_13_447 VGND VGND VPWR VPWR sky130_fd_sc_hd__fill_1
X_3414_ RF0.regs\[0\]\[11\] _0603_ VGND VGND VPWR VPWR _1571_ sky130_fd_sc_hd__nor2_1
XFILLER_0_68_53 VGND VGND VPWR VPWR sky130_fd_sc_hd__decap_8
XPHY_EDGE_ROW_15_Right_15 VGND VGND VPWR VPWR sky130_fd_sc_hd__decap_3
XFILLER_0_0_352 VGND VGND VPWR VPWR sky130_fd_sc_hd__fill_1
X_4394_ _2259_ VGND VGND VPWR VPWR _0071_ sky130_fd_sc_hd__inv_2
XFILLER_0_0_385 VGND VGND VPWR VPWR sky130_fd_sc_hd__decap_6
X_3345_ _1096_ _1502_ _1501_ _1035_ _1151_ VGND VGND VPWR VPWR net7 sky130_fd_sc_hd__o32ai_4
XFILLER_0_68_97 VGND VGND VPWR VPWR sky130_fd_sc_hd__decap_8
X_3276_ _1432_ _1433_ _1151_ VGND VGND VPWR VPWR _1434_ sky130_fd_sc_hd__o21a_1
XFILLER_0_23_3 VGND VGND VPWR VPWR sky130_fd_sc_hd__decap_3
XPHY_EDGE_ROW_24_Right_24 VGND VGND VPWR VPWR sky130_fd_sc_hd__decap_3
XFILLER_0_75_130 VPWR VGND VPWR VGND sky130_ef_sc_hd__decap_12
XTAP_TAPCELL_ROW_36_486 VGND VPWR sky130_fd_sc_hd__tapvpwrvgnd_1
XFILLER_0_48_388 VGND VGND VPWR VPWR sky130_fd_sc_hd__fill_1
XFILLER_0_31_211 VGND VGND VPWR VPWR sky130_fd_sc_hd__decap_6
XFILLER_0_16_296 VPWR VGND VPWR VGND sky130_ef_sc_hd__decap_12
XFILLER_0_71_391 VGND VGND VPWR VPWR sky130_fd_sc_hd__fill_1
XPHY_EDGE_ROW_33_Right_33 VGND VGND VPWR VPWR sky130_fd_sc_hd__decap_3
XFILLER_0_31_299 VGND VGND VPWR VPWR sky130_fd_sc_hd__decap_4
XPHY_EDGE_ROW_42_Right_42 VGND VGND VPWR VPWR sky130_fd_sc_hd__decap_3
XFILLER_0_66_130 VGND VGND VPWR VPWR sky130_fd_sc_hd__decap_8
XFILLER_0_66_141 VGND VGND VPWR VPWR sky130_fd_sc_hd__fill_1
XFILLER_0_54_325 VPWR VGND VPWR VGND sky130_ef_sc_hd__decap_12
XFILLER_0_81_177 VGND VGND VPWR VPWR sky130_fd_sc_hd__fill_1
XPHY_EDGE_ROW_51_Right_51 VGND VGND VPWR VPWR sky130_fd_sc_hd__decap_3
XFILLER_0_1_138 VGND VGND VPWR VPWR sky130_fd_sc_hd__decap_3
X_3130_ _1039_ _1289_ VGND VGND VPWR VPWR _1290_ sky130_fd_sc_hd__nor2_1
XTAP_TAPCELL_ROW_78_843 VGND VPWR sky130_fd_sc_hd__tapvpwrvgnd_1
X_3061_ _1019_ _1011_ _1216_ _1220_ VGND VGND VPWR VPWR _1221_ sky130_fd_sc_hd__a31o_1
XPHY_EDGE_ROW_60_Right_60 VGND VGND VPWR VPWR sky130_fd_sc_hd__decap_3
XFILLER_0_77_417 VPWR VGND VPWR VGND sky130_ef_sc_hd__decap_12
X_3963_ _2053_ VGND VGND VPWR VPWR _0389_ sky130_fd_sc_hd__clkbuf_1
X_3894_ _1651_ _1886_ VGND VGND VPWR VPWR _2015_ sky130_fd_sc_hd__xor2_2
XTAP_TAPCELL_ROW_33_456 VGND VPWR sky130_fd_sc_hd__tapvpwrvgnd_1
X_2914_ _1074_ VGND VGND VPWR VPWR _1075_ sky130_fd_sc_hd__clkbuf_4
XFILLER_0_70_65 VGND VGND VPWR VPWR sky130_fd_sc_hd__decap_8
X_2845_ RF0.regs\[10\]\[14\] _0615_ _0672_ RF0.regs\[25\]\[14\] VGND VGND VPWR VPWR
+ _1006_ sky130_fd_sc_hd__a22oi_4
XFILLER_0_13_222 VGND VGND VPWR VPWR sky130_fd_sc_hd__fill_2
Xhold101 RF0.regs\[20\]\[0\] VGND VGND VPWR VPWR net136 sky130_fd_sc_hd__dlygate4sd3_1
X_4515_ _2277_ VGND VGND VPWR VPWR _0174_ sky130_fd_sc_hd__inv_2
X_2776_ RF0.regs\[10\]\[18\] _0615_ _0931_ RF0.regs\[25\]\[18\] VGND VGND VPWR VPWR
+ _0937_ sky130_fd_sc_hd__a22oi_4
XFILLER_0_53_391 VGND VGND VPWR VPWR sky130_fd_sc_hd__fill_1
XFILLER_0_13_266 VGND VGND VPWR VPWR sky130_fd_sc_hd__fill_1
Xhold123 RF0.regs\[30\]\[17\] VGND VGND VPWR VPWR net158 sky130_fd_sc_hd__dlygate4sd3_1
Xhold112 RF0.regs\[30\]\[26\] VGND VGND VPWR VPWR net147 sky130_fd_sc_hd__dlygate4sd3_1
X_4446_ _2266_ VGND VGND VPWR VPWR _0116_ sky130_fd_sc_hd__inv_2
X_4377_ _2256_ VGND VGND VPWR VPWR _0057_ sky130_fd_sc_hd__inv_2
XFILLER_0_0_193 VGND VGND VPWR VPWR sky130_fd_sc_hd__decap_3
X_3328_ RF0.regs\[20\]\[14\] _0625_ _0610_ RF0.regs\[15\]\[14\] _1485_ VGND VGND VPWR
+ VPWR _1486_ sky130_fd_sc_hd__a221o_1
X_3259_ _1255_ _1251_ _1263_ _1257_ _1064_ _1134_ VGND VGND VPWR VPWR _1417_ sky130_fd_sc_hd__mux4_1
XFILLER_0_36_303 VGND VGND VPWR VPWR sky130_fd_sc_hd__fill_2
XFILLER_0_48_141 VGND VGND VPWR VPWR sky130_fd_sc_hd__decap_6
XTAP_TAPCELL_ROW_75_813 VGND VPWR sky130_fd_sc_hd__tapvpwrvgnd_1
XFILLER_0_39_130 VGND VGND VPWR VPWR sky130_fd_sc_hd__fill_2
XFILLER_0_67_461 VPWR VGND VPWR VGND sky130_ef_sc_hd__decap_12
XFILLER_0_6_208 VGND VGND VPWR VPWR sky130_fd_sc_hd__decap_3
XFILLER_0_54_166 VGND VGND VPWR VPWR sky130_fd_sc_hd__decap_6
X_2630_ _0788_ _0789_ VGND VGND VPWR VPWR _0791_ sky130_fd_sc_hd__and2_1
XFILLER_0_42_339 VGND VGND VPWR VPWR sky130_fd_sc_hd__fill_1
X_2561_ _0710_ _0719_ _0720_ _0721_ VGND VGND VPWR VPWR _0722_ sky130_fd_sc_hd__o31a_4
XFILLER_0_2_469 VGND VGND VPWR VPWR sky130_fd_sc_hd__decap_6
X_2492_ _0652_ VGND VGND VPWR VPWR _0653_ sky130_fd_sc_hd__clkbuf_4
XFILLER_0_49_55 VGND VGND VPWR VPWR sky130_fd_sc_hd__fill_1
X_4300_ _1040_ _2221_ _2238_ VGND VGND VPWR VPWR _2239_ sky130_fd_sc_hd__o21ai_1
XFILLER_0_10_269 VGND VGND VPWR VPWR sky130_fd_sc_hd__decap_3
X_4231_ _2196_ VGND VGND VPWR VPWR _0264_ sky130_fd_sc_hd__clkbuf_1
XFILLER_0_49_77 VGND VGND VPWR VPWR sky130_fd_sc_hd__decap_4
X_4162_ _2005_ RF0.regs\[25\]\[8\] _2156_ VGND VGND VPWR VPWR _2160_ sky130_fd_sc_hd__mux2_1
X_4093_ _2123_ VGND VGND VPWR VPWR _0329_ sky130_fd_sc_hd__clkbuf_1
XFILLER_0_65_65 VGND VGND VPWR VPWR sky130_fd_sc_hd__fill_2
X_3113_ RF0.regs\[20\]\[26\] _0627_ _0611_ RF0.regs\[15\]\[26\] _1272_ VGND VGND VPWR
+ VPWR _1273_ sky130_fd_sc_hd__a221o_1
X_3044_ _1203_ VGND VGND VPWR VPWR _1204_ sky130_fd_sc_hd__buf_2
XFILLER_0_81_53 VGND VGND VPWR VPWR sky130_fd_sc_hd__decap_3
XFILLER_0_77_225 VPWR VGND VPWR VGND sky130_ef_sc_hd__decap_12
XTAP_TAPCELL_ROW_46_570 VGND VPWR sky130_fd_sc_hd__tapvpwrvgnd_1
XFILLER_0_81_97 VPWR VGND VPWR VGND sky130_ef_sc_hd__decap_12
X_3946_ _2044_ VGND VGND VPWR VPWR _0397_ sky130_fd_sc_hd__clkbuf_1
XFILLER_0_45_111 VGND VGND VPWR VPWR sky130_fd_sc_hd__fill_1
XFILLER_0_18_347 VGND VGND VPWR VPWR sky130_fd_sc_hd__decap_8
XFILLER_0_14_91 VGND VGND VPWR VPWR sky130_fd_sc_hd__decap_6
XFILLER_0_45_122 VGND VGND VPWR VPWR sky130_fd_sc_hd__decap_6
X_3877_ _1584_ _1693_ VGND VGND VPWR VPWR _2003_ sky130_fd_sc_hd__nor2_1
X_2828_ _0986_ _0770_ _0988_ VGND VGND VPWR VPWR _0989_ sky130_fd_sc_hd__o21ai_2
XFILLER_0_26_391 VGND VGND VPWR VPWR sky130_fd_sc_hd__decap_4
X_2759_ _0837_ _0894_ _0906_ _0919_ VGND VGND VPWR VPWR _0920_ sky130_fd_sc_hd__a211o_4
X_4429_ _2264_ VGND VGND VPWR VPWR _0101_ sky130_fd_sc_hd__inv_2
XTAP_TAPCELL_ROW_1_184 VGND VPWR sky130_fd_sc_hd__tapvpwrvgnd_1
XFILLER_0_68_225 VGND VGND VPWR VPWR sky130_fd_sc_hd__decap_4
XTAP_TAPCELL_ROW_80_860 VGND VPWR sky130_fd_sc_hd__tapvpwrvgnd_1
XFILLER_0_64_453 VGND VGND VPWR VPWR sky130_fd_sc_hd__decap_3
XFILLER_0_36_177 VPWR VGND VPWR VGND sky130_ef_sc_hd__decap_12
XFILLER_0_10_27 VGND VGND VPWR VPWR sky130_fd_sc_hd__fill_1
XFILLER_0_32_383 VGND VGND VPWR VPWR sky130_fd_sc_hd__fill_1
XTAP_TAPCELL_ROW_9_251 VGND VPWR sky130_fd_sc_hd__tapvpwrvgnd_1
XFILLER_0_35_57 VGND VGND VPWR VPWR sky130_fd_sc_hd__decap_3
XFILLER_0_35_68 VGND VGND VPWR VPWR sky130_fd_sc_hd__fill_2
XFILLER_0_59_247 VPWR VGND VPWR VGND sky130_ef_sc_hd__decap_12
X_4780_ clknet_leaf_1_clk _0430_ _0174_ VGND VGND VPWR VPWR RF0.regs\[5\]\[14\] sky130_fd_sc_hd__dfrtp_1
XTAP_TAPCELL_ROW_43_540 VGND VPWR sky130_fd_sc_hd__tapvpwrvgnd_1
X_3800_ _1138_ _1140_ _1438_ _1139_ _1065_ _1076_ VGND VGND VPWR VPWR _1941_ sky130_fd_sc_hd__mux4_1
XFILLER_0_55_420 VGND VGND VPWR VPWR sky130_fd_sc_hd__decap_6
X_3731_ _1517_ _1521_ _1064_ VGND VGND VPWR VPWR _1872_ sky130_fd_sc_hd__mux2_1
XFILLER_0_70_412 VGND VGND VPWR VPWR sky130_fd_sc_hd__decap_8
Xclkload10 clknet_leaf_23_clk VGND VGND VPWR VPWR clkload10/Y sky130_fd_sc_hd__inv_8
X_3662_ _1483_ _1789_ _1812_ _1809_ _1803_ VGND VGND VPWR VPWR _1813_ sky130_fd_sc_hd__o2111a_4
XFILLER_0_70_445 VPWR VGND VPWR VGND sky130_ef_sc_hd__decap_12
X_3593_ _1138_ _1439_ _1438_ _1435_ _1057_ _1075_ VGND VGND VPWR VPWR _1744_ sky130_fd_sc_hd__mux4_1
Xclkload21 clknet_leaf_11_clk VGND VGND VPWR VPWR clkload21/Y sky130_fd_sc_hd__inv_6
X_2613_ RF0.regs\[10\]\[27\] _0618_ _0676_ RF0.regs\[25\]\[27\] VGND VGND VPWR VPWR
+ _0774_ sky130_fd_sc_hd__a22o_1
X_2544_ _0704_ VGND VGND VPWR VPWR _0705_ sky130_fd_sc_hd__inv_2
X_2475_ IM0.addr\[2\] _0514_ VGND VGND VPWR VPWR _0636_ sky130_fd_sc_hd__and2_2
XFILLER_0_76_53 VPWR VGND VPWR VGND sky130_ef_sc_hd__decap_12
X_4214_ _2187_ VGND VGND VPWR VPWR _0272_ sky130_fd_sc_hd__clkbuf_1
X_4145_ _1975_ RF0.regs\[25\]\[16\] _2145_ VGND VGND VPWR VPWR _2151_ sky130_fd_sc_hd__mux2_1
X_4076_ _2114_ VGND VGND VPWR VPWR _0337_ sky130_fd_sc_hd__clkbuf_1
X_3027_ _0778_ _0784_ _1068_ VGND VGND VPWR VPWR _1187_ sky130_fd_sc_hd__mux2_1
Xclkload4 clknet_leaf_3_clk VGND VGND VPWR VPWR clkload4/Y sky130_fd_sc_hd__clkinv_2
X_3929_ _1956_ RF0.regs\[10\]\[21\] _2035_ VGND VGND VPWR VPWR _2036_ sky130_fd_sc_hd__mux2_1
XFILLER_0_33_158 VGND VGND VPWR VPWR sky130_fd_sc_hd__decap_6
XFILLER_0_33_169 VGND VGND VPWR VPWR sky130_fd_sc_hd__decap_4
XFILLER_0_41_180 VGND VGND VPWR VPWR sky130_fd_sc_hd__decap_4
XFILLER_0_37_420 VGND VGND VPWR VPWR sky130_fd_sc_hd__fill_1
XFILLER_0_37_442 VGND VGND VPWR VPWR sky130_fd_sc_hd__decap_6
XFILLER_0_52_401 VPWR VGND VPWR VGND sky130_ef_sc_hd__decap_12
XTAP_TAPCELL_ROW_12_278 VGND VPWR sky130_fd_sc_hd__tapvpwrvgnd_1
XFILLER_0_24_125 VGND VGND VPWR VPWR sky130_fd_sc_hd__fill_2
XFILLER_0_64_272 VGND VGND VPWR VPWR sky130_fd_sc_hd__fill_1
XFILLER_0_12_309 VPWR VGND VPWR VGND sky130_ef_sc_hd__decap_12
XFILLER_0_20_320 VGND VGND VPWR VPWR sky130_fd_sc_hd__fill_1
XFILLER_0_20_353 VGND VGND VPWR VPWR sky130_fd_sc_hd__decap_8
XFILLER_0_1_69 VGND VGND VPWR VPWR sky130_fd_sc_hd__fill_1
XFILLER_0_47_217 VGND VGND VPWR VPWR sky130_fd_sc_hd__decap_6
XFILLER_0_62_66 VGND VGND VPWR VPWR sky130_fd_sc_hd__fill_1
X_4832_ clknet_leaf_25_clk _0482_ _0226_ VGND VGND VPWR VPWR IM0.addr\[2\] sky130_fd_sc_hd__dfrtp_4
X_4763_ clknet_leaf_12_clk _0413_ _0157_ VGND VGND VPWR VPWR RF0.regs\[10\]\[29\]
+ sky130_fd_sc_hd__dfrtp_1
XFILLER_0_7_325 VGND VGND VPWR VPWR sky130_fd_sc_hd__decap_8
X_4694_ clknet_leaf_9_clk _0344_ _0088_ VGND VGND VPWR VPWR RF0.regs\[20\]\[24\] sky130_fd_sc_hd__dfrtp_1
X_3714_ _1855_ _1856_ VGND VGND VPWR VPWR _1857_ sky130_fd_sc_hd__xnor2_2
XFILLER_0_15_169 VGND VGND VPWR VPWR sky130_fd_sc_hd__fill_1
XFILLER_0_15_147 VGND VGND VPWR VPWR sky130_fd_sc_hd__fill_1
XFILLER_0_70_253 VGND VGND VPWR VPWR sky130_fd_sc_hd__fill_1
XFILLER_0_11_70 VGND VGND VPWR VPWR sky130_fd_sc_hd__fill_1
XFILLER_0_30_106 VGND VGND VPWR VPWR sky130_fd_sc_hd__fill_1
X_3645_ _1300_ _1361_ _1203_ VGND VGND VPWR VPWR _1796_ sky130_fd_sc_hd__a21oi_1
XFILLER_0_11_331 VGND VGND VPWR VPWR sky130_fd_sc_hd__decap_4
X_3576_ _1000_ _1726_ _1727_ VGND VGND VPWR VPWR _1728_ sky130_fd_sc_hd__o21a_1
X_2527_ _0659_ _0687_ VGND VGND VPWR VPWR _0688_ sky130_fd_sc_hd__nand2_1
X_2458_ _0618_ VGND VGND VPWR VPWR _0619_ sky130_fd_sc_hd__buf_4
XFILLER_0_53_3 VPWR VGND VPWR VGND sky130_ef_sc_hd__decap_12
Xhold38 IM0.addr\[17\] VGND VGND VPWR VPWR net73 sky130_fd_sc_hd__dlygate4sd3_1
Xhold27 _0542_ VGND VGND VPWR VPWR net62 sky130_fd_sc_hd__dlygate4sd3_1
Xhold16 IM0.addr\[31\] VGND VGND VPWR VPWR net51 sky130_fd_sc_hd__dlygate4sd3_1
XTAP_TAPCELL_ROW_3_202 VGND VPWR sky130_fd_sc_hd__tapvpwrvgnd_1
Xhold49 IM0.addr\[26\] VGND VGND VPWR VPWR net84 sky130_fd_sc_hd__dlygate4sd3_1
X_2389_ _0569_ VGND VGND VPWR VPWR _0467_ sky130_fd_sc_hd__clkbuf_1
X_4128_ _1859_ RF0.regs\[25\]\[24\] _2134_ VGND VGND VPWR VPWR _2142_ sky130_fd_sc_hd__mux2_1
X_4059_ _2105_ VGND VGND VPWR VPWR _0345_ sky130_fd_sc_hd__clkbuf_1
XTAP_TAPCELL_ROW_54_635 VGND VPWR sky130_fd_sc_hd__tapvpwrvgnd_1
XFILLER_0_38_217 VGND VGND VPWR VPWR sky130_fd_sc_hd__fill_1
XFILLER_0_34_401 VGND VGND VPWR VPWR sky130_fd_sc_hd__decap_3
XFILLER_0_21_128 VGND VGND VPWR VPWR sky130_fd_sc_hd__fill_2
XFILLER_0_61_275 VGND VGND VPWR VPWR sky130_fd_sc_hd__decap_4
XFILLER_0_16_15 VGND VGND VPWR VPWR sky130_fd_sc_hd__fill_1
XFILLER_0_69_386 VGND VGND VPWR VPWR sky130_fd_sc_hd__decap_3
XTAP_TAPCELL_ROW_25_392 VGND VPWR sky130_fd_sc_hd__tapvpwrvgnd_1
XFILLER_0_25_423 VGND VGND VPWR VPWR sky130_fd_sc_hd__fill_1
XFILLER_0_37_272 VGND VGND VPWR VPWR sky130_fd_sc_hd__decap_8
X_3430_ RF0.regs\[20\]\[7\] _0624_ _1090_ RF0.regs\[25\]\[7\] _1586_ VGND VGND VPWR
+ VPWR _1587_ sky130_fd_sc_hd__a221o_1
X_3361_ _1458_ _1517_ _1062_ VGND VGND VPWR VPWR _1518_ sky130_fd_sc_hd__mux2_1
X_2312_ _0535_ VGND VGND VPWR VPWR _0510_ sky130_fd_sc_hd__clkbuf_1
XFILLER_0_57_55 VGND VGND VPWR VPWR sky130_fd_sc_hd__fill_1
X_3292_ _1445_ _1427_ _1449_ VGND VGND VPWR VPWR _1450_ sky130_fd_sc_hd__a21bo_4
X_4815_ clknet_leaf_16_clk _0465_ _0209_ VGND VGND VPWR VPWR RF0.regs\[0\]\[17\] sky130_fd_sc_hd__dfrtp_1
X_4746_ clknet_leaf_2_clk _0396_ _0140_ VGND VGND VPWR VPWR RF0.regs\[10\]\[12\] sky130_fd_sc_hd__dfrtp_2
X_4677_ clknet_leaf_22_clk _0327_ _0071_ VGND VGND VPWR VPWR RF0.regs\[20\]\[7\] sky130_fd_sc_hd__dfrtp_1
X_3628_ _1429_ VGND VGND VPWR VPWR _1779_ sky130_fd_sc_hd__inv_2
Xoutput17 net17 VGND VGND VPWR VPWR Result[24] sky130_fd_sc_hd__clkbuf_4
Xoutput28 net28 VGND VGND VPWR VPWR Result[5] sky130_fd_sc_hd__buf_2
X_3559_ _1533_ _1711_ _1545_ VGND VGND VPWR VPWR _1712_ sky130_fd_sc_hd__or3_1
XFILLER_0_81_359 VGND VGND VPWR VPWR sky130_fd_sc_hd__decap_4
XTAP_TAPCELL_ROW_22_362 VGND VPWR sky130_fd_sc_hd__tapvpwrvgnd_1
XFILLER_0_22_404 VGND VGND VPWR VPWR sky130_fd_sc_hd__decap_4
XFILLER_0_34_253 VPWR VGND VPWR VGND sky130_ef_sc_hd__decap_12
XFILLER_0_34_297 VGND VGND VPWR VPWR sky130_fd_sc_hd__decap_6
XFILLER_0_27_36 VGND VGND VPWR VPWR sky130_fd_sc_hd__decap_3
XFILLER_0_27_69 VPWR VGND VPWR VGND sky130_ef_sc_hd__decap_12
XFILLER_0_57_312 VGND VGND VPWR VPWR sky130_fd_sc_hd__decap_8
XTAP_TAPCELL_ROW_73_796 VGND VPWR sky130_fd_sc_hd__tapvpwrvgnd_1
XFILLER_0_43_57 VPWR VGND VPWR VGND sky130_ef_sc_hd__decap_12
X_2930_ _0969_ VGND VGND VPWR VPWR _1090_ sky130_fd_sc_hd__buf_4
X_4600_ _2247_ VGND VGND VPWR VPWR _0250_ sky130_fd_sc_hd__inv_2
X_2861_ RF0.regs\[10\]\[5\] _0614_ _0671_ RF0.regs\[25\]\[5\] VGND VGND VPWR VPWR
+ _1022_ sky130_fd_sc_hd__a22o_1
X_2792_ _0930_ _0932_ VGND VGND VPWR VPWR _0953_ sky130_fd_sc_hd__and2_1
X_4531_ _2279_ VGND VGND VPWR VPWR _0188_ sky130_fd_sc_hd__inv_2
X_4462_ _2270_ VGND VGND VPWR VPWR _0128_ sky130_fd_sc_hd__inv_2
X_3413_ _1566_ _1569_ VGND VGND VPWR VPWR _1570_ sky130_fd_sc_hd__nor2_1
X_4393_ _2259_ VGND VGND VPWR VPWR _0070_ sky130_fd_sc_hd__inv_2
XFILLER_0_21_481 VGND VGND VPWR VPWR sky130_fd_sc_hd__fill_1
X_3344_ _0922_ _1490_ _0899_ VGND VGND VPWR VPWR _1502_ sky130_fd_sc_hd__a21oi_2
X_3275_ _1036_ _1150_ VGND VGND VPWR VPWR _1433_ sky130_fd_sc_hd__nand2_4
XFILLER_0_16_3 VPWR VGND VPWR VGND sky130_ef_sc_hd__decap_12
XFILLER_0_48_301 VGND VGND VPWR VPWR sky130_fd_sc_hd__decap_6
XFILLER_0_75_142 VGND VGND VPWR VPWR sky130_fd_sc_hd__fill_1
XFILLER_0_33_90 VGND VGND VPWR VPWR sky130_fd_sc_hd__decap_6
XFILLER_0_63_337 VGND VGND VPWR VPWR sky130_fd_sc_hd__decap_3
XFILLER_0_8_475 VGND VGND VPWR VPWR sky130_fd_sc_hd__fill_1
XFILLER_0_16_253 VGND VGND VPWR VPWR sky130_fd_sc_hd__decap_4
X_4729_ clknet_leaf_8_clk _0379_ _0123_ VGND VGND VPWR VPWR RF0.regs\[15\]\[27\] sky130_fd_sc_hd__dfrtp_1
XFILLER_0_12_481 VGND VGND VPWR VPWR sky130_fd_sc_hd__fill_1
XPHY_EDGE_ROW_10_Left_92 VGND VGND VPWR VPWR sky130_fd_sc_hd__decap_3
XFILLER_0_79_481 VGND VGND VPWR VPWR sky130_fd_sc_hd__fill_1
XFILLER_0_39_323 VGND VGND VPWR VPWR sky130_fd_sc_hd__decap_6
XFILLER_0_1_117 VGND VGND VPWR VPWR sky130_fd_sc_hd__fill_1
XFILLER_0_38_68 VGND VGND VPWR VPWR sky130_fd_sc_hd__decap_8
X_3060_ _1062_ _1219_ VGND VGND VPWR VPWR _1220_ sky130_fd_sc_hd__and2_1
XFILLER_0_77_429 VPWR VGND VPWR VGND sky130_ef_sc_hd__decap_12
X_3962_ _2011_ RF0.regs\[10\]\[5\] _2046_ VGND VGND VPWR VPWR _2053_ sky130_fd_sc_hd__mux2_1
X_3893_ _2014_ VGND VGND VPWR VPWR _0420_ sky130_fd_sc_hd__clkbuf_1
X_2913_ _1073_ VGND VGND VPWR VPWR _1074_ sky130_fd_sc_hd__clkbuf_4
XTAP_TAPCELL_ROW_33_457 VGND VPWR sky130_fd_sc_hd__tapvpwrvgnd_1
XFILLER_0_45_337 VPWR VGND VPWR VGND sky130_ef_sc_hd__decap_12
X_2844_ _0909_ _0913_ _1004_ VGND VGND VPWR VPWR _1005_ sky130_fd_sc_hd__mux2_1
XFILLER_0_70_88 VGND VGND VPWR VPWR sky130_fd_sc_hd__decap_3
XFILLER_0_72_123 VPWR VGND VPWR VGND sky130_ef_sc_hd__decap_12
XFILLER_0_5_445 VGND VGND VPWR VPWR sky130_fd_sc_hd__decap_3
XFILLER_0_60_329 VGND VGND VPWR VPWR sky130_fd_sc_hd__fill_2
X_4514_ _2277_ VGND VGND VPWR VPWR _0173_ sky130_fd_sc_hd__inv_2
X_2775_ _0934_ _0935_ VGND VGND VPWR VPWR _0936_ sky130_fd_sc_hd__nor2_2
Xhold102 RF0.regs\[20\]\[28\] VGND VGND VPWR VPWR net137 sky130_fd_sc_hd__dlygate4sd3_1
Xhold124 RF0.regs\[30\]\[6\] VGND VGND VPWR VPWR net159 sky130_fd_sc_hd__dlygate4sd3_1
Xhold113 RF0.regs\[30\]\[20\] VGND VGND VPWR VPWR net148 sky130_fd_sc_hd__dlygate4sd3_1
X_4445_ _2266_ VGND VGND VPWR VPWR _0115_ sky130_fd_sc_hd__inv_2
X_4376_ _2256_ VGND VGND VPWR VPWR _0056_ sky130_fd_sc_hd__inv_2
X_3327_ RF0.regs\[5\]\[14\] _0634_ _0638_ RF0.regs\[30\]\[14\] _0641_ VGND VGND VPWR
+ VPWR _1485_ sky130_fd_sc_hd__a221o_1
X_3258_ _0802_ _0800_ _0974_ _1414_ VGND VGND VPWR VPWR _1416_ sky130_fd_sc_hd__a211o_1
X_3189_ _1034_ _1345_ _1347_ _1150_ VGND VGND VPWR VPWR _1348_ sky130_fd_sc_hd__o211a_1
XTAP_TAPCELL_ROW_49_590 VGND VPWR sky130_fd_sc_hd__tapvpwrvgnd_1
XFILLER_0_36_348 VGND VGND VPWR VPWR sky130_fd_sc_hd__fill_2
XFILLER_0_48_197 VPWR VGND VPWR VGND sky130_ef_sc_hd__decap_12
XFILLER_0_63_167 VGND VGND VPWR VPWR sky130_fd_sc_hd__fill_1
XFILLER_0_5_3 VPWR VGND VPWR VGND sky130_ef_sc_hd__decap_12
XTAP_TAPCELL_ROW_75_814 VGND VPWR sky130_fd_sc_hd__tapvpwrvgnd_1
XFILLER_0_24_26 VGND VGND VPWR VPWR sky130_fd_sc_hd__fill_2
XFILLER_0_39_120 VGND VGND VPWR VPWR sky130_fd_sc_hd__fill_1
XFILLER_0_39_153 VGND VGND VPWR VPWR sky130_fd_sc_hd__fill_2
XFILLER_0_67_440 VGND VGND VPWR VPWR sky130_fd_sc_hd__decap_8
XFILLER_0_67_473 VGND VGND VPWR VPWR sky130_fd_sc_hd__decap_8
XTAP_TAPCELL_ROW_30_427 VGND VPWR sky130_fd_sc_hd__tapvpwrvgnd_1
X_2560_ _0513_ IM0.addr\[0\] _0594_ _0600_ VGND VGND VPWR VPWR _0721_ sky130_fd_sc_hd__or4bb_4
X_2491_ _0651_ VGND VGND VPWR VPWR _0652_ sky130_fd_sc_hd__buf_2
X_4230_ _2005_ net144 _2192_ VGND VGND VPWR VPWR _2196_ sky130_fd_sc_hd__mux2_1
X_4161_ _2159_ VGND VGND VPWR VPWR _0297_ sky130_fd_sc_hd__clkbuf_1
X_4092_ net119 _2001_ _2120_ VGND VGND VPWR VPWR _2123_ sky130_fd_sc_hd__mux2_1
XFILLER_0_65_55 VGND VGND VPWR VPWR sky130_fd_sc_hd__fill_1
X_3112_ RF0.regs\[5\]\[26\] _0635_ _0639_ RF0.regs\[30\]\[26\] _0642_ VGND VGND VPWR
+ VPWR _1272_ sky130_fd_sc_hd__a221o_1
X_3043_ _1202_ VGND VGND VPWR VPWR _1203_ sky130_fd_sc_hd__buf_2
XFILLER_0_77_237 VGND VGND VPWR VPWR sky130_fd_sc_hd__decap_4
XFILLER_0_77_259 VPWR VGND VPWR VGND sky130_ef_sc_hd__decap_12
XTAP_TAPCELL_ROW_46_571 VGND VPWR sky130_fd_sc_hd__tapvpwrvgnd_1
XFILLER_0_73_421 VPWR VGND VPWR VGND sky130_ef_sc_hd__decap_12
X_3945_ _1988_ RF0.regs\[10\]\[13\] _2035_ VGND VGND VPWR VPWR _2044_ sky130_fd_sc_hd__mux2_1
X_3876_ _2002_ VGND VGND VPWR VPWR _0425_ sky130_fd_sc_hd__clkbuf_1
X_2827_ _0766_ _0987_ VGND VGND VPWR VPWR _0988_ sky130_fd_sc_hd__and2_1
XFILLER_0_26_381 VGND VGND VPWR VPWR sky130_fd_sc_hd__fill_1
X_2758_ _0910_ _0917_ _0918_ VGND VGND VPWR VPWR _0919_ sky130_fd_sc_hd__or3b_1
XFILLER_0_41_362 VGND VGND VPWR VPWR sky130_fd_sc_hd__fill_1
X_4428_ _2264_ VGND VGND VPWR VPWR _0100_ sky130_fd_sc_hd__inv_2
X_2689_ _0622_ _0848_ _0849_ VGND VGND VPWR VPWR _0850_ sky130_fd_sc_hd__or3_2
XFILLER_0_1_481 VGND VGND VPWR VPWR sky130_fd_sc_hd__fill_1
X_4359_ _2255_ VGND VGND VPWR VPWR _0040_ sky130_fd_sc_hd__inv_2
XTAP_TAPCELL_ROW_1_185 VGND VPWR sky130_fd_sc_hd__tapvpwrvgnd_1
XFILLER_0_76_270 VGND VGND VPWR VPWR sky130_fd_sc_hd__decap_8
XFILLER_0_36_123 VGND VGND VPWR VPWR sky130_fd_sc_hd__fill_2
XFILLER_0_64_421 VGND VGND VPWR VPWR sky130_fd_sc_hd__decap_3
XFILLER_0_24_307 VGND VGND VPWR VPWR sky130_fd_sc_hd__fill_1
XFILLER_0_17_381 VGND VGND VPWR VPWR sky130_fd_sc_hd__decap_8
XFILLER_0_36_189 VGND VGND VPWR VPWR sky130_fd_sc_hd__decap_6
XFILLER_0_32_351 VGND VGND VPWR VPWR sky130_fd_sc_hd__fill_2
XFILLER_0_32_362 VGND VGND VPWR VPWR sky130_fd_sc_hd__fill_2
XTAP_TAPCELL_ROW_9_252 VGND VPWR sky130_fd_sc_hd__tapvpwrvgnd_1
XFILLER_0_19_15 VGND VGND VPWR VPWR sky130_fd_sc_hd__fill_2
XFILLER_0_59_259 VPWR VGND VPWR VGND sky130_ef_sc_hd__decap_12
XTAP_TAPCELL_ROW_43_541 VGND VPWR sky130_fd_sc_hd__tapvpwrvgnd_1
X_3730_ _1711_ VGND VGND VPWR VPWR _1871_ sky130_fd_sc_hd__inv_2
XFILLER_0_27_167 VGND VGND VPWR VPWR sky130_fd_sc_hd__fill_1
XFILLER_0_42_137 VGND VGND VPWR VPWR sky130_fd_sc_hd__decap_3
X_3661_ _1411_ _1421_ _1811_ VGND VGND VPWR VPWR _1812_ sky130_fd_sc_hd__a21o_1
Xclkload22 clknet_leaf_12_clk VGND VGND VPWR VPWR clkload22/Y sky130_fd_sc_hd__bufinv_16
Xclkload11 clknet_leaf_24_clk VGND VGND VPWR VPWR clkload11/X sky130_fd_sc_hd__clkbuf_4
X_3592_ _1742_ _1635_ _1057_ VGND VGND VPWR VPWR _1743_ sky130_fd_sc_hd__mux2_1
X_2612_ _0754_ _0772_ VGND VGND VPWR VPWR _0773_ sky130_fd_sc_hd__nand2_1
XFILLER_0_70_457 VPWR VGND VPWR VGND sky130_ef_sc_hd__decap_12
X_2543_ _0656_ _0703_ VGND VGND VPWR VPWR _0704_ sky130_fd_sc_hd__nand2_1
X_2474_ _0634_ VGND VGND VPWR VPWR _0635_ sky130_fd_sc_hd__buf_2
XFILLER_0_76_65 VPWR VGND VPWR VGND sky130_ef_sc_hd__decap_12
X_4213_ _1975_ RF0.regs\[30\]\[16\] _2181_ VGND VGND VPWR VPWR _2187_ sky130_fd_sc_hd__mux2_1
X_4144_ _2150_ VGND VGND VPWR VPWR _0305_ sky130_fd_sc_hd__clkbuf_1
X_4075_ RF0.regs\[20\]\[17\] _1972_ _2109_ VGND VGND VPWR VPWR _2114_ sky130_fd_sc_hd__mux2_1
X_3026_ _1183_ _1185_ _1075_ VGND VGND VPWR VPWR _1186_ sky130_fd_sc_hd__mux2_1
XFILLER_0_46_421 VGND VGND VPWR VPWR sky130_fd_sc_hd__fill_1
Xclkload5 clknet_leaf_17_clk VGND VGND VPWR VPWR clkload5/Y sky130_fd_sc_hd__inv_6
X_3928_ _2023_ VGND VGND VPWR VPWR _2035_ sky130_fd_sc_hd__clkbuf_4
XFILLER_0_33_104 VGND VGND VPWR VPWR sky130_fd_sc_hd__decap_3
X_3859_ _1989_ VGND VGND VPWR VPWR _0429_ sky130_fd_sc_hd__clkbuf_1
XFILLER_0_61_468 VPWR VGND VPWR VGND sky130_ef_sc_hd__decap_12
XFILLER_0_56_218 VGND VGND VPWR VPWR sky130_fd_sc_hd__decap_6
XFILLER_0_49_281 VGND VGND VPWR VPWR sky130_fd_sc_hd__fill_1
XFILLER_0_64_240 VGND VGND VPWR VPWR sky130_fd_sc_hd__decap_3
XFILLER_0_64_262 VGND VGND VPWR VPWR sky130_fd_sc_hd__decap_3
XFILLER_0_52_413 VGND VGND VPWR VPWR sky130_fd_sc_hd__decap_3
XFILLER_0_52_435 VPWR VGND VPWR VGND sky130_ef_sc_hd__decap_12
XTAP_TAPCELL_ROW_12_279 VGND VPWR sky130_fd_sc_hd__tapvpwrvgnd_1
XFILLER_0_20_365 VPWR VGND VPWR VGND sky130_ef_sc_hd__decap_12
XFILLER_0_1_15 VPWR VGND VPWR VGND sky130_ef_sc_hd__decap_12
X_4831_ clknet_leaf_25_clk _0481_ _0225_ VGND VGND VPWR VPWR IM0.addr\[1\] sky130_fd_sc_hd__dfrtp_2
XFILLER_0_28_421 VGND VGND VPWR VPWR sky130_fd_sc_hd__fill_2
XFILLER_0_28_432 VGND VGND VPWR VPWR sky130_fd_sc_hd__decap_6
X_4762_ clknet_leaf_12_clk _0412_ _0156_ VGND VGND VPWR VPWR RF0.regs\[10\]\[28\]
+ sky130_fd_sc_hd__dfrtp_2
XFILLER_0_55_240 VPWR VGND VPWR VGND sky130_ef_sc_hd__decap_12
XFILLER_0_15_126 VGND VGND VPWR VPWR sky130_fd_sc_hd__fill_1
X_4693_ clknet_leaf_9_clk _0343_ _0087_ VGND VGND VPWR VPWR RF0.regs\[20\]\[23\] sky130_fd_sc_hd__dfrtp_1
X_3713_ _1404_ _1813_ _1359_ VGND VGND VPWR VPWR _1856_ sky130_fd_sc_hd__o21a_1
X_3644_ _1725_ _1794_ _1730_ VGND VGND VPWR VPWR _1795_ sky130_fd_sc_hd__o21a_1
XFILLER_0_43_479 VGND VGND VPWR VPWR sky130_fd_sc_hd__decap_3
XFILLER_0_11_310 VGND VGND VPWR VPWR sky130_fd_sc_hd__fill_1
XFILLER_0_23_181 VGND VGND VPWR VPWR sky130_fd_sc_hd__decap_4
X_3575_ _1154_ _1314_ _1202_ VGND VGND VPWR VPWR _1727_ sky130_fd_sc_hd__a21o_1
X_2526_ RF0.regs\[15\]\[24\] _0664_ _0673_ RF0.regs\[5\]\[24\] VGND VGND VPWR VPWR
+ _0687_ sky130_fd_sc_hd__a22o_1
X_2457_ _0617_ VGND VGND VPWR VPWR _0618_ sky130_fd_sc_hd__clkbuf_4
Xhold28 IM0.addr\[16\] VGND VGND VPWR VPWR net63 sky130_fd_sc_hd__dlygate4sd3_1
Xhold17 IM0.addr\[4\] VGND VGND VPWR VPWR net52 sky130_fd_sc_hd__dlygate4sd3_1
XFILLER_0_46_3 VPWR VGND VPWR VGND sky130_ef_sc_hd__decap_12
XTAP_TAPCELL_ROW_3_203 VGND VPWR sky130_fd_sc_hd__tapvpwrvgnd_1
Xhold39 IM0.addr\[10\] VGND VGND VPWR VPWR net74 sky130_fd_sc_hd__dlygate4sd3_1
X_2388_ net94 VGND VGND VPWR VPWR _0569_ sky130_fd_sc_hd__clkbuf_1
X_4127_ _2141_ VGND VGND VPWR VPWR _0313_ sky130_fd_sc_hd__clkbuf_1
X_4058_ net122 _1857_ _2098_ VGND VGND VPWR VPWR _2105_ sky130_fd_sc_hd__mux2_1
X_3009_ _1167_ _1168_ _1007_ VGND VGND VPWR VPWR _1169_ sky130_fd_sc_hd__mux2_1
XTAP_TAPCELL_ROW_54_636 VGND VPWR sky130_fd_sc_hd__tapvpwrvgnd_1
XFILLER_0_78_376 VPWR VGND VPWR VGND sky130_ef_sc_hd__decap_12
XFILLER_0_46_251 VGND VGND VPWR VPWR sky130_fd_sc_hd__fill_1
XFILLER_0_16_27 VGND VGND VPWR VPWR sky130_fd_sc_hd__fill_1
XFILLER_0_32_15 VPWR VGND VPWR VGND sky130_ef_sc_hd__decap_12
X_3360_ _1073_ _1514_ _1516_ VGND VGND VPWR VPWR _1517_ sky130_fd_sc_hd__a21oi_1
X_2311_ _0533_ _0534_ VGND VGND VPWR VPWR _0535_ sky130_fd_sc_hd__and2b_1
XPHY_EDGE_ROW_29_Left_111 VGND VGND VPWR VPWR sky130_fd_sc_hd__decap_3
X_3291_ _1444_ _1448_ _1426_ VGND VGND VPWR VPWR _1449_ sky130_fd_sc_hd__a21o_1
XFILLER_0_73_55 VGND VGND VPWR VPWR sky130_fd_sc_hd__fill_1
XPHY_EDGE_ROW_38_Left_120 VGND VGND VPWR VPWR sky130_fd_sc_hd__decap_3
XFILLER_0_75_335 VGND VGND VPWR VPWR sky130_fd_sc_hd__fill_1
XTAP_TAPCELL_ROW_51_606 VGND VPWR sky130_fd_sc_hd__tapvpwrvgnd_1
XFILLER_0_7_101 VGND VGND VPWR VPWR sky130_fd_sc_hd__decap_4
X_4814_ clknet_leaf_10_clk _0464_ _0208_ VGND VGND VPWR VPWR RF0.regs\[0\]\[16\] sky130_fd_sc_hd__dfrtp_1
X_4745_ clknet_leaf_21_clk _0395_ _0139_ VGND VGND VPWR VPWR RF0.regs\[10\]\[11\]
+ sky130_fd_sc_hd__dfrtp_2
X_4676_ clknet_leaf_24_clk _0326_ _0070_ VGND VGND VPWR VPWR RF0.regs\[20\]\[6\] sky130_fd_sc_hd__dfrtp_1
XFILLER_0_31_427 VGND VGND VPWR VPWR sky130_fd_sc_hd__decap_3
XFILLER_0_43_265 VGND VGND VPWR VPWR sky130_fd_sc_hd__fill_1
X_3627_ _1435_ VGND VGND VPWR VPWR _1778_ sky130_fd_sc_hd__inv_2
Xoutput18 net18 VGND VGND VPWR VPWR Result[25] sky130_fd_sc_hd__clkbuf_4
Xoutput29 net29 VGND VGND VPWR VPWR Result[6] sky130_fd_sc_hd__buf_2
X_3558_ _1710_ _1542_ _1543_ VGND VGND VPWR VPWR _1711_ sky130_fd_sc_hd__o21ai_2
X_2509_ _0669_ VGND VGND VPWR VPWR _0670_ sky130_fd_sc_hd__clkbuf_4
XFILLER_0_11_195 VGND VGND VPWR VPWR sky130_fd_sc_hd__fill_2
X_3489_ RF0.regs\[0\]\[3\] _0602_ _1644_ VGND VGND VPWR VPWR _1645_ sky130_fd_sc_hd__o21a_1
XFILLER_0_78_173 VGND VGND VPWR VPWR sky130_fd_sc_hd__decap_3
XFILLER_0_19_240 VGND VGND VPWR VPWR sky130_fd_sc_hd__decap_4
XTAP_TAPCELL_ROW_22_363 VGND VPWR sky130_fd_sc_hd__tapvpwrvgnd_1
XFILLER_0_34_265 VGND VGND VPWR VPWR sky130_fd_sc_hd__decap_8
Xclkbuf_leaf_27_clk clknet_1_0__leaf_clk VGND VGND VPWR VPWR clknet_leaf_27_clk sky130_fd_sc_hd__clkbuf_8
XFILLER_0_69_151 VPWR VGND VPWR VGND sky130_ef_sc_hd__decap_12
XFILLER_0_43_69 VPWR VGND VPWR VGND sky130_ef_sc_hd__decap_12
XFILLER_0_69_184 VPWR VGND VPWR VGND sky130_ef_sc_hd__decap_12
XTAP_TAPCELL_ROW_73_797 VGND VPWR sky130_fd_sc_hd__tapvpwrvgnd_1
X_2860_ _1012_ _1018_ _1020_ VGND VGND VPWR VPWR _1021_ sky130_fd_sc_hd__mux2_1
X_2791_ _0949_ _0950_ _0951_ VGND VGND VPWR VPWR _0952_ sky130_fd_sc_hd__o21ai_1
XFILLER_0_4_126 VGND VGND VPWR VPWR sky130_fd_sc_hd__fill_1
X_4530_ _2276_ VGND VGND VPWR VPWR _2279_ sky130_fd_sc_hd__clkbuf_2
XFILLER_0_13_449 VPWR VGND VPWR VGND sky130_ef_sc_hd__decap_12
X_4461_ _2269_ VGND VGND VPWR VPWR _2270_ sky130_fd_sc_hd__clkbuf_4
X_3412_ _1096_ _1567_ _1568_ _1151_ _1266_ VGND VGND VPWR VPWR _1569_ sky130_fd_sc_hd__o32a_2
X_4392_ _2259_ VGND VGND VPWR VPWR _0069_ sky130_fd_sc_hd__inv_2
X_3343_ _0899_ _0922_ _1490_ VGND VGND VPWR VPWR _1501_ sky130_fd_sc_hd__and3_1
X_3274_ _1292_ _1428_ _1429_ _1431_ _1011_ _1063_ VGND VGND VPWR VPWR _1432_ sky130_fd_sc_hd__mux4_2
XTAP_TAPCELL_ROW_64_720 VGND VPWR sky130_fd_sc_hd__tapvpwrvgnd_1
XPHY_EDGE_ROW_5_Right_5 VGND VGND VPWR VPWR sky130_fd_sc_hd__decap_3
Xclkbuf_leaf_18_clk clknet_1_0__leaf_clk VGND VGND VPWR VPWR clknet_leaf_18_clk sky130_fd_sc_hd__clkbuf_8
XFILLER_0_8_421 VPWR VGND VPWR VGND sky130_ef_sc_hd__decap_12
XFILLER_0_75_198 VGND VGND VPWR VPWR sky130_fd_sc_hd__fill_1
XFILLER_0_75_176 VGND VGND VPWR VPWR sky130_fd_sc_hd__fill_2
X_2989_ _1148_ _1146_ VGND VGND VPWR VPWR _1149_ sky130_fd_sc_hd__nand2_1
X_4728_ clknet_leaf_7_clk _0378_ _0122_ VGND VGND VPWR VPWR RF0.regs\[15\]\[26\] sky130_fd_sc_hd__dfrtp_1
X_4659_ clknet_leaf_9_clk _0309_ _0053_ VGND VGND VPWR VPWR RF0.regs\[25\]\[21\] sky130_fd_sc_hd__dfrtp_2
XFILLER_0_71_393 VGND VGND VPWR VPWR sky130_fd_sc_hd__fill_2
XFILLER_0_39_335 VGND VGND VPWR VPWR sky130_fd_sc_hd__fill_1
XFILLER_0_81_113 VPWR VGND VPWR VGND sky130_ef_sc_hd__decap_12
XFILLER_0_39_379 VGND VGND VPWR VPWR sky130_fd_sc_hd__fill_1
XTAP_TAPCELL_ROW_70_767 VGND VPWR sky130_fd_sc_hd__tapvpwrvgnd_1
XFILLER_0_54_349 VPWR VGND VPWR VGND sky130_ef_sc_hd__decap_12
XFILLER_0_22_257 VGND VGND VPWR VPWR sky130_fd_sc_hd__fill_1
XFILLER_0_10_419 VGND VGND VPWR VPWR sky130_fd_sc_hd__fill_1
XFILLER_0_38_58 VGND VGND VPWR VPWR sky130_fd_sc_hd__decap_4
X_3961_ _2052_ VGND VGND VPWR VPWR _0390_ sky130_fd_sc_hd__clkbuf_1
X_2912_ _1072_ VGND VGND VPWR VPWR _1073_ sky130_fd_sc_hd__clkbuf_4
X_3892_ _2013_ RF0.regs\[5\]\[4\] _1994_ VGND VGND VPWR VPWR _2014_ sky130_fd_sc_hd__mux2_1
XTAP_TAPCELL_ROW_33_458 VGND VPWR sky130_fd_sc_hd__tapvpwrvgnd_1
XFILLER_0_72_113 VGND VGND VPWR VPWR sky130_fd_sc_hd__fill_1
XFILLER_0_5_413 VPWR VGND VPWR VGND sky130_ef_sc_hd__decap_12
X_2843_ _1003_ VGND VGND VPWR VPWR _1004_ sky130_fd_sc_hd__clkbuf_4
XFILLER_0_45_349 VGND VGND VPWR VPWR sky130_fd_sc_hd__decap_8
X_2774_ _0698_ _0700_ net36 _0623_ VGND VGND VPWR VPWR _0935_ sky130_fd_sc_hd__a31o_1
XFILLER_0_72_168 VPWR VGND VPWR VGND sky130_ef_sc_hd__decap_12
X_4513_ _2277_ VGND VGND VPWR VPWR _0172_ sky130_fd_sc_hd__inv_2
Xhold114 RF0.regs\[0\]\[7\] VGND VGND VPWR VPWR net149 sky130_fd_sc_hd__dlygate4sd3_1
Xhold103 RF0.regs\[20\]\[8\] VGND VGND VPWR VPWR net138 sky130_fd_sc_hd__dlygate4sd3_1
Xhold125 RF0.regs\[30\]\[24\] VGND VGND VPWR VPWR net160 sky130_fd_sc_hd__dlygate4sd3_1
X_4444_ _2266_ VGND VGND VPWR VPWR _0114_ sky130_fd_sc_hd__inv_2
Xclkbuf_leaf_7_clk clknet_1_1__leaf_clk VGND VGND VPWR VPWR clknet_leaf_7_clk sky130_fd_sc_hd__clkbuf_8
X_4375_ _2256_ VGND VGND VPWR VPWR _0055_ sky130_fd_sc_hd__inv_2
X_3326_ RF0.regs\[10\]\[14\] _0630_ _0618_ RF0.regs\[25\]\[14\] VGND VGND VPWR VPWR
+ _1484_ sky130_fd_sc_hd__a22o_1
X_3257_ _0974_ _1414_ _0802_ _0800_ VGND VGND VPWR VPWR _1415_ sky130_fd_sc_hd__o211ai_2
X_3188_ _0713_ _1346_ VGND VGND VPWR VPWR _1347_ sky130_fd_sc_hd__nand2_1
XTAP_TAPCELL_ROW_49_591 VGND VPWR sky130_fd_sc_hd__tapvpwrvgnd_1
XFILLER_0_68_419 VGND VGND VPWR VPWR sky130_fd_sc_hd__fill_1
XFILLER_0_63_113 VPWR VGND VPWR VGND sky130_ef_sc_hd__decap_12
XFILLER_0_8_262 VGND VGND VPWR VPWR sky130_fd_sc_hd__decap_4
XFILLER_0_8_251 VGND VGND VPWR VPWR sky130_fd_sc_hd__fill_1
XTAP_TAPCELL_ROW_75_815 VGND VPWR sky130_fd_sc_hd__tapvpwrvgnd_1
XTAP_TAPCELL_ROW_30_428 VGND VPWR sky130_fd_sc_hd__tapvpwrvgnd_1
XFILLER_0_40_15 VPWR VGND VPWR VGND sky130_ef_sc_hd__decap_12
XFILLER_0_35_393 VGND VGND VPWR VPWR sky130_fd_sc_hd__decap_4
X_2490_ _0650_ VGND VGND VPWR VPWR _0651_ sky130_fd_sc_hd__buf_2
XFILLER_0_10_227 VGND VGND VPWR VPWR sky130_fd_sc_hd__fill_1
XFILLER_0_4_15 VGND VGND VPWR VPWR sky130_fd_sc_hd__decap_6
X_4160_ _2001_ RF0.regs\[25\]\[9\] _2156_ VGND VGND VPWR VPWR _2159_ sky130_fd_sc_hd__mux2_1
X_3111_ RF0.regs\[10\]\[26\] _0631_ _0619_ RF0.regs\[25\]\[26\] VGND VGND VPWR VPWR
+ _1271_ sky130_fd_sc_hd__a22o_1
X_4091_ _2122_ VGND VGND VPWR VPWR _0330_ sky130_fd_sc_hd__clkbuf_1
X_3042_ _0711_ _1101_ VGND VGND VPWR VPWR _1202_ sky130_fd_sc_hd__nor2_2
X_3944_ _2043_ VGND VGND VPWR VPWR _0398_ sky130_fd_sc_hd__clkbuf_1
XFILLER_0_45_102 VGND VGND VPWR VPWR sky130_fd_sc_hd__decap_3
XFILLER_0_73_433 VPWR VGND VPWR VGND sky130_ef_sc_hd__decap_12
X_3875_ _2001_ RF0.regs\[5\]\[9\] _1994_ VGND VGND VPWR VPWR _2002_ sky130_fd_sc_hd__mux2_1
X_2826_ _0764_ _0765_ VGND VGND VPWR VPWR _0987_ sky130_fd_sc_hd__or2_1
XFILLER_0_5_221 VGND VGND VPWR VPWR sky130_fd_sc_hd__decap_3
XFILLER_0_60_127 VPWR VGND VPWR VGND sky130_ef_sc_hd__decap_12
XFILLER_0_5_287 VPWR VGND VPWR VGND sky130_ef_sc_hd__decap_12
X_2757_ _0908_ _0909_ VGND VGND VPWR VPWR _0918_ sky130_fd_sc_hd__or2_1
XFILLER_0_76_3 VPWR VGND VPWR VGND sky130_ef_sc_hd__decap_12
X_2688_ _0657_ _0842_ _0727_ VGND VGND VPWR VPWR _0849_ sky130_fd_sc_hd__and3_1
X_4427_ _2264_ VGND VGND VPWR VPWR _0099_ sky130_fd_sc_hd__inv_2
X_4358_ _2253_ VGND VGND VPWR VPWR _2255_ sky130_fd_sc_hd__buf_4
X_3309_ _1097_ _1457_ _1456_ _1461_ _1466_ VGND VGND VPWR VPWR _1467_ sky130_fd_sc_hd__o32a_4
X_4289_ _1935_ _2229_ _2230_ _1085_ VGND VGND VPWR VPWR _2231_ sky130_fd_sc_hd__o211a_1
XFILLER_0_68_205 VGND VGND VPWR VPWR sky130_fd_sc_hd__decap_3
XTAP_TAPCELL_ROW_1_186 VGND VPWR sky130_fd_sc_hd__tapvpwrvgnd_1
XFILLER_0_49_452 VGND VGND VPWR VPWR sky130_fd_sc_hd__fill_2
XFILLER_0_36_135 VGND VGND VPWR VPWR sky130_fd_sc_hd__fill_1
XFILLER_0_64_477 VGND VGND VPWR VPWR sky130_fd_sc_hd__decap_4
XFILLER_0_51_105 VGND VGND VPWR VPWR sky130_fd_sc_hd__decap_6
XFILLER_0_10_29 VPWR VGND VPWR VGND sky130_ef_sc_hd__decap_12
XTAP_TAPCELL_ROW_9_253 VGND VPWR sky130_fd_sc_hd__tapvpwrvgnd_1
XFILLER_0_35_15 VPWR VGND VPWR VGND sky130_ef_sc_hd__decap_12
XTAP_TAPCELL_ROW_43_542 VGND VPWR sky130_fd_sc_hd__tapvpwrvgnd_1
XFILLER_0_27_113 VPWR VGND VPWR VGND sky130_ef_sc_hd__decap_12
XFILLER_0_55_455 VGND VGND VPWR VPWR sky130_fd_sc_hd__fill_1
XFILLER_0_15_319 VPWR VGND VPWR VGND sky130_ef_sc_hd__decap_12
X_3660_ _1810_ _1421_ _1449_ VGND VGND VPWR VPWR _1811_ sky130_fd_sc_hd__o21a_1
Xclkload23 clknet_leaf_13_clk VGND VGND VPWR VPWR clkload23/Y sky130_fd_sc_hd__inv_8
Xclkload12 clknet_leaf_25_clk VGND VGND VPWR VPWR clkload12/X sky130_fd_sc_hd__clkbuf_4
X_3591_ _1741_ VGND VGND VPWR VPWR _1742_ sky130_fd_sc_hd__inv_2
X_2611_ _0682_ _0753_ _0771_ VGND VGND VPWR VPWR _0772_ sky130_fd_sc_hd__o21a_1
XFILLER_0_70_469 VGND VGND VPWR VPWR sky130_fd_sc_hd__decap_6
X_2542_ RF0.regs\[15\]\[11\] _0662_ _0667_ RF0.regs\[5\]\[11\] VGND VGND VPWR VPWR
+ _0703_ sky130_fd_sc_hd__a22o_1
X_4212_ _2186_ VGND VGND VPWR VPWR _0273_ sky130_fd_sc_hd__clkbuf_1
X_2473_ _0633_ VGND VGND VPWR VPWR _0634_ sky130_fd_sc_hd__buf_2
XFILLER_0_76_77 VGND VGND VPWR VPWR sky130_fd_sc_hd__decap_4
X_4143_ _1972_ RF0.regs\[25\]\[17\] _2145_ VGND VGND VPWR VPWR _2150_ sky130_fd_sc_hd__mux2_1
X_4074_ _2113_ VGND VGND VPWR VPWR _0338_ sky130_fd_sc_hd__clkbuf_1
X_3025_ _1184_ _0970_ _1044_ VGND VGND VPWR VPWR _1185_ sky130_fd_sc_hd__mux2_1
XFILLER_0_65_219 VGND VGND VPWR VPWR sky130_fd_sc_hd__decap_4
XFILLER_0_46_477 VGND VGND VPWR VPWR sky130_fd_sc_hd__decap_4
X_3927_ _2034_ VGND VGND VPWR VPWR _0406_ sky130_fd_sc_hd__clkbuf_1
Xclkload6 clknet_leaf_18_clk VGND VGND VPWR VPWR clkload6/Y sky130_fd_sc_hd__inv_8
X_3858_ _1988_ RF0.regs\[5\]\[13\] _1957_ VGND VGND VPWR VPWR _1989_ sky130_fd_sc_hd__mux2_1
X_3789_ _1098_ _1760_ _1761_ _1926_ _1929_ VGND VGND VPWR VPWR _1930_ sky130_fd_sc_hd__o32a_1
X_2809_ RF0.regs\[10\]\[21\] _0969_ _0674_ RF0.regs\[25\]\[21\] VGND VGND VPWR VPWR
+ _0970_ sky130_fd_sc_hd__a22o_1
XFILLER_0_14_385 VGND VGND VPWR VPWR sky130_fd_sc_hd__fill_1
XTAP_TAPCELL_ROW_6_223 VGND VPWR sky130_fd_sc_hd__tapvpwrvgnd_1
XFILLER_0_56_208 VGND VGND VPWR VPWR sky130_fd_sc_hd__fill_1
XFILLER_0_21_28 VGND VGND VPWR VPWR sky130_fd_sc_hd__decap_4
XFILLER_0_37_455 VGND VGND VPWR VPWR sky130_fd_sc_hd__fill_1
XFILLER_0_37_477 VGND VGND VPWR VPWR sky130_fd_sc_hd__decap_4
XTAP_TAPCELL_ROW_40_512 VGND VPWR sky130_fd_sc_hd__tapvpwrvgnd_1
XFILLER_0_64_296 VPWR VGND VPWR VGND sky130_ef_sc_hd__decap_12
XFILLER_0_52_447 VGND VGND VPWR VPWR sky130_fd_sc_hd__decap_4
XFILLER_0_20_377 VGND VGND VPWR VPWR sky130_fd_sc_hd__decap_3
XFILLER_0_1_27 VPWR VGND VPWR VGND sky130_ef_sc_hd__decap_12
X_4830_ clknet_leaf_25_clk _0480_ _0224_ VGND VGND VPWR VPWR IM0.addr\[0\] sky130_fd_sc_hd__dfrtp_4
XFILLER_0_28_411 VGND VGND VPWR VPWR sky130_fd_sc_hd__decap_8
XFILLER_0_55_252 VGND VGND VPWR VPWR sky130_fd_sc_hd__decap_8
X_4761_ clknet_leaf_12_clk _0411_ _0155_ VGND VGND VPWR VPWR RF0.regs\[10\]\[27\]
+ sky130_fd_sc_hd__dfrtp_1
XFILLER_0_28_477 VGND VGND VPWR VPWR sky130_fd_sc_hd__decap_4
X_4692_ clknet_leaf_9_clk _0342_ _0086_ VGND VGND VPWR VPWR RF0.regs\[20\]\[22\] sky130_fd_sc_hd__dfrtp_1
X_3712_ _1344_ _1382_ VGND VGND VPWR VPWR _1855_ sky130_fd_sc_hd__nor2_1
X_3643_ _1734_ _1793_ VGND VGND VPWR VPWR _1794_ sky130_fd_sc_hd__nand2_1
X_3574_ _1315_ _1321_ _1037_ VGND VGND VPWR VPWR _1726_ sky130_fd_sc_hd__mux2_1
X_2525_ _0659_ _0685_ VGND VGND VPWR VPWR _0686_ sky130_fd_sc_hd__nand2_1
XFILLER_0_11_399 VGND VGND VPWR VPWR sky130_fd_sc_hd__decap_3
X_2456_ _0616_ VGND VGND VPWR VPWR _0617_ sky130_fd_sc_hd__buf_4
Xhold18 _0552_ VGND VGND VPWR VPWR net53 sky130_fd_sc_hd__dlygate4sd3_1
Xhold29 _0544_ VGND VGND VPWR VPWR net64 sky130_fd_sc_hd__dlygate4sd3_1
XTAP_TAPCELL_ROW_3_204 VGND VPWR sky130_fd_sc_hd__tapvpwrvgnd_1
XFILLER_0_39_3 VPWR VGND VPWR VGND sky130_ef_sc_hd__decap_12
X_2387_ _0568_ VGND VGND VPWR VPWR _0468_ sky130_fd_sc_hd__clkbuf_1
X_4126_ _1857_ RF0.regs\[25\]\[25\] _2134_ VGND VGND VPWR VPWR _2141_ sky130_fd_sc_hd__mux2_1
X_4057_ _2104_ VGND VGND VPWR VPWR _0346_ sky130_fd_sc_hd__clkbuf_1
X_3008_ RF0.regs\[10\]\[13\] _0969_ _0931_ RF0.regs\[25\]\[13\] VGND VGND VPWR VPWR
+ _1168_ sky130_fd_sc_hd__a22o_1
XTAP_TAPCELL_ROW_54_637 VGND VPWR sky130_fd_sc_hd__tapvpwrvgnd_1
XFILLER_0_78_388 VPWR VGND VPWR VGND sky130_ef_sc_hd__decap_12
XFILLER_0_19_411 VPWR VGND VPWR VGND sky130_ef_sc_hd__decap_12
XTAP_TAPCELL_ROW_17_317 VGND VPWR sky130_fd_sc_hd__tapvpwrvgnd_1
XFILLER_0_32_27 VGND VGND VPWR VPWR sky130_fd_sc_hd__fill_1
XFILLER_0_12_119 VGND VGND VPWR VPWR sky130_fd_sc_hd__fill_1
XFILLER_0_20_141 VGND VGND VPWR VPWR sky130_fd_sc_hd__decap_3
X_2310_ IM0.addr\[29\] _0532_ IM0.addr\[30\] VGND VGND VPWR VPWR _0534_ sky130_fd_sc_hd__a21o_1
X_3290_ _1001_ _1446_ _1447_ VGND VGND VPWR VPWR _1448_ sky130_fd_sc_hd__o21ai_1
XFILLER_0_57_57 VGND VGND VPWR VPWR sky130_fd_sc_hd__fill_2
XTAP_TAPCELL_ROW_51_607 VGND VPWR sky130_fd_sc_hd__tapvpwrvgnd_1
XFILLER_0_7_113 VGND VGND VPWR VPWR sky130_fd_sc_hd__decap_4
X_4813_ clknet_leaf_16_clk _0463_ _0207_ VGND VGND VPWR VPWR RF0.regs\[0\]\[15\] sky130_fd_sc_hd__dfrtp_1
XFILLER_0_22_60 VGND VGND VPWR VPWR sky130_fd_sc_hd__decap_3
X_4744_ clknet_leaf_2_clk _0394_ _0138_ VGND VGND VPWR VPWR RF0.regs\[10\]\[10\] sky130_fd_sc_hd__dfrtp_4
XFILLER_0_43_200 VPWR VGND VPWR VGND sky130_ef_sc_hd__decap_12
XFILLER_0_28_296 VGND VGND VPWR VPWR sky130_fd_sc_hd__fill_2
X_4675_ clknet_leaf_19_clk _0325_ _0069_ VGND VGND VPWR VPWR RF0.regs\[20\]\[5\] sky130_fd_sc_hd__dfrtp_1
XFILLER_0_43_277 VGND VGND VPWR VPWR sky130_fd_sc_hd__decap_3
X_3626_ _1097_ net47 _1772_ _1774_ _1776_ VGND VGND VPWR VPWR _1777_ sky130_fd_sc_hd__o32a_1
Xoutput19 net19 VGND VGND VPWR VPWR Result[26] sky130_fd_sc_hd__clkbuf_4
XFILLER_0_3_396 VPWR VGND VPWR VGND sky130_ef_sc_hd__decap_12
X_3557_ RF0.regs\[0\]\[12\] _0603_ _1537_ VGND VGND VPWR VPWR _1710_ sky130_fd_sc_hd__o21a_1
X_2508_ _0668_ VGND VGND VPWR VPWR _0669_ sky130_fd_sc_hd__buf_4
X_3488_ _1641_ _1643_ VGND VGND VPWR VPWR _1644_ sky130_fd_sc_hd__or2_1
X_2439_ _0599_ VGND VGND VPWR VPWR _0600_ sky130_fd_sc_hd__buf_6
X_4109_ _2131_ VGND VGND VPWR VPWR _0321_ sky130_fd_sc_hd__clkbuf_1
XFILLER_0_78_141 VGND VGND VPWR VPWR sky130_fd_sc_hd__decap_4
XFILLER_0_81_317 VGND VGND VPWR VPWR sky130_fd_sc_hd__fill_1
XTAP_TAPCELL_ROW_22_364 VGND VPWR sky130_fd_sc_hd__tapvpwrvgnd_1
XFILLER_0_34_233 VPWR VGND VPWR VGND sky130_ef_sc_hd__decap_12
XFILLER_0_6_190 VGND VGND VPWR VPWR sky130_fd_sc_hd__decap_6
XFILLER_0_27_16 VPWR VGND VPWR VGND sky130_ef_sc_hd__decap_12
XFILLER_0_43_15 VPWR VGND VPWR VGND sky130_ef_sc_hd__decap_12
XFILLER_0_69_130 VGND VGND VPWR VPWR sky130_fd_sc_hd__fill_1
XFILLER_0_69_163 VGND VGND VPWR VPWR sky130_fd_sc_hd__fill_2
XFILLER_0_69_196 VPWR VGND VPWR VGND sky130_ef_sc_hd__decap_12
XTAP_TAPCELL_ROW_73_798 VGND VPWR sky130_fd_sc_hd__tapvpwrvgnd_1
XFILLER_0_72_328 VGND VGND VPWR VPWR sky130_fd_sc_hd__decap_8
X_2790_ _0944_ _0945_ VGND VGND VPWR VPWR _0951_ sky130_fd_sc_hd__nand2_1
XFILLER_0_7_15 VGND VGND VPWR VPWR sky130_fd_sc_hd__decap_4
XFILLER_0_25_288 VGND VGND VPWR VPWR sky130_fd_sc_hd__decap_4
X_4460_ _2246_ VGND VGND VPWR VPWR _2269_ sky130_fd_sc_hd__clkbuf_2
X_4391_ _2259_ VGND VGND VPWR VPWR _0068_ sky130_fd_sc_hd__inv_2
X_3411_ _0817_ _1559_ net50 VGND VGND VPWR VPWR _1568_ sky130_fd_sc_hd__o21a_1
XFILLER_0_21_461 VPWR VGND VPWR VGND sky130_ef_sc_hd__decap_12
X_3342_ RF0.regs\[0\]\[15\] _0603_ _1499_ VGND VGND VPWR VPWR _1500_ sky130_fd_sc_hd__o21a_1
X_3273_ _1430_ VGND VGND VPWR VPWR _1431_ sky130_fd_sc_hd__inv_2
XTAP_TAPCELL_ROW_64_721 VGND VPWR sky130_fd_sc_hd__tapvpwrvgnd_1
XFILLER_0_75_111 VGND VGND VPWR VPWR sky130_fd_sc_hd__fill_1
XTAP_TAPCELL_ROW_36_478 VGND VPWR sky130_fd_sc_hd__tapvpwrvgnd_1
XFILLER_0_8_400 VGND VGND VPWR VPWR sky130_fd_sc_hd__fill_2
XFILLER_0_8_433 VPWR VGND VPWR VGND sky130_ef_sc_hd__decap_12
X_2988_ RF0.regs\[0\]\[30\] _0605_ _1094_ VGND VGND VPWR VPWR _1148_ sky130_fd_sc_hd__o21ai_1
XFILLER_0_8_477 VGND VGND VPWR VPWR sky130_fd_sc_hd__decap_4
X_4727_ clknet_leaf_9_clk _0377_ _0121_ VGND VGND VPWR VPWR RF0.regs\[15\]\[25\] sky130_fd_sc_hd__dfrtp_1
XFILLER_0_71_361 VGND VGND VPWR VPWR sky130_fd_sc_hd__fill_1
X_4658_ clknet_leaf_9_clk _0308_ _0052_ VGND VGND VPWR VPWR RF0.regs\[25\]\[20\] sky130_fd_sc_hd__dfrtp_4
X_3609_ _1757_ _1759_ _0954_ VGND VGND VPWR VPWR _1760_ sky130_fd_sc_hd__nor3_4
X_4589_ _2246_ VGND VGND VPWR VPWR _2286_ sky130_fd_sc_hd__buf_4
XFILLER_0_79_461 VPWR VGND VPWR VGND sky130_ef_sc_hd__decap_12
XFILLER_0_66_100 VGND VGND VPWR VPWR sky130_fd_sc_hd__fill_1
XPHY_EDGE_ROW_11_Right_11 VGND VGND VPWR VPWR sky130_fd_sc_hd__decap_3
XTAP_TAPCELL_ROW_70_768 VGND VPWR sky130_fd_sc_hd__tapvpwrvgnd_1
XFILLER_0_81_125 VPWR VGND VPWR VGND sky130_ef_sc_hd__decap_12
XFILLER_0_47_380 VGND VGND VPWR VPWR sky130_fd_sc_hd__fill_2
XFILLER_0_47_391 VGND VGND VPWR VPWR sky130_fd_sc_hd__fill_1
XFILLER_0_81_169 VGND VGND VPWR VPWR sky130_fd_sc_hd__decap_8
XPHY_EDGE_ROW_57_Left_139 VGND VGND VPWR VPWR sky130_fd_sc_hd__decap_3
XFILLER_0_62_383 VGND VGND VPWR VPWR sky130_fd_sc_hd__decap_3
XPHY_EDGE_ROW_20_Right_20 VGND VGND VPWR VPWR sky130_fd_sc_hd__decap_3
XFILLER_0_38_15 VPWR VGND VPWR VGND sky130_ef_sc_hd__decap_12
XFILLER_0_38_37 VGND VGND VPWR VPWR sky130_fd_sc_hd__decap_3
XTAP_TAPCELL_ROW_78_835 VGND VPWR sky130_fd_sc_hd__tapvpwrvgnd_1
XPHY_EDGE_ROW_66_Left_148 VGND VGND VPWR VPWR sky130_fd_sc_hd__decap_3
XFILLER_0_54_69 VPWR VGND VPWR VGND sky130_ef_sc_hd__decap_12
X_3960_ _2009_ RF0.regs\[10\]\[6\] _2046_ VGND VGND VPWR VPWR _2052_ sky130_fd_sc_hd__mux2_1
XFILLER_0_57_111 VGND VGND VPWR VPWR sky130_fd_sc_hd__fill_1
X_2911_ _0716_ _0718_ VGND VGND VPWR VPWR _1072_ sky130_fd_sc_hd__and2_1
X_3891_ _1640_ _1689_ VGND VGND VPWR VPWR _2013_ sky130_fd_sc_hd__xor2_2
XTAP_TAPCELL_ROW_33_459 VGND VPWR sky130_fd_sc_hd__tapvpwrvgnd_1
XFILLER_0_45_306 VGND VGND VPWR VPWR sky130_fd_sc_hd__fill_2
XFILLER_0_57_155 VGND VGND VPWR VPWR sky130_fd_sc_hd__fill_1
XPHY_EDGE_ROW_75_Left_157 VGND VGND VPWR VPWR sky130_fd_sc_hd__decap_3
X_2842_ _0722_ VGND VGND VPWR VPWR _1003_ sky130_fd_sc_hd__clkbuf_4
XFILLER_0_70_79 VGND VGND VPWR VPWR sky130_fd_sc_hd__decap_4
XFILLER_0_5_425 VPWR VGND VPWR VGND sky130_ef_sc_hd__decap_12
X_2773_ _0700_ net36 _0698_ VGND VGND VPWR VPWR _0934_ sky130_fd_sc_hd__a21oi_1
X_4512_ _2277_ VGND VGND VPWR VPWR _0171_ sky130_fd_sc_hd__inv_2
Xhold104 RF0.regs\[20\]\[30\] VGND VGND VPWR VPWR net139 sky130_fd_sc_hd__dlygate4sd3_1
XFILLER_0_79_55 VGND VGND VPWR VPWR sky130_fd_sc_hd__fill_1
Xhold126 RF0.regs\[30\]\[5\] VGND VGND VPWR VPWR net161 sky130_fd_sc_hd__dlygate4sd3_1
Xhold115 RF0.regs\[30\]\[19\] VGND VGND VPWR VPWR net150 sky130_fd_sc_hd__dlygate4sd3_1
X_4443_ _2263_ VGND VGND VPWR VPWR _2266_ sky130_fd_sc_hd__buf_4
XFILLER_0_0_141 VPWR VGND VPWR VGND sky130_ef_sc_hd__decap_12
X_4374_ _2256_ VGND VGND VPWR VPWR _0054_ sky130_fd_sc_hd__inv_2
X_3325_ _1422_ _1450_ _1482_ VGND VGND VPWR VPWR _1483_ sky130_fd_sc_hd__or3_4
X_3256_ _0968_ _0973_ _1413_ VGND VGND VPWR VPWR _1414_ sky130_fd_sc_hd__a21oi_2
X_3187_ _1061_ _1163_ VGND VGND VPWR VPWR _1346_ sky130_fd_sc_hd__nand2_1
XFILLER_0_21_3 VGND VGND VPWR VPWR sky130_fd_sc_hd__fill_2
XTAP_TAPCELL_ROW_49_592 VGND VPWR sky130_fd_sc_hd__tapvpwrvgnd_1
XFILLER_0_76_475 VGND VGND VPWR VPWR sky130_fd_sc_hd__fill_1
XFILLER_0_48_155 VPWR VGND VPWR VGND sky130_ef_sc_hd__decap_12
XFILLER_0_63_125 VGND VGND VPWR VPWR sky130_fd_sc_hd__fill_2
XFILLER_0_8_296 VPWR VGND VPWR VGND sky130_ef_sc_hd__decap_12
XFILLER_0_63_169 VPWR VGND VPWR VGND sky130_ef_sc_hd__decap_12
XFILLER_0_44_361 VGND VGND VPWR VPWR sky130_fd_sc_hd__decap_3
XFILLER_0_71_180 VGND VGND VPWR VPWR sky130_fd_sc_hd__fill_1
XTAP_TAPCELL_ROW_75_816 VGND VPWR sky130_fd_sc_hd__tapvpwrvgnd_1
XFILLER_0_67_420 VGND VGND VPWR VPWR sky130_fd_sc_hd__fill_2
XFILLER_0_39_166 VGND VGND VPWR VPWR sky130_fd_sc_hd__fill_2
XFILLER_0_40_27 VGND VGND VPWR VPWR sky130_fd_sc_hd__fill_1
XTAP_TAPCELL_ROW_30_429 VGND VPWR sky130_fd_sc_hd__tapvpwrvgnd_1
XFILLER_0_42_309 VPWR VGND VPWR VGND sky130_ef_sc_hd__decap_12
XFILLER_0_62_180 VGND VGND VPWR VPWR sky130_fd_sc_hd__decap_8
X_3110_ _1241_ _1269_ VGND VGND VPWR VPWR _1270_ sky130_fd_sc_hd__nand2_1
X_4090_ net133 _1997_ _2120_ VGND VGND VPWR VPWR _2122_ sky130_fd_sc_hd__mux2_1
XFILLER_0_65_57 VGND VGND VPWR VPWR sky130_fd_sc_hd__decap_8
X_3041_ _1194_ _1196_ _1200_ VGND VGND VPWR VPWR _1201_ sky130_fd_sc_hd__o21a_1
X_3943_ _1984_ RF0.regs\[10\]\[14\] _2035_ VGND VGND VPWR VPWR _2043_ sky130_fd_sc_hd__mux2_1
XFILLER_0_58_464 VPWR VGND VPWR VGND sky130_ef_sc_hd__decap_12
XFILLER_0_73_445 VGND VGND VPWR VPWR sky130_fd_sc_hd__decap_3
X_3874_ _1999_ _2000_ VGND VGND VPWR VPWR _2001_ sky130_fd_sc_hd__xnor2_2
X_2825_ _0775_ _0983_ _0985_ VGND VGND VPWR VPWR _0986_ sky130_fd_sc_hd__a21oi_2
XFILLER_0_26_350 VPWR VGND VPWR VGND sky130_ef_sc_hd__decap_12
XFILLER_0_45_169 VGND VGND VPWR VPWR sky130_fd_sc_hd__fill_1
X_2756_ _0914_ _0916_ VGND VGND VPWR VPWR _0917_ sky130_fd_sc_hd__nand2_1
XFILLER_0_41_320 VGND VGND VPWR VPWR sky130_fd_sc_hd__fill_1
XFILLER_0_60_139 VGND VGND VPWR VPWR sky130_fd_sc_hd__fill_1
XFILLER_0_5_299 VGND VGND VPWR VPWR sky130_fd_sc_hd__decap_4
X_2687_ _0842_ _0727_ VGND VGND VPWR VPWR _0848_ sky130_fd_sc_hd__nor2_1
XFILLER_0_1_461 VPWR VGND VPWR VGND sky130_ef_sc_hd__decap_12
X_4426_ _2264_ VGND VGND VPWR VPWR _0098_ sky130_fd_sc_hd__inv_2
XFILLER_0_69_3 VPWR VGND VPWR VGND sky130_ef_sc_hd__decap_12
X_4357_ _2254_ VGND VGND VPWR VPWR _0039_ sky130_fd_sc_hd__inv_2
X_3308_ _1134_ _1462_ _1465_ _1084_ VGND VGND VPWR VPWR _1466_ sky130_fd_sc_hd__o211a_1
X_4288_ _1935_ _1122_ VGND VGND VPWR VPWR _2230_ sky130_fd_sc_hd__nand2_1
X_3239_ _1047_ _1293_ VGND VGND VPWR VPWR _1398_ sky130_fd_sc_hd__nor2_1
XTAP_TAPCELL_ROW_1_187 VGND VPWR sky130_fd_sc_hd__tapvpwrvgnd_1
XFILLER_0_49_431 VGND VGND VPWR VPWR sky130_fd_sc_hd__decap_8
XTAP_TAPCELL_ROW_80_852 VGND VPWR sky130_fd_sc_hd__tapvpwrvgnd_1
XFILLER_0_76_250 VGND VGND VPWR VPWR sky130_fd_sc_hd__fill_2
XFILLER_0_64_445 VGND VGND VPWR VPWR sky130_fd_sc_hd__decap_8
XFILLER_0_24_309 VGND VGND VPWR VPWR sky130_fd_sc_hd__decap_8
XTAP_TAPCELL_ROW_9_254 VGND VPWR sky130_fd_sc_hd__tapvpwrvgnd_1
XFILLER_0_35_27 VGND VGND VPWR VPWR sky130_fd_sc_hd__decap_6
XTAP_TAPCELL_ROW_43_543 VGND VPWR sky130_fd_sc_hd__tapvpwrvgnd_1
XFILLER_0_51_15 VPWR VGND VPWR VGND sky130_ef_sc_hd__decap_12
XFILLER_0_67_261 VGND VGND VPWR VPWR sky130_fd_sc_hd__decap_6
XFILLER_0_27_125 VPWR VGND VPWR VGND sky130_ef_sc_hd__decap_12
XFILLER_0_27_169 VPWR VGND VPWR VGND sky130_ef_sc_hd__decap_12
XFILLER_0_42_106 VPWR VGND VPWR VGND sky130_ef_sc_hd__decap_12
Xclkload24 clknet_leaf_14_clk VGND VGND VPWR VPWR clkload24/Y sky130_fd_sc_hd__inv_8
X_2610_ _0716_ VGND VGND VPWR VPWR _0771_ sky130_fd_sc_hd__clkbuf_4
Xclkload13 clknet_leaf_26_clk VGND VGND VPWR VPWR clkload13/Y sky130_fd_sc_hd__bufinv_16
X_3590_ _1436_ _1430_ _1074_ VGND VGND VPWR VPWR _1741_ sky130_fd_sc_hd__mux2_1
XFILLER_0_23_353 VGND VGND VPWR VPWR sky130_fd_sc_hd__decap_3
X_2541_ _0656_ _0701_ VGND VGND VPWR VPWR _0702_ sky130_fd_sc_hd__and2_1
X_2472_ _0632_ VGND VGND VPWR VPWR _0633_ sky130_fd_sc_hd__clkbuf_4
X_4211_ _1972_ net158 _2181_ VGND VGND VPWR VPWR _2186_ sky130_fd_sc_hd__mux2_1
XFILLER_0_76_89 VGND VGND VPWR VPWR sky130_fd_sc_hd__fill_1
X_4142_ _2149_ VGND VGND VPWR VPWR _0306_ sky130_fd_sc_hd__clkbuf_1
X_4073_ net126 _1968_ _2109_ VGND VGND VPWR VPWR _2113_ sky130_fd_sc_hd__mux2_1
X_3024_ RF0.regs\[10\]\[22\] _1090_ _0674_ RF0.regs\[25\]\[22\] VGND VGND VPWR VPWR
+ _1184_ sky130_fd_sc_hd__a22o_1
XFILLER_0_18_125 VPWR VGND VPWR VGND sky130_ef_sc_hd__decap_12
X_3926_ _1953_ RF0.regs\[10\]\[22\] _2024_ VGND VGND VPWR VPWR _2034_ sky130_fd_sc_hd__mux2_1
Xclkload7 clknet_leaf_20_clk VGND VGND VPWR VPWR clkload7/Y sky130_fd_sc_hd__inv_8
X_3857_ _1986_ _1987_ VGND VGND VPWR VPWR _1988_ sky130_fd_sc_hd__xnor2_2
XFILLER_0_26_180 VPWR VGND VPWR VGND sky130_ef_sc_hd__decap_12
X_2808_ _0828_ VGND VGND VPWR VPWR _0969_ sky130_fd_sc_hd__buf_2
X_3788_ _1136_ _1927_ _1928_ _1084_ VGND VGND VPWR VPWR _1929_ sky130_fd_sc_hd__o211a_1
X_2739_ _0623_ _0738_ VGND VGND VPWR VPWR _0900_ sky130_fd_sc_hd__or2_1
XTAP_TAPCELL_ROW_6_224 VGND VPWR sky130_fd_sc_hd__tapvpwrvgnd_1
X_4409_ _2261_ VGND VGND VPWR VPWR _0084_ sky130_fd_sc_hd__inv_2
XTAP_TAPCELL_ROW_57_657 VGND VPWR sky130_fd_sc_hd__tapvpwrvgnd_1
XFILLER_0_49_261 VGND VGND VPWR VPWR sky130_fd_sc_hd__fill_2
XTAP_TAPCELL_ROW_40_513 VGND VPWR sky130_fd_sc_hd__tapvpwrvgnd_1
XFILLER_0_64_231 VGND VGND VPWR VPWR sky130_fd_sc_hd__decap_6
XFILLER_0_24_139 VGND VGND VPWR VPWR sky130_fd_sc_hd__fill_1
XFILLER_0_32_194 VGND VGND VPWR VPWR sky130_fd_sc_hd__fill_2
XFILLER_0_20_389 VGND VGND VPWR VPWR sky130_fd_sc_hd__fill_2
XFILLER_0_46_15 VPWR VGND VPWR VGND sky130_ef_sc_hd__decap_12
XFILLER_0_1_39 VGND VGND VPWR VPWR sky130_fd_sc_hd__decap_6
XFILLER_0_7_317 VGND VGND VPWR VPWR sky130_fd_sc_hd__fill_1
X_4760_ clknet_leaf_13_clk _0410_ _0154_ VGND VGND VPWR VPWR RF0.regs\[10\]\[26\]
+ sky130_fd_sc_hd__dfrtp_1
X_4691_ clknet_leaf_9_clk _0341_ _0085_ VGND VGND VPWR VPWR RF0.regs\[20\]\[21\] sky130_fd_sc_hd__dfrtp_1
X_3711_ _1854_ VGND VGND VPWR VPWR _0442_ sky130_fd_sc_hd__clkbuf_1
XFILLER_0_11_51 VGND VGND VPWR VPWR sky130_fd_sc_hd__fill_2
X_3642_ _0652_ _1719_ _1736_ _1792_ VGND VGND VPWR VPWR _1793_ sky130_fd_sc_hd__a31o_1
XFILLER_0_55_297 VGND VGND VPWR VPWR sky130_fd_sc_hd__fill_1
XFILLER_0_70_223 VGND VGND VPWR VPWR sky130_fd_sc_hd__decap_3
XTAP_TAPCELL_ROW_11_270 VGND VPWR sky130_fd_sc_hd__tapvpwrvgnd_1
X_3573_ RF0.regs\[0\]\[17\] _0604_ _1717_ net9 VGND VGND VPWR VPWR _1725_ sky130_fd_sc_hd__o22ai_2
XPHY_EDGE_ROW_49_Right_49 VGND VGND VPWR VPWR sky130_fd_sc_hd__decap_3
XFILLER_0_51_481 VGND VGND VPWR VPWR sky130_fd_sc_hd__fill_1
X_2524_ RF0.regs\[15\]\[25\] _0664_ _0674_ RF0.regs\[5\]\[25\] VGND VGND VPWR VPWR
+ _0685_ sky130_fd_sc_hd__a22o_1
X_2455_ _0615_ VGND VGND VPWR VPWR _0616_ sky130_fd_sc_hd__clkbuf_8
Xhold19 IM0.addr\[7\] VGND VGND VPWR VPWR net54 sky130_fd_sc_hd__dlygate4sd3_1
X_2386_ net108 VGND VGND VPWR VPWR _0568_ sky130_fd_sc_hd__clkbuf_1
XTAP_TAPCELL_ROW_3_205 VGND VPWR sky130_fd_sc_hd__tapvpwrvgnd_1
X_4125_ _2140_ VGND VGND VPWR VPWR _0314_ sky130_fd_sc_hd__clkbuf_1
XPHY_EDGE_ROW_58_Right_58 VGND VGND VPWR VPWR sky130_fd_sc_hd__decap_3
X_4056_ net134 _1853_ _2098_ VGND VGND VPWR VPWR _2104_ sky130_fd_sc_hd__mux2_1
X_3007_ RF0.regs\[10\]\[14\] _0969_ _0673_ RF0.regs\[25\]\[14\] VGND VGND VPWR VPWR
+ _1167_ sky130_fd_sc_hd__a22o_1
XFILLER_0_38_209 VGND VGND VPWR VPWR sky130_fd_sc_hd__decap_8
XTAP_TAPCELL_ROW_54_638 VGND VPWR sky130_fd_sc_hd__tapvpwrvgnd_1
XFILLER_0_46_231 VGND VGND VPWR VPWR sky130_fd_sc_hd__decap_4
X_3909_ _2025_ VGND VGND VPWR VPWR _0415_ sky130_fd_sc_hd__clkbuf_1
XFILLER_0_46_253 VPWR VGND VPWR VGND sky130_ef_sc_hd__decap_12
XPHY_EDGE_ROW_67_Right_67 VGND VGND VPWR VPWR sky130_fd_sc_hd__decap_3
XFILLER_0_14_172 VGND VGND VPWR VPWR sky130_fd_sc_hd__fill_1
XFILLER_0_14_194 VGND VGND VPWR VPWR sky130_fd_sc_hd__fill_2
XPHY_EDGE_ROW_76_Right_76 VGND VGND VPWR VPWR sky130_fd_sc_hd__decap_3
XFILLER_0_16_29 VGND VGND VPWR VPWR sky130_fd_sc_hd__fill_1
XTAP_TAPCELL_ROW_17_318 VGND VPWR sky130_fd_sc_hd__tapvpwrvgnd_1
XFILLER_0_69_378 VGND VGND VPWR VPWR sky130_fd_sc_hd__decap_8
XFILLER_0_33_481 VGND VGND VPWR VPWR sky130_fd_sc_hd__fill_1
XFILLER_0_20_197 VGND VGND VPWR VPWR sky130_fd_sc_hd__fill_2
XFILLER_0_73_57 VPWR VGND VPWR VGND sky130_ef_sc_hd__decap_12
XFILLER_0_75_337 VGND VGND VPWR VPWR sky130_fd_sc_hd__decap_6
XFILLER_0_75_315 VGND VGND VPWR VPWR sky130_fd_sc_hd__fill_1
XTAP_TAPCELL_ROW_51_608 VGND VPWR sky130_fd_sc_hd__tapvpwrvgnd_1
XFILLER_0_28_231 VPWR VGND VPWR VGND sky130_ef_sc_hd__decap_12
X_4812_ clknet_leaf_3_clk _0462_ _0206_ VGND VGND VPWR VPWR RF0.regs\[0\]\[14\] sky130_fd_sc_hd__dfrtp_1
X_4743_ clknet_leaf_2_clk _0393_ _0137_ VGND VGND VPWR VPWR RF0.regs\[10\]\[9\] sky130_fd_sc_hd__dfrtp_4
XFILLER_0_28_253 VGND VGND VPWR VPWR sky130_fd_sc_hd__decap_4
XFILLER_0_22_83 VGND VGND VPWR VPWR sky130_fd_sc_hd__fill_1
XFILLER_0_43_212 VPWR VGND VPWR VGND sky130_ef_sc_hd__decap_12
X_4674_ clknet_leaf_23_clk _0324_ _0068_ VGND VGND VPWR VPWR RF0.regs\[20\]\[4\] sky130_fd_sc_hd__dfrtp_1
X_3625_ _1134_ _1289_ _1775_ _1084_ VGND VGND VPWR VPWR _1776_ sky130_fd_sc_hd__o211a_1
X_3556_ _1506_ _1508_ VGND VGND VPWR VPWR _1709_ sky130_fd_sc_hd__or2_1
X_2507_ _0667_ VGND VGND VPWR VPWR _0668_ sky130_fd_sc_hd__buf_4
X_3487_ RF0.regs\[20\]\[3\] _0623_ _0828_ RF0.regs\[25\]\[3\] _1642_ VGND VGND VPWR
+ VPWR _1643_ sky130_fd_sc_hd__a221o_1
XFILLER_0_51_3 VPWR VGND VPWR VGND sky130_ef_sc_hd__decap_12
X_2438_ _0596_ _0598_ _0597_ _0595_ VGND VGND VPWR VPWR _0599_ sky130_fd_sc_hd__nor4_4
X_2369_ _0559_ VGND VGND VPWR VPWR _0477_ sky130_fd_sc_hd__clkbuf_1
X_4108_ net125 _2020_ _2097_ VGND VGND VPWR VPWR _2131_ sky130_fd_sc_hd__mux2_1
X_4039_ _2093_ VGND VGND VPWR VPWR _0353_ sky130_fd_sc_hd__clkbuf_1
XTAP_TAPCELL_ROW_22_365 VGND VPWR sky130_fd_sc_hd__tapvpwrvgnd_1
XFILLER_0_34_245 VGND VGND VPWR VPWR sky130_fd_sc_hd__decap_6
XFILLER_0_15_481 VGND VGND VPWR VPWR sky130_fd_sc_hd__fill_1
XFILLER_0_22_418 VGND VGND VPWR VPWR sky130_fd_sc_hd__fill_2
XFILLER_0_27_28 VGND VGND VPWR VPWR sky130_fd_sc_hd__decap_8
XFILLER_0_43_27 VPWR VGND VPWR VGND sky130_ef_sc_hd__decap_12
XTAP_TAPCELL_ROW_73_799 VGND VPWR sky130_fd_sc_hd__tapvpwrvgnd_1
XFILLER_0_57_337 VGND VGND VPWR VPWR sky130_fd_sc_hd__decap_4
XFILLER_0_25_212 VPWR VGND VPWR VGND sky130_ef_sc_hd__decap_12
XFILLER_0_80_362 VGND VGND VPWR VPWR sky130_fd_sc_hd__fill_2
XFILLER_0_80_340 VGND VGND VPWR VPWR sky130_fd_sc_hd__fill_2
XFILLER_0_4_139 VGND VGND VPWR VPWR sky130_fd_sc_hd__fill_1
XFILLER_0_25_245 VGND VGND VPWR VPWR sky130_fd_sc_hd__decap_6
XFILLER_0_0_312 VPWR VGND VPWR VGND sky130_ef_sc_hd__decap_12
XFILLER_0_0_301 VGND VGND VPWR VPWR sky130_fd_sc_hd__fill_1
X_4390_ _2259_ VGND VGND VPWR VPWR _0067_ sky130_fd_sc_hd__inv_2
X_3410_ _0817_ net50 _1559_ VGND VGND VPWR VPWR _1567_ sky130_fd_sc_hd__nor3_1
XFILLER_0_21_473 VGND VGND VPWR VPWR sky130_fd_sc_hd__decap_8
X_3341_ _1496_ _1498_ VGND VGND VPWR VPWR _1499_ sky130_fd_sc_hd__or2_1
XFILLER_0_0_378 VGND VGND VPWR VPWR sky130_fd_sc_hd__decap_3
X_3272_ _0851_ _1022_ _1004_ VGND VGND VPWR VPWR _1430_ sky130_fd_sc_hd__mux2_1
XTAP_TAPCELL_ROW_64_722 VGND VPWR sky130_fd_sc_hd__tapvpwrvgnd_1
XFILLER_0_48_315 VGND VGND VPWR VPWR sky130_fd_sc_hd__fill_1
XTAP_TAPCELL_ROW_36_479 VGND VPWR sky130_fd_sc_hd__tapvpwrvgnd_1
XFILLER_0_8_445 VPWR VGND VPWR VGND sky130_ef_sc_hd__decap_12
X_2987_ _1146_ VGND VGND VPWR VPWR _1147_ sky130_fd_sc_hd__inv_2
X_4726_ clknet_leaf_9_clk _0376_ _0120_ VGND VGND VPWR VPWR RF0.regs\[15\]\[24\] sky130_fd_sc_hd__dfrtp_1
X_4657_ clknet_leaf_10_clk _0307_ _0051_ VGND VGND VPWR VPWR RF0.regs\[25\]\[19\]
+ sky130_fd_sc_hd__dfrtp_4
X_3608_ _0952_ _1758_ _0938_ VGND VGND VPWR VPWR _1759_ sky130_fd_sc_hd__a21oi_4
X_4588_ _2285_ VGND VGND VPWR VPWR _0239_ sky130_fd_sc_hd__inv_2
X_3539_ _1588_ _1598_ _1602_ _1692_ VGND VGND VPWR VPWR _1693_ sky130_fd_sc_hd__a22oi_4
XTAP_TAPCELL_ROW_27_402 VGND VPWR sky130_fd_sc_hd__tapvpwrvgnd_1
XFILLER_0_79_473 VGND VGND VPWR VPWR sky130_fd_sc_hd__decap_8
XFILLER_0_39_359 VGND VGND VPWR VPWR sky130_fd_sc_hd__fill_1
XFILLER_0_66_178 VGND VGND VPWR VPWR sky130_fd_sc_hd__fill_2
XTAP_TAPCELL_ROW_70_769 VGND VPWR sky130_fd_sc_hd__tapvpwrvgnd_1
XFILLER_0_81_137 VGND VGND VPWR VPWR sky130_fd_sc_hd__decap_3
XFILLER_0_38_27 VGND VGND VPWR VPWR sky130_fd_sc_hd__fill_1
XTAP_TAPCELL_ROW_78_836 VGND VPWR sky130_fd_sc_hd__tapvpwrvgnd_1
XFILLER_0_54_15 VPWR VGND VPWR VGND sky130_ef_sc_hd__decap_12
X_2910_ _1066_ _1070_ _1040_ VGND VGND VPWR VPWR _1071_ sky130_fd_sc_hd__o21ai_1
X_3890_ _2012_ VGND VGND VPWR VPWR _0421_ sky130_fd_sc_hd__clkbuf_1
X_2841_ _1001_ VGND VGND VPWR VPWR _1002_ sky130_fd_sc_hd__clkbuf_4
XFILLER_0_5_437 VGND VGND VPWR VPWR sky130_fd_sc_hd__decap_8
X_2772_ _0930_ _0932_ VGND VGND VPWR VPWR _0933_ sky130_fd_sc_hd__xnor2_1
XFILLER_0_53_351 VGND VGND VPWR VPWR sky130_fd_sc_hd__decap_8
X_4511_ _2277_ VGND VGND VPWR VPWR _0170_ sky130_fd_sc_hd__inv_2
Xhold116 RF0.regs\[30\]\[28\] VGND VGND VPWR VPWR net151 sky130_fd_sc_hd__dlygate4sd3_1
Xhold105 RF0.regs\[30\]\[11\] VGND VGND VPWR VPWR net140 sky130_fd_sc_hd__dlygate4sd3_1
X_4442_ _2265_ VGND VGND VPWR VPWR _0113_ sky130_fd_sc_hd__inv_2
Xhold127 RF0.regs\[20\]\[14\] VGND VGND VPWR VPWR net162 sky130_fd_sc_hd__dlygate4sd3_1
XFILLER_0_0_153 VPWR VGND VPWR VGND sky130_ef_sc_hd__decap_12
XFILLER_0_0_131 VGND VGND VPWR VPWR sky130_fd_sc_hd__decap_8
XFILLER_0_21_281 VGND VGND VPWR VPWR sky130_fd_sc_hd__decap_4
X_4373_ _2256_ VGND VGND VPWR VPWR _0053_ sky130_fd_sc_hd__inv_2
XFILLER_0_0_197 VPWR VGND VPWR VGND sky130_ef_sc_hd__decap_12
X_3324_ _1481_ _1469_ _1468_ VGND VGND VPWR VPWR _1482_ sky130_fd_sc_hd__or3_4
X_3255_ _1412_ _0974_ VGND VGND VPWR VPWR _1413_ sky130_fd_sc_hd__or2_1
XFILLER_0_28_82 VGND VGND VPWR VPWR sky130_fd_sc_hd__fill_2
X_3186_ _1157_ _1162_ _1019_ VGND VGND VPWR VPWR _1345_ sky130_fd_sc_hd__mux2_1
XFILLER_0_14_3 VGND VGND VPWR VPWR sky130_fd_sc_hd__fill_1
XTAP_TAPCELL_ROW_49_593 VGND VPWR sky130_fd_sc_hd__tapvpwrvgnd_1
XFILLER_0_76_421 VPWR VGND VPWR VGND sky130_ef_sc_hd__decap_12
XPHY_EDGE_ROW_14_Left_96 VGND VGND VPWR VPWR sky130_fd_sc_hd__decap_3
XFILLER_0_48_167 VGND VGND VPWR VPWR sky130_fd_sc_hd__decap_4
XFILLER_0_8_253 VGND VGND VPWR VPWR sky130_fd_sc_hd__fill_2
X_4709_ clknet_leaf_22_clk _0359_ _0103_ VGND VGND VPWR VPWR RF0.regs\[15\]\[7\] sky130_fd_sc_hd__dfrtp_1
XFILLER_0_4_481 VGND VGND VPWR VPWR sky130_fd_sc_hd__fill_1
XTAP_TAPCELL_ROW_75_817 VGND VPWR sky130_fd_sc_hd__tapvpwrvgnd_1
XFILLER_0_50_343 VGND VGND VPWR VPWR sky130_fd_sc_hd__decap_6
XFILLER_0_49_15 VPWR VGND VPWR VGND sky130_ef_sc_hd__decap_12
XFILLER_0_50_365 VPWR VGND VPWR VGND sky130_ef_sc_hd__decap_12
X_3040_ _1197_ _1199_ VGND VGND VPWR VPWR _1200_ sky130_fd_sc_hd__or2_1
XFILLER_0_81_57 VPWR VGND VPWR VGND sky130_ef_sc_hd__decap_12
XTAP_TAPCELL_ROW_46_563 VGND VPWR sky130_fd_sc_hd__tapvpwrvgnd_1
XFILLER_0_18_307 VGND VGND VPWR VPWR sky130_fd_sc_hd__fill_1
X_3942_ _2042_ VGND VGND VPWR VPWR _0399_ sky130_fd_sc_hd__clkbuf_1
X_3873_ _1584_ _1693_ _1583_ VGND VGND VPWR VPWR _2000_ sky130_fd_sc_hd__o21a_1
X_2824_ _0770_ _0984_ VGND VGND VPWR VPWR _0985_ sky130_fd_sc_hd__or2_1
XFILLER_0_5_245 VGND VGND VPWR VPWR sky130_fd_sc_hd__fill_2
XFILLER_0_26_362 VGND VGND VPWR VPWR sky130_fd_sc_hd__fill_2
XFILLER_0_30_61 VGND VGND VPWR VPWR sky130_fd_sc_hd__decap_3
X_2755_ _0912_ _0915_ VGND VGND VPWR VPWR _0916_ sky130_fd_sc_hd__or2b_1
X_2686_ _0846_ VGND VGND VPWR VPWR _0847_ sky130_fd_sc_hd__inv_2
X_4425_ _2264_ VGND VGND VPWR VPWR _0097_ sky130_fd_sc_hd__inv_2
X_4356_ _2254_ VGND VGND VPWR VPWR _0038_ sky130_fd_sc_hd__inv_2
XFILLER_0_1_473 VGND VGND VPWR VPWR sky130_fd_sc_hd__decap_8
X_3307_ _1034_ _1464_ VGND VGND VPWR VPWR _1465_ sky130_fd_sc_hd__nand2_1
X_4287_ _1282_ _1287_ _1059_ VGND VGND VPWR VPWR _2229_ sky130_fd_sc_hd__mux2_1
X_3238_ _1296_ _1118_ _1048_ VGND VGND VPWR VPWR _1397_ sky130_fd_sc_hd__mux2_1
X_3169_ _1031_ VGND VGND VPWR VPWR _1328_ sky130_fd_sc_hd__inv_2
XFILLER_0_68_229 VGND VGND VPWR VPWR sky130_fd_sc_hd__fill_1
XTAP_TAPCELL_ROW_1_188 VGND VPWR sky130_fd_sc_hd__tapvpwrvgnd_1
XTAP_TAPCELL_ROW_80_853 VGND VPWR sky130_fd_sc_hd__tapvpwrvgnd_1
XFILLER_0_51_129 VGND VGND VPWR VPWR sky130_fd_sc_hd__decap_8
XFILLER_0_44_192 VGND VGND VPWR VPWR sky130_fd_sc_hd__decap_4
XFILLER_0_32_365 VGND VGND VPWR VPWR sky130_fd_sc_hd__decap_4
XTAP_TAPCELL_ROW_9_255 VGND VPWR sky130_fd_sc_hd__tapvpwrvgnd_1
XFILLER_0_3_3 VPWR VGND VPWR VGND sky130_ef_sc_hd__decap_12
XFILLER_0_59_207 VGND VGND VPWR VPWR sky130_fd_sc_hd__decap_4
XFILLER_0_51_27 VPWR VGND VPWR VGND sky130_ef_sc_hd__decap_12
XTAP_TAPCELL_ROW_43_544 VGND VPWR sky130_fd_sc_hd__tapvpwrvgnd_1
XFILLER_0_67_284 VPWR VGND VPWR VGND sky130_ef_sc_hd__decap_12
XFILLER_0_27_137 VPWR VGND VPWR VGND sky130_ef_sc_hd__decap_12
XFILLER_0_42_118 VPWR VGND VPWR VGND sky130_ef_sc_hd__decap_12
Xclkload14 clknet_leaf_27_clk VGND VGND VPWR VPWR clkload14/Y sky130_fd_sc_hd__clkinv_4
Xclkload25 clknet_leaf_16_clk VGND VGND VPWR VPWR clkload25/Y sky130_fd_sc_hd__inv_12
X_2540_ RF0.regs\[15\]\[12\] _0662_ _0667_ RF0.regs\[5\]\[12\] VGND VGND VPWR VPWR
+ _0701_ sky130_fd_sc_hd__a22o_1
X_2471_ _0514_ IM0.addr\[2\] VGND VGND VPWR VPWR _0632_ sky130_fd_sc_hd__nor2b_2
XFILLER_0_50_173 VPWR VGND VPWR VGND sky130_ef_sc_hd__decap_12
X_4210_ _2185_ VGND VGND VPWR VPWR _0274_ sky130_fd_sc_hd__clkbuf_1
X_4141_ _1968_ RF0.regs\[25\]\[18\] _2145_ VGND VGND VPWR VPWR _2149_ sky130_fd_sc_hd__mux2_1
X_4072_ _2112_ VGND VGND VPWR VPWR _0339_ sky130_fd_sc_hd__clkbuf_1
X_3023_ _1181_ _1182_ _1044_ VGND VGND VPWR VPWR _1183_ sky130_fd_sc_hd__mux2_1
XFILLER_0_25_61 VGND VGND VPWR VPWR sky130_fd_sc_hd__fill_1
XFILLER_0_18_115 VGND VGND VPWR VPWR sky130_fd_sc_hd__fill_1
X_3925_ _2033_ VGND VGND VPWR VPWR _0407_ sky130_fd_sc_hd__clkbuf_1
XFILLER_0_73_232 VGND VGND VPWR VPWR sky130_fd_sc_hd__fill_2
XFILLER_0_18_137 VGND VGND VPWR VPWR sky130_fd_sc_hd__decap_3
XFILLER_0_46_446 VPWR VGND VPWR VGND sky130_ef_sc_hd__decap_12
Xclkload8 clknet_leaf_21_clk VGND VGND VPWR VPWR clkload8/Y sky130_fd_sc_hd__clkinvlp_4
X_3856_ _1711_ _1977_ _1543_ VGND VGND VPWR VPWR _1987_ sky130_fd_sc_hd__o21a_1
XFILLER_0_41_93 VGND VGND VPWR VPWR sky130_fd_sc_hd__decap_3
XFILLER_0_61_405 VPWR VGND VPWR VGND sky130_ef_sc_hd__decap_12
XFILLER_0_81_3 VPWR VGND VPWR VGND sky130_ef_sc_hd__decap_12
XFILLER_0_26_192 VGND VGND VPWR VPWR sky130_fd_sc_hd__decap_4
X_3787_ _1136_ _1899_ VGND VGND VPWR VPWR _1928_ sky130_fd_sc_hd__nand2_1
X_2807_ _0957_ _0948_ _0961_ _0967_ VGND VGND VPWR VPWR _0968_ sky130_fd_sc_hd__a211o_1
XFILLER_0_61_449 VGND VGND VPWR VPWR sky130_fd_sc_hd__decap_6
XFILLER_0_14_365 VPWR VGND VPWR VGND sky130_ef_sc_hd__decap_12
XFILLER_0_14_343 VPWR VGND VPWR VGND sky130_ef_sc_hd__decap_12
XFILLER_0_41_140 VGND VGND VPWR VPWR sky130_fd_sc_hd__decap_3
X_2738_ net33 _0898_ VGND VGND VPWR VPWR _0899_ sky130_fd_sc_hd__xnor2_1
XFILLER_0_41_184 VGND VGND VPWR VPWR sky130_fd_sc_hd__fill_1
X_2669_ _0827_ _0829_ VGND VGND VPWR VPWR _0830_ sky130_fd_sc_hd__nand2_1
X_4408_ _2261_ VGND VGND VPWR VPWR _0083_ sky130_fd_sc_hd__inv_2
XTAP_TAPCELL_ROW_6_225 VGND VPWR sky130_fd_sc_hd__tapvpwrvgnd_1
XFILLER_0_5_60 VGND VGND VPWR VPWR sky130_fd_sc_hd__fill_1
X_4339_ _2251_ VGND VGND VPWR VPWR _0024_ sky130_fd_sc_hd__inv_2
XTAP_TAPCELL_ROW_57_658 VGND VPWR sky130_fd_sc_hd__tapvpwrvgnd_1
XFILLER_0_49_251 VGND VGND VPWR VPWR sky130_fd_sc_hd__fill_2
XFILLER_0_37_402 VPWR VGND VPWR VGND sky130_ef_sc_hd__decap_12
XTAP_TAPCELL_ROW_40_514 VGND VPWR sky130_fd_sc_hd__tapvpwrvgnd_1
XFILLER_0_46_27 VGND VGND VPWR VPWR sky130_fd_sc_hd__fill_1
XFILLER_0_62_15 VPWR VGND VPWR VGND sky130_ef_sc_hd__decap_12
X_3710_ _1853_ RF0.regs\[5\]\[26\] _1835_ VGND VGND VPWR VPWR _1854_ sky130_fd_sc_hd__mux2_1
XFILLER_0_43_405 VGND VGND VPWR VPWR sky130_fd_sc_hd__fill_1
X_4690_ clknet_leaf_4_clk _0340_ _0084_ VGND VGND VPWR VPWR RF0.regs\[20\]\[20\] sky130_fd_sc_hd__dfrtp_1
X_3641_ _1203_ _1790_ _1791_ _1000_ VGND VGND VPWR VPWR _1792_ sky130_fd_sc_hd__o22a_1
XFILLER_0_43_449 VPWR VGND VPWR VGND sky130_ef_sc_hd__decap_12
XTAP_TAPCELL_ROW_11_271 VGND VPWR sky130_fd_sc_hd__tapvpwrvgnd_1
X_3572_ _0652_ _1720_ _1721_ _1722_ _1724_ VGND VGND VPWR VPWR net9 sky130_fd_sc_hd__a32o_1
XFILLER_0_70_257 VGND VGND VPWR VPWR sky130_fd_sc_hd__decap_4
XFILLER_0_11_302 VGND VGND VPWR VPWR sky130_fd_sc_hd__decap_8
X_2523_ _0659_ _0683_ VGND VGND VPWR VPWR _0684_ sky130_fd_sc_hd__and2_1
XFILLER_0_11_335 VGND VGND VPWR VPWR sky130_fd_sc_hd__fill_1
X_2454_ _0614_ VGND VGND VPWR VPWR _0615_ sky130_fd_sc_hd__clkbuf_8
X_2385_ _0567_ VGND VGND VPWR VPWR _0469_ sky130_fd_sc_hd__clkbuf_1
X_4124_ _1853_ RF0.regs\[25\]\[26\] _2134_ VGND VGND VPWR VPWR _2140_ sky130_fd_sc_hd__mux2_1
X_4055_ _2103_ VGND VGND VPWR VPWR _0347_ sky130_fd_sc_hd__clkbuf_1
X_3006_ _1154_ _1161_ _1165_ VGND VGND VPWR VPWR _1166_ sky130_fd_sc_hd__a21oi_2
XTAP_TAPCELL_ROW_54_639 VGND VPWR sky130_fd_sc_hd__tapvpwrvgnd_1
XFILLER_0_46_221 VGND VGND VPWR VPWR sky130_fd_sc_hd__decap_4
XFILLER_0_52_70 VGND VGND VPWR VPWR sky130_fd_sc_hd__decap_8
X_3908_ _1833_ RF0.regs\[10\]\[31\] _2024_ VGND VGND VPWR VPWR _2025_ sky130_fd_sc_hd__mux2_4
XFILLER_0_46_265 VPWR VGND VPWR VGND sky130_ef_sc_hd__decap_12
X_3839_ _1973_ VGND VGND VPWR VPWR _0433_ sky130_fd_sc_hd__clkbuf_1
XFILLER_0_61_279 VGND VGND VPWR VPWR sky130_fd_sc_hd__fill_1
XFILLER_0_14_151 VGND VGND VPWR VPWR sky130_fd_sc_hd__fill_1
XFILLER_0_16_19 VGND VGND VPWR VPWR sky130_fd_sc_hd__decap_8
XFILLER_0_69_324 VGND VGND VPWR VPWR sky130_fd_sc_hd__fill_1
XTAP_TAPCELL_ROW_17_319 VGND VPWR sky130_fd_sc_hd__tapvpwrvgnd_1
XFILLER_0_32_29 VPWR VGND VPWR VGND sky130_ef_sc_hd__decap_12
XTAP_TAPCELL_ROW_25_385 VGND VPWR sky130_fd_sc_hd__tapvpwrvgnd_1
XFILLER_0_52_213 VPWR VGND VPWR VGND sky130_ef_sc_hd__decap_12
XPHY_EDGE_ROW_2_Left_84 VGND VGND VPWR VPWR sky130_fd_sc_hd__decap_3
XFILLER_0_57_15 VPWR VGND VPWR VGND sky130_ef_sc_hd__decap_12
XFILLER_0_73_69 VGND VGND VPWR VPWR sky130_fd_sc_hd__decap_6
XFILLER_0_75_327 VGND VGND VPWR VPWR sky130_fd_sc_hd__decap_8
X_4811_ clknet_leaf_21_clk _0461_ _0205_ VGND VGND VPWR VPWR RF0.regs\[0\]\[13\] sky130_fd_sc_hd__dfrtp_1
XTAP_TAPCELL_ROW_51_609 VGND VPWR sky130_fd_sc_hd__tapvpwrvgnd_1
X_4742_ clknet_leaf_22_clk _0392_ _0136_ VGND VGND VPWR VPWR RF0.regs\[10\]\[8\] sky130_fd_sc_hd__dfrtp_1
XFILLER_0_28_243 VGND VGND VPWR VPWR sky130_fd_sc_hd__fill_2
XFILLER_0_16_449 VPWR VGND VPWR VGND sky130_ef_sc_hd__decap_12
XFILLER_0_7_159 VGND VGND VPWR VPWR sky130_fd_sc_hd__fill_1
X_4673_ clknet_leaf_19_clk _0323_ _0067_ VGND VGND VPWR VPWR RF0.regs\[20\]\[3\] sky130_fd_sc_hd__dfrtp_1
X_3624_ _1134_ _1299_ VGND VGND VPWR VPWR _1775_ sky130_fd_sc_hd__nand2_1
XFILLER_0_11_132 VGND VGND VPWR VPWR sky130_fd_sc_hd__fill_2
X_3555_ _1703_ _1704_ _1705_ _1707_ VGND VGND VPWR VPWR _1708_ sky130_fd_sc_hd__or4bb_1
XFILLER_0_11_154 VGND VGND VPWR VPWR sky130_fd_sc_hd__decap_8
X_2506_ _0666_ VGND VGND VPWR VPWR _0667_ sky130_fd_sc_hd__clkbuf_4
X_3486_ RF0.regs\[15\]\[3\] _0608_ _0628_ RF0.regs\[10\]\[3\] VGND VGND VPWR VPWR
+ _1642_ sky130_fd_sc_hd__a22o_1
X_2437_ IM0.addr\[31\] IM0.addr\[30\] IM0.addr\[29\] IM0.addr\[26\] VGND VGND VPWR
+ VPWR _0598_ sky130_fd_sc_hd__or4_4
XFILLER_0_44_3 VPWR VGND VPWR VGND sky130_ef_sc_hd__decap_12
X_2368_ net90 VGND VGND VPWR VPWR _0559_ sky130_fd_sc_hd__clkbuf_1
X_2299_ IM0.addr\[16\] IM0.addr\[15\] _0523_ VGND VGND VPWR VPWR _0524_ sky130_fd_sc_hd__and3_1
X_4107_ _2130_ VGND VGND VPWR VPWR _0322_ sky130_fd_sc_hd__clkbuf_1
XTAP_TAPCELL_ROW_67_742 VGND VPWR sky130_fd_sc_hd__tapvpwrvgnd_1
X_4038_ _2020_ RF0.regs\[15\]\[1\] _2059_ VGND VGND VPWR VPWR _2093_ sky130_fd_sc_hd__mux2_1
XFILLER_0_2_61 VGND VGND VPWR VPWR sky130_fd_sc_hd__decap_3
XFILLER_0_19_298 VGND VGND VPWR VPWR sky130_fd_sc_hd__decap_6
XTAP_TAPCELL_ROW_22_366 VGND VPWR sky130_fd_sc_hd__tapvpwrvgnd_1
XFILLER_0_34_213 VGND VGND VPWR VPWR sky130_fd_sc_hd__fill_1
XFILLER_0_22_408 VGND VGND VPWR VPWR sky130_fd_sc_hd__fill_1
XFILLER_0_43_39 VPWR VGND VPWR VGND sky130_ef_sc_hd__decap_12
XFILLER_0_57_327 VGND VGND VPWR VPWR sky130_fd_sc_hd__decap_4
XFILLER_0_0_324 VPWR VGND VPWR VGND sky130_ef_sc_hd__decap_12
X_3340_ RF0.regs\[20\]\[15\] _0625_ _1091_ RF0.regs\[25\]\[15\] _1497_ VGND VGND VPWR
+ VPWR _1498_ sky130_fd_sc_hd__a221o_1
X_3271_ _0860_ _0880_ _1003_ VGND VGND VPWR VPWR _1429_ sky130_fd_sc_hd__mux2_1
XTAP_TAPCELL_ROW_64_723 VGND VPWR sky130_fd_sc_hd__tapvpwrvgnd_1
XFILLER_0_63_319 VGND VGND VPWR VPWR sky130_fd_sc_hd__decap_8
XFILLER_0_8_457 VPWR VGND VPWR VGND sky130_ef_sc_hd__decap_12
X_2986_ _1099_ _0992_ _1100_ _1101_ _1145_ VGND VGND VPWR VPWR _1146_ sky130_fd_sc_hd__o32a_1
XFILLER_0_16_257 VGND VGND VPWR VPWR sky130_fd_sc_hd__fill_1
X_4725_ clknet_leaf_9_clk _0375_ _0119_ VGND VGND VPWR VPWR RF0.regs\[15\]\[23\] sky130_fd_sc_hd__dfrtp_1
X_4656_ clknet_leaf_10_clk _0306_ _0050_ VGND VGND VPWR VPWR RF0.regs\[25\]\[18\]
+ sky130_fd_sc_hd__dfrtp_2
XFILLER_0_71_385 VGND VGND VPWR VPWR sky130_fd_sc_hd__decap_6
X_4587_ _2285_ VGND VGND VPWR VPWR _0238_ sky130_fd_sc_hd__inv_2
X_3607_ _0920_ _0927_ _0942_ _0946_ VGND VGND VPWR VPWR _1758_ sky130_fd_sc_hd__a211o_4
X_3538_ _1606_ _1609_ _1612_ _1691_ VGND VGND VPWR VPWR _1692_ sky130_fd_sc_hd__o22ai_4
XFILLER_0_3_184 VGND VGND VPWR VPWR sky130_fd_sc_hd__fill_1
X_3469_ _1621_ _1622_ _1624_ VGND VGND VPWR VPWR _1625_ sky130_fd_sc_hd__mux2_4
XFILLER_0_79_441 VGND VGND VPWR VPWR sky130_fd_sc_hd__decap_6
XTAP_TAPCELL_ROW_27_403 VGND VPWR sky130_fd_sc_hd__tapvpwrvgnd_1
XFILLER_0_62_352 VGND VGND VPWR VPWR sky130_fd_sc_hd__fill_2
XTAP_TAPCELL_ROW_78_837 VGND VPWR sky130_fd_sc_hd__tapvpwrvgnd_1
XFILLER_0_54_27 VGND VGND VPWR VPWR sky130_fd_sc_hd__fill_1
XFILLER_0_57_113 VPWR VGND VPWR VGND sky130_ef_sc_hd__decap_12
XFILLER_0_70_15 VPWR VGND VPWR VGND sky130_ef_sc_hd__decap_12
X_2840_ _1000_ VGND VGND VPWR VPWR _1001_ sky130_fd_sc_hd__buf_2
XFILLER_0_72_138 VGND VGND VPWR VPWR sky130_fd_sc_hd__fill_2
X_2771_ RF0.regs\[10\]\[19\] _0616_ _0931_ RF0.regs\[25\]\[19\] VGND VGND VPWR VPWR
+ _0932_ sky130_fd_sc_hd__a22o_1
XFILLER_0_72_149 VPWR VGND VPWR VGND sky130_ef_sc_hd__decap_12
XFILLER_0_5_449 VPWR VGND VPWR VGND sky130_ef_sc_hd__decap_12
X_4510_ _2277_ VGND VGND VPWR VPWR _0169_ sky130_fd_sc_hd__inv_2
XFILLER_0_53_374 VGND VGND VPWR VPWR sky130_fd_sc_hd__decap_8
XFILLER_0_79_57 VPWR VGND VPWR VGND sky130_ef_sc_hd__decap_12
Xhold117 RF0.regs\[30\]\[4\] VGND VGND VPWR VPWR net152 sky130_fd_sc_hd__dlygate4sd3_1
Xhold106 RF0.regs\[20\]\[6\] VGND VGND VPWR VPWR net141 sky130_fd_sc_hd__dlygate4sd3_1
X_4441_ _2265_ VGND VGND VPWR VPWR _0112_ sky130_fd_sc_hd__inv_2
XPHY_EDGE_ROW_9_Right_9 VGND VGND VPWR VPWR sky130_fd_sc_hd__decap_3
XFILLER_0_0_110 VGND VGND VPWR VPWR sky130_fd_sc_hd__fill_2
Xhold128 RF0.regs\[30\]\[23\] VGND VGND VPWR VPWR net163 sky130_fd_sc_hd__dlygate4sd3_1
X_4372_ _2256_ VGND VGND VPWR VPWR _0052_ sky130_fd_sc_hd__inv_2
XFILLER_0_0_165 VGND VGND VPWR VPWR sky130_fd_sc_hd__decap_3
X_3323_ _1474_ _1479_ _1480_ VGND VGND VPWR VPWR _1481_ sky130_fd_sc_hd__o21ai_2
X_3254_ _0795_ _0796_ VGND VGND VPWR VPWR _1412_ sky130_fd_sc_hd__nor2_1
XFILLER_0_28_94 VGND VGND VPWR VPWR sky130_fd_sc_hd__fill_2
X_3185_ RF0.regs\[0\]\[25\] _0605_ _1308_ _1343_ VGND VGND VPWR VPWR _1344_ sky130_fd_sc_hd__a2bb2o_1
XFILLER_0_76_400 VPWR VGND VPWR VGND sky130_ef_sc_hd__decap_12
XTAP_TAPCELL_ROW_49_594 VGND VPWR sky130_fd_sc_hd__tapvpwrvgnd_1
XFILLER_0_76_433 VPWR VGND VPWR VGND sky130_ef_sc_hd__decap_12
XFILLER_0_48_113 VGND VGND VPWR VPWR sky130_fd_sc_hd__fill_1
XFILLER_0_76_477 VGND VGND VPWR VPWR sky130_fd_sc_hd__decap_4
XFILLER_0_8_243 VGND VGND VPWR VPWR sky130_fd_sc_hd__decap_8
XTAP_TAPCELL_ROW_32_450 VGND VPWR sky130_fd_sc_hd__tapvpwrvgnd_1
XFILLER_0_44_330 VGND VGND VPWR VPWR sky130_fd_sc_hd__fill_1
X_2969_ _1080_ _0769_ _1128_ _1049_ VGND VGND VPWR VPWR _1129_ sky130_fd_sc_hd__a211o_1
X_4708_ clknet_leaf_25_clk _0358_ _0102_ VGND VGND VPWR VPWR RF0.regs\[15\]\[6\] sky130_fd_sc_hd__dfrtp_1
XFILLER_0_44_352 VGND VGND VPWR VPWR sky130_fd_sc_hd__decap_3
X_4639_ clknet_leaf_20_clk _0289_ _0033_ VGND VGND VPWR VPWR RF0.regs\[25\]\[1\] sky130_fd_sc_hd__dfrtp_2
XFILLER_0_8_93 VGND VGND VPWR VPWR sky130_fd_sc_hd__decap_8
XFILLER_0_8_82 VGND VGND VPWR VPWR sky130_fd_sc_hd__fill_2
XFILLER_0_39_113 VGND VGND VPWR VPWR sky130_fd_sc_hd__fill_1
XFILLER_0_54_149 VGND VGND VPWR VPWR sky130_fd_sc_hd__fill_2
XFILLER_0_2_408 VPWR VGND VPWR VGND sky130_ef_sc_hd__decap_12
XFILLER_0_49_27 VPWR VGND VPWR VGND sky130_ef_sc_hd__decap_12
XFILLER_0_50_377 VPWR VGND VPWR VGND sky130_ef_sc_hd__decap_12
XFILLER_0_50_399 VGND VGND VPWR VPWR sky130_fd_sc_hd__decap_4
XFILLER_0_4_29 VGND VGND VPWR VPWR sky130_fd_sc_hd__fill_1
XFILLER_0_65_15 VPWR VGND VPWR VGND sky130_ef_sc_hd__decap_12
XFILLER_0_81_69 VPWR VGND VPWR VGND sky130_ef_sc_hd__decap_12
XTAP_TAPCELL_ROW_46_564 VGND VPWR sky130_fd_sc_hd__tapvpwrvgnd_1
X_3941_ _1981_ RF0.regs\[10\]\[15\] _2035_ VGND VGND VPWR VPWR _2042_ sky130_fd_sc_hd__mux2_1
XFILLER_0_58_455 VGND VGND VPWR VPWR sky130_fd_sc_hd__decap_3
XFILLER_0_58_477 VGND VGND VPWR VPWR sky130_fd_sc_hd__decap_4
XFILLER_0_14_85 VGND VGND VPWR VPWR sky130_fd_sc_hd__decap_3
X_3872_ _1705_ _1702_ VGND VGND VPWR VPWR _1999_ sky130_fd_sc_hd__and2_1
X_2823_ _0768_ _0769_ VGND VGND VPWR VPWR _0984_ sky130_fd_sc_hd__and2_1
X_2754_ RF0.regs\[10\]\[12\] _0828_ _0671_ RF0.regs\[25\]\[12\] VGND VGND VPWR VPWR
+ _0915_ sky130_fd_sc_hd__a22o_1
XFILLER_0_5_279 VGND VGND VPWR VPWR sky130_fd_sc_hd__fill_1
XFILLER_0_53_193 VGND VGND VPWR VPWR sky130_fd_sc_hd__fill_1
X_2685_ _0844_ _0845_ VGND VGND VPWR VPWR _0846_ sky130_fd_sc_hd__or2_1
X_4424_ _2264_ VGND VGND VPWR VPWR _0096_ sky130_fd_sc_hd__inv_2
XFILLER_0_1_441 VGND VGND VPWR VPWR sky130_fd_sc_hd__decap_6
X_4355_ _2254_ VGND VGND VPWR VPWR _0037_ sky130_fd_sc_hd__inv_2
XFILLER_0_39_71 VGND VGND VPWR VPWR sky130_fd_sc_hd__fill_2
XFILLER_0_39_93 VGND VGND VPWR VPWR sky130_fd_sc_hd__decap_4
X_3306_ _1463_ _1327_ _1057_ VGND VGND VPWR VPWR _1464_ sky130_fd_sc_hd__mux2_1
X_4286_ _1467_ VGND VGND VPWR VPWR net14 sky130_fd_sc_hd__inv_2
X_3237_ _1395_ VGND VGND VPWR VPWR _1396_ sky130_fd_sc_hd__inv_2
X_3168_ _1074_ _1015_ _1326_ VGND VGND VPWR VPWR _1327_ sky130_fd_sc_hd__o21ai_1
X_3099_ _1252_ _1258_ _1135_ VGND VGND VPWR VPWR _1259_ sky130_fd_sc_hd__mux2_1
XFILLER_0_49_422 VGND VGND VPWR VPWR sky130_fd_sc_hd__decap_6
XTAP_TAPCELL_ROW_80_854 VGND VPWR sky130_fd_sc_hd__tapvpwrvgnd_1
XFILLER_0_17_374 VGND VGND VPWR VPWR sky130_fd_sc_hd__decap_4
XFILLER_0_51_119 VGND VGND VPWR VPWR sky130_fd_sc_hd__fill_1
XTAP_TAPCELL_ROW_9_256 VGND VPWR sky130_fd_sc_hd__tapvpwrvgnd_1
XFILLER_0_59_219 VGND VGND VPWR VPWR sky130_fd_sc_hd__decap_4
XTAP_TAPCELL_ROW_43_545 VGND VPWR sky130_fd_sc_hd__tapvpwrvgnd_1
XFILLER_0_51_39 VPWR VGND VPWR VGND sky130_ef_sc_hd__decap_12
XFILLER_0_55_403 VGND VGND VPWR VPWR sky130_fd_sc_hd__fill_2
XFILLER_0_27_149 VPWR VGND VPWR VGND sky130_ef_sc_hd__decap_12
XFILLER_0_55_447 VGND VGND VPWR VPWR sky130_fd_sc_hd__fill_1
XFILLER_0_67_296 VGND VGND VPWR VPWR sky130_fd_sc_hd__decap_8
XFILLER_0_23_333 VGND VGND VPWR VPWR sky130_fd_sc_hd__decap_3
Xclkload15 clknet_leaf_4_clk VGND VGND VPWR VPWR clkload15/Y sky130_fd_sc_hd__bufinv_16
XFILLER_0_50_141 VGND VGND VPWR VPWR sky130_fd_sc_hd__decap_4
XFILLER_0_50_185 VGND VGND VPWR VPWR sky130_fd_sc_hd__decap_4
X_2470_ _0630_ VGND VGND VPWR VPWR _0631_ sky130_fd_sc_hd__clkbuf_4
X_4140_ _2148_ VGND VGND VPWR VPWR _0307_ sky130_fd_sc_hd__clkbuf_1
X_4071_ net130 _1965_ _2109_ VGND VGND VPWR VPWR _2112_ sky130_fd_sc_hd__mux2_1
X_3022_ RF0.regs\[10\]\[23\] _1090_ _0674_ RF0.regs\[25\]\[23\] VGND VGND VPWR VPWR
+ _1182_ sky130_fd_sc_hd__a22o_1
XFILLER_0_46_425 VGND VGND VPWR VPWR sky130_fd_sc_hd__decap_8
X_3924_ _1951_ RF0.regs\[10\]\[23\] _2024_ VGND VGND VPWR VPWR _2033_ sky130_fd_sc_hd__mux2_1
XFILLER_0_18_149 VGND VGND VPWR VPWR sky130_fd_sc_hd__fill_1
XFILLER_0_46_458 VGND VGND VPWR VPWR sky130_fd_sc_hd__decap_4
XFILLER_0_73_277 VGND VGND VPWR VPWR sky130_fd_sc_hd__decap_3
XTAP_TAPCELL_ROW_14_291 VGND VPWR sky130_fd_sc_hd__tapvpwrvgnd_1
Xclkload9 clknet_leaf_22_clk VGND VGND VPWR VPWR clkload9/Y sky130_fd_sc_hd__clkinv_1
X_3855_ _1533_ _1545_ VGND VGND VPWR VPWR _1986_ sky130_fd_sc_hd__nor2_1
XFILLER_0_61_417 VGND VGND VPWR VPWR sky130_fd_sc_hd__decap_8
X_3786_ _1208_ _1523_ _1209_ _1210_ _1076_ _1066_ VGND VGND VPWR VPWR _1927_ sky130_fd_sc_hd__mux4_1
X_2806_ _0965_ _0966_ VGND VGND VPWR VPWR _0967_ sky130_fd_sc_hd__nand2_1
XFILLER_0_61_439 VGND VGND VPWR VPWR sky130_fd_sc_hd__decap_3
XFILLER_0_14_355 VGND VGND VPWR VPWR sky130_fd_sc_hd__fill_1
XFILLER_0_14_333 VGND VGND VPWR VPWR sky130_fd_sc_hd__decap_3
X_2737_ RF0.regs\[10\]\[15\] _0615_ _0671_ RF0.regs\[25\]\[15\] VGND VGND VPWR VPWR
+ _0898_ sky130_fd_sc_hd__a22oi_4
XFILLER_0_74_3 VPWR VGND VPWR VGND sky130_ef_sc_hd__decap_12
XFILLER_0_14_377 VGND VGND VPWR VPWR sky130_fd_sc_hd__decap_8
X_2668_ RF0.regs\[10\]\[8\] _0828_ _0672_ RF0.regs\[25\]\[8\] VGND VGND VPWR VPWR
+ _0829_ sky130_fd_sc_hd__a22o_1
X_4407_ _2261_ VGND VGND VPWR VPWR _0082_ sky130_fd_sc_hd__inv_2
X_2599_ _0757_ _0758_ _0759_ VGND VGND VPWR VPWR _0760_ sky130_fd_sc_hd__o21ai_1
XTAP_TAPCELL_ROW_6_226 VGND VPWR sky130_fd_sc_hd__tapvpwrvgnd_1
X_4338_ _2251_ VGND VGND VPWR VPWR _0023_ sky130_fd_sc_hd__inv_2
X_4269_ _1099_ _1567_ _1568_ _1152_ _2218_ VGND VGND VPWR VPWR _2219_ sky130_fd_sc_hd__o32a_1
XTAP_TAPCELL_ROW_57_659 VGND VPWR sky130_fd_sc_hd__tapvpwrvgnd_1
XFILLER_0_37_414 VGND VGND VPWR VPWR sky130_fd_sc_hd__decap_6
XTAP_TAPCELL_ROW_40_515 VGND VPWR sky130_fd_sc_hd__tapvpwrvgnd_1
XFILLER_0_32_141 VPWR VGND VPWR VGND sky130_ef_sc_hd__decap_12
XFILLER_0_20_303 VGND VGND VPWR VPWR sky130_fd_sc_hd__decap_4
XFILLER_0_62_27 VGND VGND VPWR VPWR sky130_fd_sc_hd__fill_1
XFILLER_0_28_447 VGND VGND VPWR VPWR sky130_fd_sc_hd__decap_4
XFILLER_0_15_119 VGND VGND VPWR VPWR sky130_fd_sc_hd__fill_1
X_3640_ _1345_ _1350_ _1037_ VGND VGND VPWR VPWR _1791_ sky130_fd_sc_hd__mux2_1
XFILLER_0_55_288 VGND VGND VPWR VPWR sky130_fd_sc_hd__fill_2
XFILLER_0_70_214 VGND VGND VPWR VPWR sky130_fd_sc_hd__decap_6
XTAP_TAPCELL_ROW_11_272 VGND VPWR sky130_fd_sc_hd__tapvpwrvgnd_1
X_3571_ _1034_ _1330_ _1723_ _1000_ VGND VGND VPWR VPWR _1724_ sky130_fd_sc_hd__a211o_1
X_2522_ RF0.regs\[15\]\[26\] _0664_ _0674_ RF0.regs\[5\]\[26\] VGND VGND VPWR VPWR
+ _0683_ sky130_fd_sc_hd__a22o_1
X_2453_ _0613_ VGND VGND VPWR VPWR _0614_ sky130_fd_sc_hd__clkbuf_4
X_2384_ RF0.regs\[0\]\[21\] VGND VGND VPWR VPWR _0567_ sky130_fd_sc_hd__clkbuf_1
X_4123_ _2139_ VGND VGND VPWR VPWR _0315_ sky130_fd_sc_hd__clkbuf_1
X_4054_ net128 _1850_ _2098_ VGND VGND VPWR VPWR _2103_ sky130_fd_sc_hd__mux2_1
X_3005_ _1034_ _1150_ _1164_ VGND VGND VPWR VPWR _1165_ sky130_fd_sc_hd__and3_1
XFILLER_0_36_72 VGND VGND VPWR VPWR sky130_fd_sc_hd__decap_3
XFILLER_0_46_200 VGND VGND VPWR VPWR sky130_fd_sc_hd__fill_1
XFILLER_0_19_447 VGND VGND VPWR VPWR sky130_fd_sc_hd__fill_1
XFILLER_0_46_277 VGND VGND VPWR VPWR sky130_fd_sc_hd__decap_4
X_3907_ _2023_ VGND VGND VPWR VPWR _2024_ sky130_fd_sc_hd__clkbuf_4
X_3838_ _1972_ RF0.regs\[5\]\[17\] _1957_ VGND VGND VPWR VPWR _1973_ sky130_fd_sc_hd__mux2_1
XFILLER_0_46_299 VGND VGND VPWR VPWR sky130_fd_sc_hd__decap_4
XFILLER_0_6_363 VGND VGND VPWR VPWR sky130_fd_sc_hd__fill_1
X_3769_ _1440_ _1432_ _1135_ VGND VGND VPWR VPWR _1910_ sky130_fd_sc_hd__mux2_1
XFILLER_0_42_461 VGND VGND VPWR VPWR sky130_fd_sc_hd__fill_2
XFILLER_0_77_391 VGND VGND VPWR VPWR sky130_fd_sc_hd__fill_1
XFILLER_0_37_211 VGND VGND VPWR VPWR sky130_fd_sc_hd__fill_1
XTAP_TAPCELL_ROW_25_386 VGND VPWR sky130_fd_sc_hd__tapvpwrvgnd_1
XFILLER_0_37_288 VPWR VGND VPWR VGND sky130_ef_sc_hd__decap_12
XFILLER_0_52_225 VPWR VGND VPWR VGND sky130_ef_sc_hd__decap_12
XFILLER_0_40_409 VGND VGND VPWR VPWR sky130_fd_sc_hd__fill_2
XFILLER_0_57_27 VPWR VGND VPWR VGND sky130_ef_sc_hd__decap_12
XFILLER_0_73_15 VPWR VGND VPWR VGND sky130_ef_sc_hd__decap_12
X_4810_ clknet_leaf_21_clk _0460_ _0204_ VGND VGND VPWR VPWR RF0.regs\[0\]\[12\] sky130_fd_sc_hd__dfrtp_1
XFILLER_0_7_105 VGND VGND VPWR VPWR sky130_fd_sc_hd__fill_1
XFILLER_0_68_380 VPWR VGND VPWR VGND sky130_ef_sc_hd__decap_12
XFILLER_0_16_406 VPWR VGND VPWR VGND sky130_ef_sc_hd__decap_12
XFILLER_0_7_138 VGND VGND VPWR VPWR sky130_fd_sc_hd__fill_1
X_4741_ clknet_leaf_21_clk _0391_ _0135_ VGND VGND VPWR VPWR RF0.regs\[10\]\[7\] sky130_fd_sc_hd__dfrtp_1
XFILLER_0_22_41 VGND VGND VPWR VPWR sky130_fd_sc_hd__fill_2
X_4672_ clknet_leaf_19_clk _0322_ _0066_ VGND VGND VPWR VPWR RF0.regs\[20\]\[2\] sky130_fd_sc_hd__dfrtp_1
XFILLER_0_43_225 VGND VGND VPWR VPWR sky130_fd_sc_hd__fill_2
X_3623_ _1203_ _1773_ VGND VGND VPWR VPWR _1774_ sky130_fd_sc_hd__nor2_1
XFILLER_0_43_247 VGND VGND VPWR VPWR sky130_fd_sc_hd__decap_3
XFILLER_0_43_269 VGND VGND VPWR VPWR sky130_fd_sc_hd__decap_8
XFILLER_0_3_355 VPWR VGND VPWR VGND sky130_ef_sc_hd__decap_12
X_3554_ _1706_ _1561_ _1562_ VGND VGND VPWR VPWR _1707_ sky130_fd_sc_hd__a21oi_2
X_2505_ _0594_ _0600_ _0665_ VGND VGND VPWR VPWR _0666_ sky130_fd_sc_hd__and3_1
X_3485_ RF0.regs\[5\]\[3\] _0632_ _0636_ RF0.regs\[30\]\[3\] _0606_ VGND VGND VPWR
+ VPWR _1641_ sky130_fd_sc_hd__a221o_1
X_2436_ IM0.addr\[8\] IM0.addr\[7\] IM0.addr\[4\] VGND VGND VPWR VPWR _0597_ sky130_fd_sc_hd__or3_1
X_2367_ _0558_ VGND VGND VPWR VPWR _0478_ sky130_fd_sc_hd__clkbuf_1
XFILLER_0_37_3 VPWR VGND VPWR VGND sky130_ef_sc_hd__decap_12
X_2298_ IM0.addr\[14\] _0522_ VGND VGND VPWR VPWR _0523_ sky130_fd_sc_hd__and2_1
X_4106_ net145 _2018_ _2120_ VGND VGND VPWR VPWR _2130_ sky130_fd_sc_hd__mux2_1
XTAP_TAPCELL_ROW_67_743 VGND VPWR sky130_fd_sc_hd__tapvpwrvgnd_1
X_4037_ _2092_ VGND VGND VPWR VPWR _0354_ sky130_fd_sc_hd__clkbuf_1
XFILLER_0_63_81 VGND VGND VPWR VPWR sky130_fd_sc_hd__decap_3
XFILLER_0_66_306 VGND VGND VPWR VPWR sky130_fd_sc_hd__fill_2
XFILLER_0_19_200 VGND VGND VPWR VPWR sky130_fd_sc_hd__decap_8
XFILLER_0_19_211 VGND VGND VPWR VPWR sky130_fd_sc_hd__fill_1
XFILLER_0_81_309 VGND VGND VPWR VPWR sky130_fd_sc_hd__fill_2
XFILLER_0_19_266 VGND VGND VPWR VPWR sky130_fd_sc_hd__decap_8
XTAP_TAPCELL_ROW_22_367 VGND VPWR sky130_fd_sc_hd__tapvpwrvgnd_1
XFILLER_0_15_461 VPWR VGND VPWR VGND sky130_ef_sc_hd__decap_12
XFILLER_0_30_475 VGND VGND VPWR VPWR sky130_fd_sc_hd__fill_1
XFILLER_0_4_108 VGND VGND VPWR VPWR sky130_fd_sc_hd__fill_1
XFILLER_0_40_206 VGND VGND VPWR VPWR sky130_fd_sc_hd__fill_1
XFILLER_0_68_15 VPWR VGND VPWR VGND sky130_ef_sc_hd__decap_12
X_3270_ _1030_ _0863_ _0722_ VGND VGND VPWR VPWR _1428_ sky130_fd_sc_hd__mux2_1
XFILLER_0_17_30 VGND VGND VPWR VPWR sky130_fd_sc_hd__fill_2
XTAP_TAPCELL_ROW_64_724 VGND VPWR sky130_fd_sc_hd__tapvpwrvgnd_1
XTAP_TAPCELL_ROW_72_790 VGND VPWR sky130_fd_sc_hd__tapvpwrvgnd_1
XFILLER_0_8_469 VGND VGND VPWR VPWR sky130_fd_sc_hd__decap_6
X_2985_ _1124_ _1144_ _1085_ VGND VGND VPWR VPWR _1145_ sky130_fd_sc_hd__mux2_1
X_4724_ clknet_leaf_9_clk _0374_ _0118_ VGND VGND VPWR VPWR RF0.regs\[15\]\[22\] sky130_fd_sc_hd__dfrtp_1
X_4655_ clknet_leaf_3_clk _0305_ _0049_ VGND VGND VPWR VPWR RF0.regs\[25\]\[17\] sky130_fd_sc_hd__dfrtp_2
X_4586_ _2285_ VGND VGND VPWR VPWR _0237_ sky130_fd_sc_hd__inv_2
X_3606_ _0956_ _0953_ VGND VGND VPWR VPWR _1757_ sky130_fd_sc_hd__nor2_1
X_3537_ _1616_ _1620_ _1625_ _1690_ VGND VGND VPWR VPWR _1691_ sky130_fd_sc_hd__a22oi_4
XFILLER_0_12_475 VGND VGND VPWR VPWR sky130_fd_sc_hd__fill_1
X_3468_ _1000_ _1623_ _1619_ _0651_ VGND VGND VPWR VPWR _1624_ sky130_fd_sc_hd__a2bb2o_1
X_2419_ _0584_ VGND VGND VPWR VPWR _0452_ sky130_fd_sc_hd__clkbuf_1
X_3399_ _0822_ _0823_ VGND VGND VPWR VPWR _1556_ sky130_fd_sc_hd__nor2_1
XTAP_TAPCELL_ROW_27_404 VGND VPWR sky130_fd_sc_hd__tapvpwrvgnd_1
XTAP_TAPCELL_ROW_35_470 VGND VPWR sky130_fd_sc_hd__tapvpwrvgnd_1
XFILLER_0_47_372 VGND VGND VPWR VPWR sky130_fd_sc_hd__decap_8
XFILLER_0_74_180 VGND VGND VPWR VPWR sky130_fd_sc_hd__decap_3
XFILLER_0_62_375 VGND VGND VPWR VPWR sky130_fd_sc_hd__decap_8
XPHY_EDGE_ROW_26_Left_108 VGND VGND VPWR VPWR sky130_fd_sc_hd__decap_3
XFILLER_0_38_29 VGND VGND VPWR VPWR sky130_fd_sc_hd__decap_8
XTAP_TAPCELL_ROW_78_838 VGND VPWR sky130_fd_sc_hd__tapvpwrvgnd_1
XPHY_EDGE_ROW_35_Left_117 VGND VGND VPWR VPWR sky130_fd_sc_hd__decap_3
XFILLER_0_57_103 VGND VGND VPWR VPWR sky130_fd_sc_hd__decap_4
XFILLER_0_57_125 VGND VGND VPWR VPWR sky130_fd_sc_hd__decap_3
XFILLER_0_70_27 VGND VGND VPWR VPWR sky130_fd_sc_hd__fill_1
X_2770_ _0672_ VGND VGND VPWR VPWR _0931_ sky130_fd_sc_hd__clkbuf_4
XFILLER_0_53_364 VGND VGND VPWR VPWR sky130_fd_sc_hd__fill_1
XFILLER_0_79_69 VPWR VGND VPWR VGND sky130_ef_sc_hd__decap_12
Xhold107 RF0.regs\[30\]\[7\] VGND VGND VPWR VPWR net142 sky130_fd_sc_hd__dlygate4sd3_1
X_4440_ _2265_ VGND VGND VPWR VPWR _0111_ sky130_fd_sc_hd__inv_2
XPHY_EDGE_ROW_44_Left_126 VGND VGND VPWR VPWR sky130_fd_sc_hd__decap_3
Xhold118 RF0.regs\[30\]\[25\] VGND VGND VPWR VPWR net153 sky130_fd_sc_hd__dlygate4sd3_1
X_4371_ _2256_ VGND VGND VPWR VPWR _0051_ sky130_fd_sc_hd__inv_2
X_3322_ _1473_ _1479_ VGND VGND VPWR VPWR _1480_ sky130_fd_sc_hd__nand2_1
X_3253_ _1410_ VGND VGND VPWR VPWR _1411_ sky130_fd_sc_hd__inv_2
X_3184_ _1098_ _1312_ _1313_ _1342_ VGND VGND VPWR VPWR _1343_ sky130_fd_sc_hd__o31a_1
XPHY_EDGE_ROW_53_Left_135 VGND VGND VPWR VPWR sky130_fd_sc_hd__decap_3
XTAP_TAPCELL_ROW_49_595 VGND VPWR sky130_fd_sc_hd__tapvpwrvgnd_1
XFILLER_0_76_412 VGND VGND VPWR VPWR sky130_fd_sc_hd__decap_8
XFILLER_0_44_94 VGND VGND VPWR VPWR sky130_fd_sc_hd__decap_6
XFILLER_0_76_445 VPWR VGND VPWR VGND sky130_ef_sc_hd__decap_12
XFILLER_0_48_147 VGND VGND VPWR VPWR sky130_fd_sc_hd__fill_1
XTAP_TAPCELL_ROW_32_451 VGND VPWR sky130_fd_sc_hd__tapvpwrvgnd_1
X_2968_ _1080_ _0774_ VGND VGND VPWR VPWR _1128_ sky130_fd_sc_hd__nor2_1
X_4707_ clknet_leaf_23_clk _0357_ _0101_ VGND VGND VPWR VPWR RF0.regs\[15\]\[5\] sky130_fd_sc_hd__dfrtp_1
XPHY_EDGE_ROW_62_Left_144 VGND VGND VPWR VPWR sky130_fd_sc_hd__decap_3
X_4638_ clknet_leaf_19_clk _0288_ _0032_ VGND VGND VPWR VPWR RF0.regs\[25\]\[0\] sky130_fd_sc_hd__dfrtp_2
X_2899_ _1050_ _1056_ _1059_ VGND VGND VPWR VPWR _1060_ sky130_fd_sc_hd__mux2_1
X_4569_ _2284_ VGND VGND VPWR VPWR _0221_ sky130_fd_sc_hd__inv_2
XPHY_EDGE_ROW_71_Left_153 VGND VGND VPWR VPWR sky130_fd_sc_hd__decap_3
XFILLER_0_79_250 VGND VGND VPWR VPWR sky130_fd_sc_hd__fill_2
XFILLER_0_67_401 VGND VGND VPWR VPWR sky130_fd_sc_hd__fill_1
XPHY_EDGE_ROW_80_Left_162 VGND VGND VPWR VPWR sky130_fd_sc_hd__decap_3
XFILLER_0_54_139 VGND VGND VPWR VPWR sky130_fd_sc_hd__fill_1
XFILLER_0_50_301 VGND VGND VPWR VPWR sky130_fd_sc_hd__decap_4
XFILLER_0_35_397 VGND VGND VPWR VPWR sky130_fd_sc_hd__fill_1
XFILLER_0_49_39 VPWR VGND VPWR VGND sky130_ef_sc_hd__decap_12
XFILLER_0_50_389 VGND VGND VPWR VPWR sky130_fd_sc_hd__fill_1
XFILLER_0_65_27 VPWR VGND VPWR VGND sky130_ef_sc_hd__decap_12
XFILLER_0_81_15 VPWR VGND VPWR VGND sky130_ef_sc_hd__decap_12
X_3940_ _2041_ VGND VGND VPWR VPWR _0400_ sky130_fd_sc_hd__clkbuf_1
XTAP_TAPCELL_ROW_46_565 VGND VPWR sky130_fd_sc_hd__tapvpwrvgnd_1
XFILLER_0_18_309 VPWR VGND VPWR VGND sky130_ef_sc_hd__decap_12
X_3871_ _1998_ VGND VGND VPWR VPWR _0426_ sky130_fd_sc_hd__clkbuf_1
X_2822_ _0779_ _0980_ _0982_ VGND VGND VPWR VPWR _0983_ sky130_fd_sc_hd__o21ai_4
XFILLER_0_5_225 VPWR VGND VPWR VGND sky130_ef_sc_hd__decap_12
XFILLER_0_30_41 VGND VGND VPWR VPWR sky130_fd_sc_hd__decap_4
X_2753_ _0912_ _0913_ VGND VGND VPWR VPWR _0914_ sky130_fd_sc_hd__nand2_1
XFILLER_0_53_150 VPWR VGND VPWR VGND sky130_ef_sc_hd__decap_12
XFILLER_0_60_109 VGND VGND VPWR VPWR sky130_fd_sc_hd__fill_1
XFILLER_0_81_481 VGND VGND VPWR VPWR sky130_fd_sc_hd__fill_1
XFILLER_0_41_312 VGND VGND VPWR VPWR sky130_fd_sc_hd__decap_8
XFILLER_0_41_334 VGND VGND VPWR VPWR sky130_fd_sc_hd__fill_2
X_2684_ RF0.regs\[10\]\[7\] _0614_ _0670_ RF0.regs\[25\]\[7\] VGND VGND VPWR VPWR
+ _0845_ sky130_fd_sc_hd__a22o_2
XFILLER_0_30_85 VGND VGND VPWR VPWR sky130_fd_sc_hd__fill_1
XFILLER_0_41_356 VGND VGND VPWR VPWR sky130_fd_sc_hd__decap_6
X_4423_ _2263_ VGND VGND VPWR VPWR _2264_ sky130_fd_sc_hd__buf_4
X_4354_ _2254_ VGND VGND VPWR VPWR _0036_ sky130_fd_sc_hd__inv_2
X_3305_ _1335_ VGND VGND VPWR VPWR _1463_ sky130_fd_sc_hd__inv_2
X_4285_ _2228_ VGND VGND VPWR VPWR net13 sky130_fd_sc_hd__inv_2
X_3236_ _1019_ _0723_ _1028_ VGND VGND VPWR VPWR _1395_ sky130_fd_sc_hd__or3_1
X_3167_ _1074_ _1025_ VGND VGND VPWR VPWR _1326_ sky130_fd_sc_hd__nand2_1
X_3098_ _1255_ _1257_ _1020_ VGND VGND VPWR VPWR _1258_ sky130_fd_sc_hd__mux2_1
XFILLER_0_55_82 VGND VGND VPWR VPWR sky130_fd_sc_hd__fill_1
XTAP_TAPCELL_ROW_80_855 VGND VPWR sky130_fd_sc_hd__tapvpwrvgnd_1
XFILLER_0_71_81 VGND VGND VPWR VPWR sky130_fd_sc_hd__fill_1
XFILLER_0_36_139 VGND VGND VPWR VPWR sky130_fd_sc_hd__fill_1
XFILLER_0_72_481 VGND VGND VPWR VPWR sky130_fd_sc_hd__fill_1
XFILLER_0_55_426 VGND VGND VPWR VPWR sky130_fd_sc_hd__fill_1
Xclkload16 clknet_leaf_5_clk VGND VGND VPWR VPWR clkload16/Y sky130_fd_sc_hd__inv_6
XFILLER_0_63_481 VGND VGND VPWR VPWR sky130_fd_sc_hd__fill_1
XFILLER_0_2_206 VGND VGND VPWR VPWR sky130_fd_sc_hd__decap_4
XFILLER_0_23_367 VPWR VGND VPWR VGND sky130_ef_sc_hd__decap_12
XFILLER_0_76_15 VPWR VGND VPWR VGND sky130_ef_sc_hd__decap_12
X_4070_ _2111_ VGND VGND VPWR VPWR _0340_ sky130_fd_sc_hd__clkbuf_1
X_3021_ RF0.regs\[10\]\[24\] _1090_ _0675_ RF0.regs\[25\]\[24\] VGND VGND VPWR VPWR
+ _1181_ sky130_fd_sc_hd__a22o_1
X_3923_ _2032_ VGND VGND VPWR VPWR _0408_ sky130_fd_sc_hd__clkbuf_1
X_3854_ _1985_ VGND VGND VPWR VPWR _0430_ sky130_fd_sc_hd__clkbuf_1
X_2805_ _0963_ _0964_ VGND VGND VPWR VPWR _0966_ sky130_fd_sc_hd__nand2_1
XTAP_TAPCELL_ROW_14_292 VGND VPWR sky130_fd_sc_hd__tapvpwrvgnd_1
X_3785_ _1433_ _1897_ _1152_ VGND VGND VPWR VPWR _1926_ sky130_fd_sc_hd__o21a_1
XFILLER_0_54_481 VGND VGND VPWR VPWR sky130_fd_sc_hd__fill_1
X_2736_ _0623_ _0895_ _0896_ VGND VGND VPWR VPWR _0897_ sky130_fd_sc_hd__nor3_1
X_2667_ _0809_ VGND VGND VPWR VPWR _0828_ sky130_fd_sc_hd__buf_2
XFILLER_0_41_164 VGND VGND VPWR VPWR sky130_fd_sc_hd__fill_1
X_4406_ _2258_ VGND VGND VPWR VPWR _2261_ sky130_fd_sc_hd__buf_4
XFILLER_0_67_3 VPWR VGND VPWR VGND sky130_ef_sc_hd__decap_12
X_2598_ _0513_ _0606_ _0636_ VGND VGND VPWR VPWR _0759_ sky130_fd_sc_hd__or3_2
XTAP_TAPCELL_ROW_6_227 VGND VPWR sky130_fd_sc_hd__tapvpwrvgnd_1
XFILLER_0_5_40 VGND VGND VPWR VPWR sky130_fd_sc_hd__fill_1
X_4337_ _2251_ VGND VGND VPWR VPWR _0022_ sky130_fd_sc_hd__inv_2
X_4268_ _2217_ VGND VGND VPWR VPWR _2218_ sky130_fd_sc_hd__inv_2
X_3219_ _1240_ VGND VGND VPWR VPWR _1378_ sky130_fd_sc_hd__inv_2
X_4199_ _2179_ VGND VGND VPWR VPWR _0279_ sky130_fd_sc_hd__clkbuf_1
XFILLER_0_37_426 VGND VGND VPWR VPWR sky130_fd_sc_hd__decap_4
XTAP_TAPCELL_ROW_40_516 VGND VPWR sky130_fd_sc_hd__tapvpwrvgnd_1
XFILLER_0_32_131 VGND VGND VPWR VPWR sky130_fd_sc_hd__decap_8
XFILLER_0_32_153 VPWR VGND VPWR VGND sky130_ef_sc_hd__decap_12
XFILLER_0_46_29 VPWR VGND VPWR VGND sky130_ef_sc_hd__decap_12
XFILLER_0_55_201 VGND VGND VPWR VPWR sky130_fd_sc_hd__fill_1
XFILLER_0_43_429 VGND VGND VPWR VPWR sky130_fd_sc_hd__fill_2
XFILLER_0_55_278 VGND VGND VPWR VPWR sky130_fd_sc_hd__fill_2
XTAP_TAPCELL_ROW_11_273 VGND VPWR sky130_fd_sc_hd__tapvpwrvgnd_1
X_3570_ _1034_ _1336_ VGND VGND VPWR VPWR _1723_ sky130_fd_sc_hd__nor2_1
XFILLER_0_51_440 VGND VGND VPWR VPWR sky130_fd_sc_hd__decap_8
X_2521_ _0659_ _0681_ VGND VGND VPWR VPWR _0682_ sky130_fd_sc_hd__nand2_1
XFILLER_0_11_337 VPWR VGND VPWR VGND sky130_ef_sc_hd__decap_12
X_2452_ _0612_ VGND VGND VPWR VPWR _0613_ sky130_fd_sc_hd__buf_4
XPHY_EDGE_ROW_18_Right_18 VGND VGND VPWR VPWR sky130_fd_sc_hd__decap_3
X_2383_ _0566_ VGND VGND VPWR VPWR _0470_ sky130_fd_sc_hd__clkbuf_1
X_4122_ _1850_ RF0.regs\[25\]\[27\] _2134_ VGND VGND VPWR VPWR _2139_ sky130_fd_sc_hd__mux2_1
X_4053_ _2102_ VGND VGND VPWR VPWR _0348_ sky130_fd_sc_hd__clkbuf_1
X_3004_ _1162_ _1163_ _1019_ VGND VGND VPWR VPWR _1164_ sky130_fd_sc_hd__mux2_1
XTAP_TAPCELL_ROW_19_340 VGND VPWR sky130_fd_sc_hd__tapvpwrvgnd_1
XPHY_EDGE_ROW_27_Right_27 VGND VGND VPWR VPWR sky130_fd_sc_hd__decap_3
XFILLER_0_52_61 VGND VGND VPWR VPWR sky130_fd_sc_hd__decap_3
XFILLER_0_52_83 VGND VGND VPWR VPWR sky130_fd_sc_hd__fill_1
XFILLER_0_52_94 VGND VGND VPWR VPWR sky130_fd_sc_hd__decap_6
X_3906_ _0512_ _0631_ VGND VGND VPWR VPWR _2023_ sky130_fd_sc_hd__nand2_2
XFILLER_0_34_418 VGND VGND VPWR VPWR sky130_fd_sc_hd__fill_2
X_3837_ _1864_ _1971_ VGND VGND VPWR VPWR _1972_ sky130_fd_sc_hd__xor2_2
XFILLER_0_14_131 VGND VGND VPWR VPWR sky130_fd_sc_hd__decap_8
X_3768_ _1537_ _1870_ _1871_ _1907_ _1908_ VGND VGND VPWR VPWR _1909_ sky130_fd_sc_hd__a221o_1
XFILLER_0_61_237 VGND VGND VPWR VPWR sky130_fd_sc_hd__fill_1
X_2719_ RF0.regs\[10\]\[3\] _0613_ _0669_ RF0.regs\[25\]\[3\] VGND VGND VPWR VPWR
+ _0880_ sky130_fd_sc_hd__a22oi_4
X_3699_ _1826_ _1844_ VGND VGND VPWR VPWR _1845_ sky130_fd_sc_hd__nor2_2
XPHY_EDGE_ROW_36_Right_36 VGND VGND VPWR VPWR sky130_fd_sc_hd__decap_3
XPHY_EDGE_ROW_45_Right_45 VGND VGND VPWR VPWR sky130_fd_sc_hd__decap_3
XTAP_TAPCELL_ROW_53_630 VGND VPWR sky130_fd_sc_hd__tapvpwrvgnd_1
XFILLER_0_37_223 VGND VGND VPWR VPWR sky130_fd_sc_hd__fill_1
XTAP_TAPCELL_ROW_25_387 VGND VPWR sky130_fd_sc_hd__tapvpwrvgnd_1
XFILLER_0_25_407 VGND VGND VPWR VPWR sky130_fd_sc_hd__fill_1
XFILLER_0_18_481 VGND VGND VPWR VPWR sky130_fd_sc_hd__fill_1
XFILLER_0_33_473 VGND VGND VPWR VPWR sky130_fd_sc_hd__decap_8
XPHY_EDGE_ROW_54_Right_54 VGND VGND VPWR VPWR sky130_fd_sc_hd__decap_3
XFILLER_0_57_39 VPWR VGND VPWR VGND sky130_ef_sc_hd__decap_12
XFILLER_0_73_27 VPWR VGND VPWR VGND sky130_ef_sc_hd__decap_12
XPHY_EDGE_ROW_63_Right_63 VGND VGND VPWR VPWR sky130_fd_sc_hd__decap_3
XTAP_TAPCELL_ROW_16_310 VGND VPWR sky130_fd_sc_hd__tapvpwrvgnd_1
XFILLER_0_68_392 VGND VGND VPWR VPWR sky130_fd_sc_hd__fill_2
XFILLER_0_7_117 VGND VGND VPWR VPWR sky130_fd_sc_hd__fill_1
X_4740_ clknet_leaf_18_clk _0390_ _0134_ VGND VGND VPWR VPWR RF0.regs\[10\]\[6\] sky130_fd_sc_hd__dfrtp_1
XFILLER_0_16_418 VGND VGND VPWR VPWR sky130_fd_sc_hd__fill_2
X_4671_ clknet_leaf_20_clk _0321_ _0065_ VGND VGND VPWR VPWR RF0.regs\[20\]\[1\] sky130_fd_sc_hd__dfrtp_1
X_3622_ _1154_ _1295_ VGND VGND VPWR VPWR _1773_ sky130_fd_sc_hd__and2_1
XPHY_EDGE_ROW_72_Right_72 VGND VGND VPWR VPWR sky130_fd_sc_hd__decap_3
XFILLER_0_3_367 VGND VGND VPWR VPWR sky130_fd_sc_hd__decap_4
X_3553_ RF0.regs\[0\]\[10\] _0604_ _1555_ VGND VGND VPWR VPWR _1706_ sky130_fd_sc_hd__o21bai_1
XFILLER_0_51_281 VGND VGND VPWR VPWR sky130_fd_sc_hd__decap_3
X_2504_ IM0.addr\[2\] IM0.addr\[1\] IM0.addr\[0\] VGND VGND VPWR VPWR _0665_ sky130_fd_sc_hd__o21a_1
X_3484_ _1629_ _1634_ _1639_ VGND VGND VPWR VPWR _1640_ sky130_fd_sc_hd__mux2_1
X_2435_ IM0.addr\[18\] IM0.addr\[20\] IM0.addr\[19\] IM0.addr\[21\] VGND VGND VPWR
+ VPWR _0596_ sky130_fd_sc_hd__or4_4
X_2366_ net98 VGND VGND VPWR VPWR _0558_ sky130_fd_sc_hd__clkbuf_1
X_4105_ _2129_ VGND VGND VPWR VPWR _0323_ sky130_fd_sc_hd__clkbuf_1
XPHY_EDGE_ROW_81_Right_81 VGND VGND VPWR VPWR sky130_fd_sc_hd__decap_3
X_2297_ IM0.addr\[13\] IM0.addr\[12\] _0521_ VGND VGND VPWR VPWR _0522_ sky130_fd_sc_hd__and3_1
X_4036_ _2018_ RF0.regs\[15\]\[2\] _2082_ VGND VGND VPWR VPWR _2092_ sky130_fd_sc_hd__mux2_1
XTAP_TAPCELL_ROW_67_744 VGND VPWR sky130_fd_sc_hd__tapvpwrvgnd_1
XFILLER_0_78_145 VGND VGND VPWR VPWR sky130_fd_sc_hd__fill_1
XFILLER_0_2_85 VGND VGND VPWR VPWR sky130_fd_sc_hd__decap_4
XTAP_TAPCELL_ROW_50_600 VGND VPWR sky130_fd_sc_hd__tapvpwrvgnd_1
XFILLER_0_59_381 VGND VGND VPWR VPWR sky130_fd_sc_hd__fill_2
XFILLER_0_15_473 VGND VGND VPWR VPWR sky130_fd_sc_hd__decap_8
XFILLER_0_30_421 VGND VGND VPWR VPWR sky130_fd_sc_hd__fill_1
XFILLER_0_30_443 VGND VGND VPWR VPWR sky130_fd_sc_hd__fill_2
XFILLER_0_69_101 VGND VGND VPWR VPWR sky130_fd_sc_hd__decap_8
XFILLER_0_65_351 VPWR VGND VPWR VGND sky130_ef_sc_hd__decap_12
XFILLER_0_80_376 VPWR VGND VPWR VGND sky130_ef_sc_hd__decap_12
XFILLER_0_7_19 VGND VGND VPWR VPWR sky130_fd_sc_hd__fill_1
XFILLER_0_33_270 VGND VGND VPWR VPWR sky130_fd_sc_hd__decap_8
XFILLER_0_33_281 VPWR VGND VPWR VGND sky130_ef_sc_hd__decap_12
XFILLER_0_68_27 VGND VGND VPWR VPWR sky130_fd_sc_hd__fill_1
XFILLER_0_48_307 VGND VGND VPWR VPWR sky130_fd_sc_hd__fill_1
XTAP_TAPCELL_ROW_72_791 VGND VPWR sky130_fd_sc_hd__tapvpwrvgnd_1
XFILLER_0_56_340 VGND VGND VPWR VPWR sky130_fd_sc_hd__fill_2
X_2984_ _1130_ _1137_ _1143_ _1136_ VGND VGND VPWR VPWR _1144_ sky130_fd_sc_hd__a22o_1
X_4723_ clknet_leaf_9_clk _0373_ _0117_ VGND VGND VPWR VPWR RF0.regs\[15\]\[21\] sky130_fd_sc_hd__dfrtp_1
X_4654_ clknet_leaf_3_clk _0304_ _0048_ VGND VGND VPWR VPWR RF0.regs\[25\]\[16\] sky130_fd_sc_hd__dfrtp_4
XFILLER_0_12_421 VPWR VGND VPWR VGND sky130_ef_sc_hd__decap_12
X_4585_ _2285_ VGND VGND VPWR VPWR _0236_ sky130_fd_sc_hd__inv_2
X_3605_ RF0.regs\[0\]\[19\] _0603_ _1755_ VGND VGND VPWR VPWR _1756_ sky130_fd_sc_hd__o21ai_1
XFILLER_0_71_398 VGND VGND VPWR VPWR sky130_fd_sc_hd__decap_4
X_3536_ _1629_ _1633_ _1640_ _1689_ VGND VGND VPWR VPWR _1690_ sky130_fd_sc_hd__a2bb2o_2
X_3467_ _1518_ _1154_ VGND VGND VPWR VPWR _1623_ sky130_fd_sc_hd__nand2_1
X_2418_ net100 VGND VGND VPWR VPWR _0584_ sky130_fd_sc_hd__clkbuf_1
X_3398_ _1552_ _1554_ VGND VGND VPWR VPWR _1555_ sky130_fd_sc_hd__nor2_1
X_2349_ IM0.addr\[6\] _0517_ net54 VGND VGND VPWR VPWR _0550_ sky130_fd_sc_hd__a21oi_1
XTAP_TAPCELL_ROW_27_405 VGND VPWR sky130_fd_sc_hd__tapvpwrvgnd_1
X_4019_ _2083_ VGND VGND VPWR VPWR _0363_ sky130_fd_sc_hd__clkbuf_1
XPHY_EDGE_ROW_0_Right_0 VGND VGND VPWR VPWR sky130_fd_sc_hd__decap_3
XFILLER_0_39_329 VGND VGND VPWR VPWR sky130_fd_sc_hd__fill_1
XTAP_TAPCELL_ROW_35_471 VGND VPWR sky130_fd_sc_hd__tapvpwrvgnd_1
XFILLER_0_62_321 VPWR VGND VPWR VGND sky130_ef_sc_hd__decap_12
XFILLER_0_7_481 VGND VGND VPWR VPWR sky130_fd_sc_hd__fill_1
XTAP_TAPCELL_ROW_78_839 VGND VPWR sky130_fd_sc_hd__tapvpwrvgnd_1
XFILLER_0_54_29 VPWR VGND VPWR VGND sky130_ef_sc_hd__decap_12
XFILLER_0_57_148 VGND VGND VPWR VPWR sky130_fd_sc_hd__fill_1
XFILLER_0_57_159 VGND VGND VPWR VPWR sky130_fd_sc_hd__fill_1
XFILLER_0_79_15 VPWR VGND VPWR VGND sky130_ef_sc_hd__decap_12
XFILLER_0_13_207 VGND VGND VPWR VPWR sky130_fd_sc_hd__decap_3
Xhold108 RF0.regs\[20\]\[3\] VGND VGND VPWR VPWR net143 sky130_fd_sc_hd__dlygate4sd3_1
Xhold119 RF0.regs\[30\]\[0\] VGND VGND VPWR VPWR net154 sky130_fd_sc_hd__dlygate4sd3_1
X_4370_ _2256_ VGND VGND VPWR VPWR _0050_ sky130_fd_sc_hd__inv_2
X_3321_ _0652_ _1455_ _1475_ _1478_ VGND VGND VPWR VPWR _1479_ sky130_fd_sc_hd__a31o_1
X_3252_ RF0.regs\[0\]\[23\] _0603_ _1409_ VGND VGND VPWR VPWR _1410_ sky130_fd_sc_hd__o21a_1
XFILLER_0_28_63 VGND VGND VPWR VPWR sky130_fd_sc_hd__fill_1
X_3183_ _1332_ _1333_ _1152_ _1341_ VGND VGND VPWR VPWR _1342_ sky130_fd_sc_hd__o2bb2a_1
XFILLER_0_28_85 VGND VGND VPWR VPWR sky130_fd_sc_hd__decap_3
XTAP_TAPCELL_ROW_49_596 VGND VPWR sky130_fd_sc_hd__tapvpwrvgnd_1
XFILLER_0_76_457 VPWR VGND VPWR VGND sky130_ef_sc_hd__decap_12
XFILLER_0_48_137 VGND VGND VPWR VPWR sky130_fd_sc_hd__decap_3
XTAP_TAPCELL_ROW_32_452 VGND VPWR sky130_fd_sc_hd__tapvpwrvgnd_1
XFILLER_0_44_321 VGND VGND VPWR VPWR sky130_fd_sc_hd__fill_1
XFILLER_0_60_61 VGND VGND VPWR VPWR sky130_fd_sc_hd__decap_3
X_2967_ net41 _0761_ VGND VGND VPWR VPWR _1127_ sky130_fd_sc_hd__or2_1
X_4706_ clknet_leaf_23_clk _0356_ _0100_ VGND VGND VPWR VPWR RF0.regs\[15\]\[4\] sky130_fd_sc_hd__dfrtp_1
XFILLER_0_44_365 VPWR VGND VPWR VGND sky130_ef_sc_hd__decap_12
X_2898_ _1058_ VGND VGND VPWR VPWR _1059_ sky130_fd_sc_hd__clkbuf_4
X_4637_ clknet_leaf_7_clk _0287_ _0031_ VGND VGND VPWR VPWR RF0.regs\[30\]\[31\] sky130_fd_sc_hd__dfrtp_1
X_4568_ _2284_ VGND VGND VPWR VPWR _0220_ sky130_fd_sc_hd__inv_2
XFILLER_0_69_92 VGND VGND VPWR VPWR sky130_fd_sc_hd__decap_6
X_3519_ _0869_ _0864_ _0868_ _1095_ VGND VGND VPWR VPWR _1674_ sky130_fd_sc_hd__a31o_1
XFILLER_0_12_295 VGND VGND VPWR VPWR sky130_fd_sc_hd__fill_1
X_4499_ _2275_ VGND VGND VPWR VPWR _0160_ sky130_fd_sc_hd__inv_2
XFILLER_0_79_284 VPWR VGND VPWR VGND sky130_ef_sc_hd__decap_12
XFILLER_0_47_181 VPWR VGND VPWR VGND sky130_ef_sc_hd__decap_12
Xclkbuf_leaf_20_clk clknet_1_0__leaf_clk VGND VGND VPWR VPWR clknet_leaf_20_clk sky130_fd_sc_hd__clkbuf_8
XFILLER_0_35_376 VPWR VGND VPWR VGND sky130_ef_sc_hd__decap_12
XFILLER_0_50_335 VGND VGND VPWR VPWR sky130_fd_sc_hd__fill_2
XFILLER_0_65_39 VPWR VGND VPWR VGND sky130_ef_sc_hd__decap_12
XFILLER_0_81_27 VGND VGND VPWR VPWR sky130_fd_sc_hd__fill_1
XTAP_TAPCELL_ROW_46_566 VGND VPWR sky130_fd_sc_hd__tapvpwrvgnd_1
X_3870_ _1997_ RF0.regs\[5\]\[10\] _1994_ VGND VGND VPWR VPWR _1998_ sky130_fd_sc_hd__mux2_1
XFILLER_0_73_449 VPWR VGND VPWR VGND sky130_ef_sc_hd__decap_12
X_2821_ _0775_ _0981_ VGND VGND VPWR VPWR _0982_ sky130_fd_sc_hd__and2_1
XFILLER_0_5_237 VGND VGND VPWR VPWR sky130_fd_sc_hd__decap_8
X_2752_ RF0.regs\[10\]\[12\] _0615_ _0671_ RF0.regs\[25\]\[12\] VGND VGND VPWR VPWR
+ _0913_ sky130_fd_sc_hd__a22oi_4
Xclkbuf_leaf_11_clk clknet_1_1__leaf_clk VGND VGND VPWR VPWR clknet_leaf_11_clk sky130_fd_sc_hd__clkbuf_8
XFILLER_0_53_162 VGND VGND VPWR VPWR sky130_fd_sc_hd__decap_6
X_4422_ _2246_ VGND VGND VPWR VPWR _2263_ sky130_fd_sc_hd__buf_1
X_2683_ _0658_ _0706_ _0843_ _0825_ VGND VGND VPWR VPWR _0844_ sky130_fd_sc_hd__a31o_1
X_4353_ _2254_ VGND VGND VPWR VPWR _0035_ sky130_fd_sc_hd__inv_2
X_3304_ _1337_ _1334_ _1057_ VGND VGND VPWR VPWR _1462_ sky130_fd_sc_hd__mux2_1
X_4284_ _0654_ _1455_ _1475_ _2227_ VGND VGND VPWR VPWR _2228_ sky130_fd_sc_hd__a31oi_1
X_3235_ _1065_ _1391_ _1393_ VGND VGND VPWR VPWR _1394_ sky130_fd_sc_hd__a21oi_1
X_3166_ _1098_ _1312_ _1313_ _1324_ _1101_ VGND VGND VPWR VPWR _1325_ sky130_fd_sc_hd__o32a_1
X_3097_ _1226_ _1256_ _1011_ VGND VGND VPWR VPWR _1257_ sky130_fd_sc_hd__mux2_1
XFILLER_0_12_3 VGND VGND VPWR VPWR sky130_fd_sc_hd__fill_1
XFILLER_0_49_402 VGND VGND VPWR VPWR sky130_fd_sc_hd__decap_4
XFILLER_0_76_221 VPWR VGND VPWR VGND sky130_ef_sc_hd__decap_12
XTAP_TAPCELL_ROW_80_856 VGND VPWR sky130_fd_sc_hd__tapvpwrvgnd_1
X_3999_ _1959_ RF0.regs\[15\]\[20\] _2071_ VGND VGND VPWR VPWR _2073_ sky130_fd_sc_hd__mux2_1
XFILLER_0_17_332 VGND VGND VPWR VPWR sky130_fd_sc_hd__decap_4
XFILLER_0_44_162 VGND VGND VPWR VPWR sky130_fd_sc_hd__fill_1
XFILLER_0_32_379 VGND VGND VPWR VPWR sky130_fd_sc_hd__decap_4
XTAP_TAPCELL_ROW_0_180 VGND VPWR sky130_fd_sc_hd__tapvpwrvgnd_1
XFILLER_0_55_449 VGND VGND VPWR VPWR sky130_fd_sc_hd__decap_6
XFILLER_0_23_302 VGND VGND VPWR VPWR sky130_fd_sc_hd__fill_2
Xclkload17 clknet_leaf_6_clk VGND VGND VPWR VPWR clkload17/Y sky130_fd_sc_hd__inv_6
XFILLER_0_23_379 VPWR VGND VPWR VGND sky130_ef_sc_hd__decap_12
XFILLER_0_76_27 VGND VGND VPWR VPWR sky130_fd_sc_hd__fill_1
Xclkbuf_leaf_0_clk clknet_1_0__leaf_clk VGND VGND VPWR VPWR clknet_leaf_0_clk sky130_fd_sc_hd__clkbuf_8
X_3020_ _1173_ _1179_ _1062_ VGND VGND VPWR VPWR _1180_ sky130_fd_sc_hd__mux2_1
XTAP_TAPCELL_ROW_59_680 VGND VPWR sky130_fd_sc_hd__tapvpwrvgnd_1
XFILLER_0_58_232 VGND VGND VPWR VPWR sky130_fd_sc_hd__fill_1
XFILLER_0_73_202 VGND VGND VPWR VPWR sky130_fd_sc_hd__fill_2
XFILLER_0_46_416 VGND VGND VPWR VPWR sky130_fd_sc_hd__fill_1
X_3922_ _1859_ RF0.regs\[10\]\[24\] _2024_ VGND VGND VPWR VPWR _2032_ sky130_fd_sc_hd__mux2_1
XFILLER_0_73_213 VGND VGND VPWR VPWR sky130_fd_sc_hd__fill_1
X_3853_ _1984_ RF0.regs\[5\]\[14\] _1957_ VGND VGND VPWR VPWR _1985_ sky130_fd_sc_hd__mux2_1
X_2804_ _0963_ _0964_ VGND VGND VPWR VPWR _0965_ sky130_fd_sc_hd__or2_1
XTAP_TAPCELL_ROW_14_293 VGND VPWR sky130_fd_sc_hd__tapvpwrvgnd_1
X_3784_ _1725_ _1748_ _1717_ _1924_ VGND VGND VPWR VPWR _1925_ sky130_fd_sc_hd__a2bb2o_1
X_2735_ _0743_ _0734_ _0738_ _0736_ VGND VGND VPWR VPWR _0896_ sky130_fd_sc_hd__o31a_1
X_2666_ net45 _0825_ _0826_ VGND VGND VPWR VPWR _0827_ sky130_fd_sc_hd__mux2_1
XFILLER_0_41_154 VGND VGND VPWR VPWR sky130_fd_sc_hd__decap_3
X_4405_ _2260_ VGND VGND VPWR VPWR _0081_ sky130_fd_sc_hd__inv_2
X_2597_ _0710_ _0677_ _0756_ VGND VGND VPWR VPWR _0758_ sky130_fd_sc_hd__o21a_1
X_4336_ _2251_ VGND VGND VPWR VPWR _0021_ sky130_fd_sc_hd__inv_2
XTAP_TAPCELL_ROW_6_228 VGND VPWR sky130_fd_sc_hd__tapvpwrvgnd_1
X_4267_ _2216_ _1647_ _1935_ VGND VGND VPWR VPWR _2217_ sky130_fd_sc_hd__mux2_1
X_3218_ _1241_ _1269_ _1376_ VGND VGND VPWR VPWR _1377_ sky130_fd_sc_hd__a21oi_1
X_4198_ _1951_ net163 _2170_ VGND VGND VPWR VPWR _2179_ sky130_fd_sc_hd__mux2_1
X_3149_ _1305_ _1307_ VGND VGND VPWR VPWR _1308_ sky130_fd_sc_hd__nor2_1
XFILLER_0_37_449 VGND VGND VPWR VPWR sky130_fd_sc_hd__decap_6
XTAP_TAPCELL_ROW_40_517 VGND VPWR sky130_fd_sc_hd__tapvpwrvgnd_1
XFILLER_0_9_362 VGND VGND VPWR VPWR sky130_fd_sc_hd__decap_3
XFILLER_0_64_268 VGND VGND VPWR VPWR sky130_fd_sc_hd__decap_4
XFILLER_0_17_151 VGND VGND VPWR VPWR sky130_fd_sc_hd__decap_3
XFILLER_0_52_419 VGND VGND VPWR VPWR sky130_fd_sc_hd__fill_1
XFILLER_0_32_165 VPWR VGND VPWR VGND sky130_ef_sc_hd__decap_12
XFILLER_0_20_316 VGND VGND VPWR VPWR sky130_fd_sc_hd__decap_4
XFILLER_0_1_3 VPWR VGND VPWR VGND sky130_ef_sc_hd__decap_12
XTAP_TAPCELL_ROW_56_650 VGND VPWR sky130_fd_sc_hd__tapvpwrvgnd_1
XFILLER_0_62_29 VPWR VGND VPWR VGND sky130_ef_sc_hd__decap_12
XFILLER_0_36_471 VGND VGND VPWR VPWR sky130_fd_sc_hd__decap_4
XFILLER_0_63_290 VGND VGND VPWR VPWR sky130_fd_sc_hd__decap_6
X_2520_ RF0.regs\[15\]\[27\] _0664_ _0675_ RF0.regs\[5\]\[27\] VGND VGND VPWR VPWR
+ _0681_ sky130_fd_sc_hd__a22o_1
X_2451_ IM0.addr\[0\] net69 net39 _0513_ VGND VGND VPWR VPWR _0612_ sky130_fd_sc_hd__and4b_1
XFILLER_0_11_349 VPWR VGND VPWR VGND sky130_ef_sc_hd__decap_12
X_2382_ net112 VGND VGND VPWR VPWR _0566_ sky130_fd_sc_hd__clkbuf_1
X_4121_ _2138_ VGND VGND VPWR VPWR _0316_ sky130_fd_sc_hd__clkbuf_1
X_4052_ net137 _1845_ _2098_ VGND VGND VPWR VPWR _2102_ sky130_fd_sc_hd__mux2_1
X_3003_ _1009_ _0865_ _0866_ VGND VGND VPWR VPWR _1163_ sky130_fd_sc_hd__and3_1
XTAP_TAPCELL_ROW_19_341 VGND VPWR sky130_fd_sc_hd__tapvpwrvgnd_1
X_3905_ _2022_ VGND VGND VPWR VPWR _0416_ sky130_fd_sc_hd__clkbuf_1
XFILLER_0_19_449 VPWR VGND VPWR VGND sky130_ef_sc_hd__decap_12
XFILLER_0_46_235 VGND VGND VPWR VPWR sky130_fd_sc_hd__fill_1
XFILLER_0_27_460 VGND VGND VPWR VPWR sky130_fd_sc_hd__fill_2
XFILLER_0_27_471 VGND VGND VPWR VPWR sky130_fd_sc_hd__decap_8
X_3836_ _1749_ _1970_ _1794_ VGND VGND VPWR VPWR _1971_ sky130_fd_sc_hd__a21bo_1
XFILLER_0_61_216 VGND VGND VPWR VPWR sky130_fd_sc_hd__fill_2
XFILLER_0_6_354 VGND VGND VPWR VPWR sky130_fd_sc_hd__fill_1
X_3767_ _1513_ _1532_ VGND VGND VPWR VPWR _1908_ sky130_fd_sc_hd__nor2_1
X_2718_ _0876_ _0878_ VGND VGND VPWR VPWR _0879_ sky130_fd_sc_hd__xnor2_1
X_3698_ _1825_ _1380_ _1814_ VGND VGND VPWR VPWR _1844_ sky130_fd_sc_hd__and3_1
X_2649_ RF0.regs\[10\]\[11\] _0809_ _0669_ RF0.regs\[25\]\[11\] VGND VGND VPWR VPWR
+ _0810_ sky130_fd_sc_hd__a22o_1
XFILLER_0_77_81 VGND VGND VPWR VPWR sky130_fd_sc_hd__decap_8
X_4319_ _2248_ VGND VGND VPWR VPWR _0007_ sky130_fd_sc_hd__inv_2
XFILLER_0_77_393 VPWR VGND VPWR VGND sky130_ef_sc_hd__decap_12
XTAP_TAPCELL_ROW_25_388 VGND VPWR sky130_fd_sc_hd__tapvpwrvgnd_1
XFILLER_0_9_181 VGND VGND VPWR VPWR sky130_fd_sc_hd__fill_1
XFILLER_0_52_249 VGND VGND VPWR VPWR sky130_fd_sc_hd__decap_3
XFILLER_0_20_179 VGND VGND VPWR VPWR sky130_fd_sc_hd__fill_1
XFILLER_0_73_39 VPWR VGND VPWR VGND sky130_ef_sc_hd__decap_12
XTAP_TAPCELL_ROW_16_311 VGND VPWR sky130_fd_sc_hd__tapvpwrvgnd_1
X_4670_ clknet_leaf_19_clk _0320_ _0064_ VGND VGND VPWR VPWR RF0.regs\[20\]\[0\] sky130_fd_sc_hd__dfrtp_1
X_3621_ _0938_ _0952_ _1758_ VGND VGND VPWR VPWR _1772_ sky130_fd_sc_hd__and3_1
XFILLER_0_3_335 VGND VGND VPWR VPWR sky130_fd_sc_hd__fill_1
XFILLER_0_24_441 VGND VGND VPWR VPWR sky130_fd_sc_hd__decap_4
X_3552_ RF0.regs\[0\]\[9\] _0604_ _1697_ net32 VGND VGND VPWR VPWR _1705_ sky130_fd_sc_hd__o22a_1
XFILLER_0_24_474 VGND VGND VPWR VPWR sky130_fd_sc_hd__fill_2
X_2503_ _0663_ VGND VGND VPWR VPWR _0664_ sky130_fd_sc_hd__buf_2
X_3483_ _0651_ _1631_ _1638_ _0711_ VGND VGND VPWR VPWR _1639_ sky130_fd_sc_hd__o2bb2a_1
X_2434_ IM0.addr\[14\] IM0.addr\[16\] IM0.addr\[15\] IM0.addr\[17\] VGND VGND VPWR
+ VPWR _0595_ sky130_fd_sc_hd__or4_4
X_2365_ _0557_ VGND VGND VPWR VPWR _0479_ sky130_fd_sc_hd__clkbuf_1
X_4104_ net143 _2015_ _2120_ VGND VGND VPWR VPWR _2129_ sky130_fd_sc_hd__mux2_1
XFILLER_0_47_51 VGND VGND VPWR VPWR sky130_fd_sc_hd__fill_1
X_2296_ IM0.addr\[11\] _0520_ VGND VGND VPWR VPWR _0521_ sky130_fd_sc_hd__and2_1
X_4035_ _2091_ VGND VGND VPWR VPWR _0355_ sky130_fd_sc_hd__clkbuf_1
XTAP_TAPCELL_ROW_67_745 VGND VPWR sky130_fd_sc_hd__tapvpwrvgnd_1
XTAP_TAPCELL_ROW_50_601 VGND VPWR sky130_fd_sc_hd__tapvpwrvgnd_1
XFILLER_0_74_363 VGND VGND VPWR VPWR sky130_fd_sc_hd__fill_1
X_3819_ _1956_ RF0.regs\[5\]\[21\] _1957_ VGND VGND VPWR VPWR _1958_ sky130_fd_sc_hd__mux2_1
X_4799_ clknet_leaf_17_clk _0449_ _0193_ VGND VGND VPWR VPWR RF0.regs\[0\]\[1\] sky130_fd_sc_hd__dfrtp_1
XFILLER_0_30_477 VGND VGND VPWR VPWR sky130_fd_sc_hd__fill_1
XPHY_EDGE_ROW_6_Left_88 VGND VGND VPWR VPWR sky130_fd_sc_hd__decap_3
XFILLER_0_65_363 VGND VGND VPWR VPWR sky130_fd_sc_hd__decap_4
XFILLER_0_25_238 VGND VGND VPWR VPWR sky130_fd_sc_hd__fill_1
XFILLER_0_80_388 VPWR VGND VPWR VGND sky130_ef_sc_hd__decap_12
XFILLER_0_33_293 VGND VGND VPWR VPWR sky130_fd_sc_hd__decap_4
XFILLER_0_75_105 VGND VGND VPWR VPWR sky130_fd_sc_hd__decap_6
XFILLER_0_48_319 VGND VGND VPWR VPWR sky130_fd_sc_hd__fill_1
XTAP_TAPCELL_ROW_72_792 VGND VPWR sky130_fd_sc_hd__tapvpwrvgnd_1
X_2983_ _1138_ _1139_ _1140_ _1142_ _1048_ _1064_ VGND VGND VPWR VPWR _1143_ sky130_fd_sc_hd__mux4_1
XFILLER_0_16_205 VGND VGND VPWR VPWR sky130_fd_sc_hd__fill_2
X_4722_ clknet_leaf_4_clk _0372_ _0116_ VGND VGND VPWR VPWR RF0.regs\[15\]\[20\] sky130_fd_sc_hd__dfrtp_1
XFILLER_0_56_363 VGND VGND VPWR VPWR sky130_fd_sc_hd__fill_1
XFILLER_0_71_300 VPWR VGND VPWR VGND sky130_ef_sc_hd__decap_12
X_4653_ clknet_leaf_3_clk _0303_ _0047_ VGND VGND VPWR VPWR RF0.regs\[25\]\[15\] sky130_fd_sc_hd__dfrtp_2
XFILLER_0_12_411 VGND VGND VPWR VPWR sky130_fd_sc_hd__decap_8
X_4584_ _2285_ VGND VGND VPWR VPWR _0235_ sky130_fd_sc_hd__inv_2
X_3604_ _1754_ VGND VGND VPWR VPWR _1755_ sky130_fd_sc_hd__inv_2
XFILLER_0_12_433 VPWR VGND VPWR VGND sky130_ef_sc_hd__decap_12
X_3535_ _1651_ _1687_ _1688_ VGND VGND VPWR VPWR _1689_ sky130_fd_sc_hd__a21o_1
XFILLER_0_12_477 VGND VGND VPWR VPWR sky130_fd_sc_hd__decap_4
X_3466_ RF0.regs\[20\]\[5\] _0624_ _1614_ _1615_ VGND VGND VPWR VPWR _1622_ sky130_fd_sc_hd__a211oi_1
X_2417_ _0583_ VGND VGND VPWR VPWR _0453_ sky130_fd_sc_hd__clkbuf_1
XFILLER_0_58_72 VPWR VGND VPWR VGND sky130_ef_sc_hd__decap_12
X_3397_ RF0.regs\[20\]\[10\] _0625_ _1091_ RF0.regs\[25\]\[10\] _1553_ VGND VGND VPWR
+ VPWR _1554_ sky130_fd_sc_hd__a221o_1
XFILLER_0_42_3 VPWR VGND VPWR VGND sky130_ef_sc_hd__decap_12
X_2348_ _0519_ _0549_ VGND VGND VPWR VPWR _0488_ sky130_fd_sc_hd__nor2_1
XTAP_TAPCELL_ROW_27_406 VGND VPWR sky130_fd_sc_hd__tapvpwrvgnd_1
X_4018_ _1993_ RF0.regs\[15\]\[11\] _2082_ VGND VGND VPWR VPWR _2083_ sky130_fd_sc_hd__mux2_1
XTAP_TAPCELL_ROW_35_472 VGND VPWR sky130_fd_sc_hd__tapvpwrvgnd_1
XFILLER_0_47_330 VGND VGND VPWR VPWR sky130_fd_sc_hd__decap_6
XFILLER_0_47_341 VGND VGND VPWR VPWR sky130_fd_sc_hd__fill_1
XFILLER_0_66_138 VGND VGND VPWR VPWR sky130_fd_sc_hd__fill_2
XFILLER_0_62_333 VGND VGND VPWR VPWR sky130_fd_sc_hd__fill_1
XFILLER_0_62_344 VGND VGND VPWR VPWR sky130_fd_sc_hd__decap_8
XFILLER_0_22_219 VGND VGND VPWR VPWR sky130_fd_sc_hd__decap_3
XFILLER_0_30_263 VPWR VGND VPWR VGND sky130_ef_sc_hd__decap_12
XFILLER_0_70_29 VPWR VGND VPWR VGND sky130_ef_sc_hd__decap_12
XFILLER_0_80_141 VGND VGND VPWR VPWR sky130_fd_sc_hd__decap_8
XFILLER_0_79_27 VPWR VGND VPWR VGND sky130_ef_sc_hd__decap_12
Xhold109 RF0.regs\[30\]\[8\] VGND VGND VPWR VPWR net144 sky130_fd_sc_hd__dlygate4sd3_1
XFILLER_0_0_113 VPWR VGND VPWR VGND sky130_ef_sc_hd__decap_12
XFILLER_0_21_241 VGND VGND VPWR VPWR sky130_fd_sc_hd__decap_4
X_3320_ _1000_ _1476_ _1477_ VGND VGND VPWR VPWR _1478_ sky130_fd_sc_hd__o21a_1
XFILLER_0_21_285 VGND VGND VPWR VPWR sky130_fd_sc_hd__fill_1
X_3251_ _1406_ _1408_ VGND VGND VPWR VPWR _1409_ sky130_fd_sc_hd__or2_1
X_3182_ _1039_ _1336_ _1340_ VGND VGND VPWR VPWR _1341_ sky130_fd_sc_hd__o21a_1
XFILLER_0_44_41 VGND VGND VPWR VPWR sky130_fd_sc_hd__decap_8
XFILLER_0_44_63 VGND VGND VPWR VPWR sky130_fd_sc_hd__fill_1
XFILLER_0_76_469 VGND VGND VPWR VPWR sky130_fd_sc_hd__decap_6
X_2966_ _1076_ _1080_ _1125_ VGND VGND VPWR VPWR _1126_ sky130_fd_sc_hd__or3_1
X_4705_ clknet_leaf_24_clk _0355_ _0099_ VGND VGND VPWR VPWR RF0.regs\[15\]\[3\] sky130_fd_sc_hd__dfrtp_1
X_2897_ _1057_ VGND VGND VPWR VPWR _1058_ sky130_fd_sc_hd__clkbuf_4
X_4636_ clknet_leaf_7_clk _0286_ _0030_ VGND VGND VPWR VPWR RF0.regs\[30\]\[30\] sky130_fd_sc_hd__dfrtp_1
XFILLER_0_8_41 VGND VGND VPWR VPWR sky130_fd_sc_hd__fill_1
XFILLER_0_44_377 VGND VGND VPWR VPWR sky130_fd_sc_hd__decap_4
XFILLER_0_8_74 VGND VGND VPWR VPWR sky130_fd_sc_hd__decap_8
XFILLER_0_8_85 VGND VGND VPWR VPWR sky130_fd_sc_hd__decap_4
X_4567_ _2280_ VGND VGND VPWR VPWR _2284_ sky130_fd_sc_hd__clkbuf_8
X_3518_ _0869_ _0864_ _1672_ VGND VGND VPWR VPWR _1673_ sky130_fd_sc_hd__a21oi_1
X_4498_ _2274_ VGND VGND VPWR VPWR _2275_ sky130_fd_sc_hd__clkbuf_4
X_3449_ RF0.regs\[20\]\[6\] _0624_ _0609_ RF0.regs\[15\]\[6\] _1604_ VGND VGND VPWR
+ VPWR _1605_ sky130_fd_sc_hd__a221o_1
XFILLER_0_79_296 VGND VGND VPWR VPWR sky130_fd_sc_hd__fill_2
Xclone10 _0728_ VGND VGND VPWR VPWR net45 sky130_fd_sc_hd__buf_2
XFILLER_0_35_322 VGND VGND VPWR VPWR sky130_fd_sc_hd__decap_6
XFILLER_0_35_333 VGND VGND VPWR VPWR sky130_fd_sc_hd__decap_3
XFILLER_0_47_193 VPWR VGND VPWR VGND sky130_ef_sc_hd__decap_12
XFILLER_0_35_388 VGND VGND VPWR VPWR sky130_fd_sc_hd__decap_4
XFILLER_0_50_358 VGND VGND VPWR VPWR sky130_fd_sc_hd__decap_6
XTAP_TAPCELL_ROW_46_567 VGND VPWR sky130_fd_sc_hd__tapvpwrvgnd_1
XPHY_EDGE_ROW_9_Left_91 VGND VGND VPWR VPWR sky130_fd_sc_hd__decap_3
XFILLER_0_58_436 VGND VGND VPWR VPWR sky130_fd_sc_hd__decap_3
XFILLER_0_58_447 VGND VGND VPWR VPWR sky130_fd_sc_hd__decap_8
XFILLER_0_14_66 VPWR VGND VPWR VGND sky130_ef_sc_hd__decap_12
XFILLER_0_38_182 VPWR VGND VPWR VGND sky130_ef_sc_hd__decap_12
X_2820_ _0773_ _0774_ VGND VGND VPWR VPWR _0981_ sky130_fd_sc_hd__or2_1
XFILLER_0_5_216 VGND VGND VPWR VPWR sky130_fd_sc_hd__fill_2
X_2751_ _0804_ _0911_ _0734_ VGND VGND VPWR VPWR _0912_ sky130_fd_sc_hd__o21a_1
XFILLER_0_81_461 VPWR VGND VPWR VGND sky130_ef_sc_hd__decap_12
X_2682_ _0842_ _0727_ VGND VGND VPWR VPWR _0843_ sky130_fd_sc_hd__or2_1
XFILLER_0_26_377 VGND VGND VPWR VPWR sky130_fd_sc_hd__decap_4
XFILLER_0_30_54 VGND VGND VPWR VPWR sky130_fd_sc_hd__decap_4
X_4421_ _2262_ VGND VGND VPWR VPWR _0095_ sky130_fd_sc_hd__inv_2
XFILLER_0_41_369 VPWR VGND VPWR VGND sky130_ef_sc_hd__decap_12
X_4352_ _2254_ VGND VGND VPWR VPWR _0034_ sky130_fd_sc_hd__inv_2
X_3303_ _1203_ _1460_ VGND VGND VPWR VPWR _1461_ sky130_fd_sc_hd__nor2_1
X_4283_ _1152_ _2206_ _2226_ VGND VGND VPWR VPWR _2227_ sky130_fd_sc_hd__a21oi_1
X_3234_ _1058_ _1392_ _1135_ VGND VGND VPWR VPWR _1393_ sky130_fd_sc_hd__a21o_1
XFILLER_0_55_51 VGND VGND VPWR VPWR sky130_fd_sc_hd__decap_4
X_3165_ _1323_ VGND VGND VPWR VPWR _1324_ sky130_fd_sc_hd__inv_2
X_3096_ _1170_ _1167_ _1007_ VGND VGND VPWR VPWR _1256_ sky130_fd_sc_hd__mux2_1
XFILLER_0_76_233 VGND VGND VPWR VPWR sky130_fd_sc_hd__fill_2
XTAP_TAPCELL_ROW_80_857 VGND VPWR sky130_fd_sc_hd__tapvpwrvgnd_1
X_3998_ _2072_ VGND VGND VPWR VPWR _0373_ sky130_fd_sc_hd__clkbuf_1
X_2949_ RF0.regs\[10\]\[5\] _0828_ _0670_ RF0.regs\[25\]\[5\] VGND VGND VPWR VPWR
+ _1109_ sky130_fd_sc_hd__a22o_1
XFILLER_0_32_369 VGND VGND VPWR VPWR sky130_fd_sc_hd__fill_1
X_4619_ clknet_leaf_5_clk _0269_ _0013_ VGND VGND VPWR VPWR RF0.regs\[30\]\[13\] sky130_fd_sc_hd__dfrtp_1
XTAP_TAPCELL_ROW_0_170 VGND VPWR sky130_fd_sc_hd__tapvpwrvgnd_1
XFILLER_0_67_211 VGND VGND VPWR VPWR sky130_fd_sc_hd__fill_1
XFILLER_0_63_461 VPWR VGND VPWR VGND sky130_ef_sc_hd__decap_12
Xclkload18 clknet_leaf_8_clk VGND VGND VPWR VPWR clkload18/Y sky130_fd_sc_hd__clkinv_4
XFILLER_0_31_391 VGND VGND VPWR VPWR sky130_fd_sc_hd__fill_1
XTAP_TAPCELL_ROW_59_681 VGND VPWR sky130_fd_sc_hd__tapvpwrvgnd_1
X_3921_ _2031_ VGND VGND VPWR VPWR _0409_ sky130_fd_sc_hd__clkbuf_1
XFILLER_0_18_119 VGND VGND VPWR VPWR sky130_fd_sc_hd__decap_3
X_3852_ _1979_ _1983_ VGND VGND VPWR VPWR _1984_ sky130_fd_sc_hd__and2b_1
X_2803_ RF0.regs\[10\]\[20\] _0617_ _0674_ RF0.regs\[25\]\[20\] VGND VGND VPWR VPWR
+ _0964_ sky130_fd_sc_hd__a22o_1
XTAP_TAPCELL_ROW_14_294 VGND VPWR sky130_fd_sc_hd__tapvpwrvgnd_1
X_3783_ _0653_ _1720_ _1721_ _1923_ _1722_ VGND VGND VPWR VPWR _1924_ sky130_fd_sc_hd__a32o_1
XFILLER_0_41_111 VGND VGND VPWR VPWR sky130_fd_sc_hd__fill_1
X_2734_ _0734_ _0739_ _0744_ VGND VGND VPWR VPWR _0895_ sky130_fd_sc_hd__and3b_1
X_2665_ _0657_ _0730_ VGND VGND VPWR VPWR _0826_ sky130_fd_sc_hd__nand2_1
X_2596_ _0659_ _0677_ _0756_ VGND VGND VPWR VPWR _0757_ sky130_fd_sc_hd__a21oi_1
X_4404_ _2260_ VGND VGND VPWR VPWR _0080_ sky130_fd_sc_hd__inv_2
X_4335_ _2251_ VGND VGND VPWR VPWR _0020_ sky130_fd_sc_hd__inv_2
XTAP_TAPCELL_ROW_6_229 VGND VPWR sky130_fd_sc_hd__tapvpwrvgnd_1
XFILLER_0_5_97 VGND VGND VPWR VPWR sky130_fd_sc_hd__decap_8
X_4266_ _2215_ _1026_ _1059_ VGND VGND VPWR VPWR _2216_ sky130_fd_sc_hd__mux2_1
X_4197_ _2178_ VGND VGND VPWR VPWR _0280_ sky130_fd_sc_hd__clkbuf_1
XFILLER_0_66_83 VGND VGND VPWR VPWR sky130_fd_sc_hd__fill_1
X_3217_ _1274_ _1375_ VGND VGND VPWR VPWR _1376_ sky130_fd_sc_hd__nand2_1
X_3148_ RF0.regs\[20\]\[25\] _0627_ _1091_ RF0.regs\[25\]\[25\] _1306_ VGND VGND VPWR
+ VPWR _1307_ sky130_fd_sc_hd__a221o_1
X_3079_ RF0.regs\[20\]\[27\] _0627_ _1091_ RF0.regs\[25\]\[27\] _1238_ VGND VGND VPWR
+ VPWR _1239_ sky130_fd_sc_hd__a221o_1
XPHY_EDGE_ROW_59_Left_141 VGND VGND VPWR VPWR sky130_fd_sc_hd__decap_3
XFILLER_0_49_299 VGND VGND VPWR VPWR sky130_fd_sc_hd__decap_8
XTAP_TAPCELL_ROW_40_518 VGND VPWR sky130_fd_sc_hd__tapvpwrvgnd_1
XFILLER_0_17_174 VPWR VGND VPWR VGND sky130_ef_sc_hd__decap_12
XFILLER_0_32_111 VGND VGND VPWR VPWR sky130_fd_sc_hd__fill_1
XFILLER_0_32_177 VPWR VGND VPWR VGND sky130_ef_sc_hd__decap_12
XPHY_EDGE_ROW_68_Left_150 VGND VGND VPWR VPWR sky130_fd_sc_hd__decap_3
XTAP_TAPCELL_ROW_56_651 VGND VPWR sky130_fd_sc_hd__tapvpwrvgnd_1
XFILLER_0_55_225 VGND VGND VPWR VPWR sky130_fd_sc_hd__fill_2
XFILLER_0_51_453 VGND VGND VPWR VPWR sky130_fd_sc_hd__fill_1
XFILLER_0_51_475 VGND VGND VPWR VPWR sky130_fd_sc_hd__decap_6
XFILLER_0_11_317 VGND VGND VPWR VPWR sky130_fd_sc_hd__decap_6
X_2450_ _0610_ VGND VGND VPWR VPWR _0611_ sky130_fd_sc_hd__clkbuf_4
X_2381_ _0565_ VGND VGND VPWR VPWR _0471_ sky130_fd_sc_hd__clkbuf_1
X_4120_ _1845_ RF0.regs\[25\]\[28\] _2134_ VGND VGND VPWR VPWR _2138_ sky130_fd_sc_hd__mux2_1
X_4051_ _2101_ VGND VGND VPWR VPWR _0349_ sky130_fd_sc_hd__clkbuf_1
X_3002_ _1104_ _1108_ _1010_ VGND VGND VPWR VPWR _1162_ sky130_fd_sc_hd__mux2_1
X_3904_ net114 VGND VGND VPWR VPWR _2022_ sky130_fd_sc_hd__clkbuf_1
XFILLER_0_52_85 VGND VGND VPWR VPWR sky130_fd_sc_hd__decap_6
X_3835_ _1551_ _1713_ VGND VGND VPWR VPWR _1970_ sky130_fd_sc_hd__or2_1
XFILLER_0_6_377 VGND VGND VPWR VPWR sky130_fd_sc_hd__fill_2
X_3766_ _1572_ _1707_ _1705_ _1896_ _1906_ VGND VGND VPWR VPWR _1907_ sky130_fd_sc_hd__a41o_1
X_2717_ _0716_ _0857_ _0877_ VGND VGND VPWR VPWR _0878_ sky130_fd_sc_hd__and3_1
X_3697_ _1843_ VGND VGND VPWR VPWR _0445_ sky130_fd_sc_hd__clkbuf_1
XFILLER_0_42_475 VGND VGND VPWR VPWR sky130_fd_sc_hd__fill_1
XFILLER_0_72_3 VPWR VGND VPWR VGND sky130_ef_sc_hd__decap_12
X_2648_ _0808_ VGND VGND VPWR VPWR _0809_ sky130_fd_sc_hd__buf_2
X_2579_ RF0.regs\[15\]\[16\] _0663_ _0668_ RF0.regs\[5\]\[16\] VGND VGND VPWR VPWR
+ _0740_ sky130_fd_sc_hd__a22o_1
X_4318_ _2248_ VGND VGND VPWR VPWR _0006_ sky130_fd_sc_hd__inv_2
X_4249_ _1099_ _1656_ _1657_ VGND VGND VPWR VPWR _2205_ sky130_fd_sc_hd__or3_1
XFILLER_0_37_225 VGND VGND VPWR VPWR sky130_fd_sc_hd__fill_1
XTAP_TAPCELL_ROW_25_389 VGND VPWR sky130_fd_sc_hd__tapvpwrvgnd_1
XFILLER_0_18_450 VPWR VGND VPWR VGND sky130_ef_sc_hd__decap_12
XFILLER_0_75_309 VGND VGND VPWR VPWR sky130_fd_sc_hd__decap_6
XTAP_TAPCELL_ROW_16_312 VGND VPWR sky130_fd_sc_hd__tapvpwrvgnd_1
XFILLER_0_43_239 VGND VGND VPWR VPWR sky130_fd_sc_hd__decap_8
X_3620_ RF0.regs\[0\]\[18\] _0604_ _1770_ VGND VGND VPWR VPWR _1771_ sky130_fd_sc_hd__o21bai_1
X_3551_ _0652_ _1698_ _1699_ _1203_ _1332_ VGND VGND VPWR VPWR net32 sky130_fd_sc_hd__a32o_1
X_2502_ _0662_ VGND VGND VPWR VPWR _0663_ sky130_fd_sc_hd__buf_2
X_3482_ _1154_ _1637_ VGND VGND VPWR VPWR _1638_ sky130_fd_sc_hd__nand2_1
X_2433_ net35 VGND VGND VPWR VPWR _0594_ sky130_fd_sc_hd__buf_6
XFILLER_0_11_169 VGND VGND VPWR VPWR sky130_fd_sc_hd__fill_1
X_2364_ net89 VGND VGND VPWR VPWR _0557_ sky130_fd_sc_hd__clkbuf_1
X_4103_ _2128_ VGND VGND VPWR VPWR _0324_ sky130_fd_sc_hd__clkbuf_1
X_2295_ IM0.addr\[10\] IM0.addr\[9\] _0519_ VGND VGND VPWR VPWR _0520_ sky130_fd_sc_hd__and3_1
XFILLER_0_47_74 VPWR VGND VPWR VGND sky130_ef_sc_hd__decap_12
X_4034_ _2015_ RF0.regs\[15\]\[3\] _2082_ VGND VGND VPWR VPWR _2091_ sky130_fd_sc_hd__mux2_1
XTAP_TAPCELL_ROW_67_746 VGND VPWR sky130_fd_sc_hd__tapvpwrvgnd_1
XFILLER_0_78_114 VGND VGND VPWR VPWR sky130_fd_sc_hd__decap_3
XFILLER_0_63_51 VGND VGND VPWR VPWR sky130_fd_sc_hd__decap_4
XFILLER_0_66_309 VPWR VGND VPWR VGND sky130_ef_sc_hd__decap_12
XFILLER_0_74_342 VGND VGND VPWR VPWR sky130_fd_sc_hd__fill_1
XFILLER_0_19_225 VPWR VGND VPWR VGND sky130_ef_sc_hd__decap_12
XTAP_TAPCELL_ROW_50_602 VGND VPWR sky130_fd_sc_hd__tapvpwrvgnd_1
XFILLER_0_6_141 VGND VGND VPWR VPWR sky130_fd_sc_hd__decap_3
XTAP_TAPCELL_ROW_22_359 VGND VPWR sky130_fd_sc_hd__tapvpwrvgnd_1
X_3818_ _1834_ VGND VGND VPWR VPWR _1957_ sky130_fd_sc_hd__clkbuf_4
XFILLER_0_15_442 VGND VGND VPWR VPWR sky130_fd_sc_hd__decap_6
X_4798_ clknet_leaf_17_clk _0448_ _0192_ VGND VGND VPWR VPWR RF0.regs\[0\]\[0\] sky130_fd_sc_hd__dfrtp_1
X_3749_ _1606_ _1881_ _1611_ _1889_ VGND VGND VPWR VPWR _1890_ sky130_fd_sc_hd__a2bb2o_1
Xmax_cap34 net35 VGND VGND VPWR VPWR net34 sky130_fd_sc_hd__clkbuf_1
XFILLER_0_18_280 VGND VGND VPWR VPWR sky130_fd_sc_hd__fill_1
XFILLER_0_65_386 VGND VGND VPWR VPWR sky130_fd_sc_hd__decap_6
XFILLER_0_68_29 VPWR VGND VPWR VGND sky130_ef_sc_hd__decap_12
XFILLER_0_17_88 VGND VGND VPWR VPWR sky130_fd_sc_hd__decap_4
XTAP_TAPCELL_ROW_64_716 VGND VPWR sky130_fd_sc_hd__tapvpwrvgnd_1
XFILLER_0_48_309 VGND VGND VPWR VPWR sky130_fd_sc_hd__decap_6
X_2982_ _1141_ _0960_ _1044_ VGND VGND VPWR VPWR _1142_ sky130_fd_sc_hd__mux2_1
X_4721_ clknet_leaf_4_clk _0371_ _0115_ VGND VGND VPWR VPWR RF0.regs\[15\]\[19\] sky130_fd_sc_hd__dfrtp_1
XFILLER_0_16_217 VGND VGND VPWR VPWR sky130_fd_sc_hd__fill_1
X_4652_ clknet_leaf_3_clk _0302_ _0046_ VGND VGND VPWR VPWR RF0.regs\[25\]\[14\] sky130_fd_sc_hd__dfrtp_4
XFILLER_0_71_312 VPWR VGND VPWR VGND sky130_ef_sc_hd__decap_12
XFILLER_0_3_111 VGND VGND VPWR VPWR sky130_fd_sc_hd__fill_1
X_3603_ RF0.regs\[20\]\[19\] _0626_ _1753_ VGND VGND VPWR VPWR _1754_ sky130_fd_sc_hd__a21oi_1
X_4583_ _2285_ VGND VGND VPWR VPWR _0234_ sky130_fd_sc_hd__inv_2
XFILLER_0_12_445 VPWR VGND VPWR VGND sky130_ef_sc_hd__decap_12
X_3534_ _1644_ net26 VGND VGND VPWR VPWR _1688_ sky130_fd_sc_hd__and2_1
XFILLER_0_3_166 VGND VGND VPWR VPWR sky130_fd_sc_hd__fill_2
X_3465_ RF0.regs\[0\]\[5\] _0603_ _1616_ VGND VGND VPWR VPWR _1621_ sky130_fd_sc_hd__o21a_1
X_2416_ net113 VGND VGND VPWR VPWR _0583_ sky130_fd_sc_hd__clkbuf_1
XFILLER_0_58_62 VGND VGND VPWR VPWR sky130_fd_sc_hd__decap_6
X_3396_ RF0.regs\[15\]\[10\] _0610_ _0629_ RF0.regs\[10\]\[10\] VGND VGND VPWR VPWR
+ _1553_ sky130_fd_sc_hd__a22o_1
X_2347_ net60 _0518_ VGND VGND VPWR VPWR _0549_ sky130_fd_sc_hd__nor2_1
XFILLER_0_35_3 VPWR VGND VPWR VGND sky130_ef_sc_hd__decap_12
XFILLER_0_74_83 VGND VGND VPWR VPWR sky130_fd_sc_hd__fill_1
X_4017_ _2059_ VGND VGND VPWR VPWR _2082_ sky130_fd_sc_hd__clkbuf_4
XTAP_TAPCELL_ROW_27_407 VGND VPWR sky130_fd_sc_hd__tapvpwrvgnd_1
XTAP_TAPCELL_ROW_35_473 VGND VPWR sky130_fd_sc_hd__tapvpwrvgnd_1
XFILLER_0_81_109 VGND VGND VPWR VPWR sky130_fd_sc_hd__decap_3
XFILLER_0_7_461 VPWR VGND VPWR VGND sky130_ef_sc_hd__decap_12
XFILLER_0_15_294 VGND VGND VPWR VPWR sky130_fd_sc_hd__decap_3
XFILLER_0_72_109 VGND VGND VPWR VPWR sky130_fd_sc_hd__decap_4
XFILLER_0_80_153 VGND VGND VPWR VPWR sky130_fd_sc_hd__fill_2
XFILLER_0_79_39 VPWR VGND VPWR VGND sky130_ef_sc_hd__decap_12
XFILLER_0_0_125 VGND VGND VPWR VPWR sky130_fd_sc_hd__decap_3
XFILLER_0_0_169 VPWR VGND VPWR VGND sky130_ef_sc_hd__decap_12
X_3250_ RF0.regs\[20\]\[23\] _0625_ _1091_ RF0.regs\[25\]\[23\] _1407_ VGND VGND VPWR
+ VPWR _1408_ sky130_fd_sc_hd__a221o_1
X_3181_ _1058_ _1337_ _1339_ _1134_ VGND VGND VPWR VPWR _1340_ sky130_fd_sc_hd__a211o_1
XTAP_TAPCELL_ROW_77_830 VGND VPWR sky130_fd_sc_hd__tapvpwrvgnd_1
XPHY_EDGE_ROW_22_Left_104 VGND VGND VPWR VPWR sky130_fd_sc_hd__decap_3
XFILLER_0_29_331 VGND VGND VPWR VPWR sky130_fd_sc_hd__decap_4
XFILLER_0_63_109 VGND VGND VPWR VPWR sky130_fd_sc_hd__decap_3
XFILLER_0_8_269 VPWR VGND VPWR VGND sky130_ef_sc_hd__decap_12
X_4704_ clknet_leaf_24_clk _0354_ _0098_ VGND VGND VPWR VPWR RF0.regs\[15\]\[2\] sky130_fd_sc_hd__dfrtp_1
XFILLER_0_60_41 VPWR VGND VPWR VGND sky130_ef_sc_hd__decap_12
X_2965_ _0765_ VGND VGND VPWR VPWR _1125_ sky130_fd_sc_hd__inv_2
X_2896_ _1020_ VGND VGND VPWR VPWR _1057_ sky130_fd_sc_hd__clkbuf_4
XFILLER_0_60_85 VGND VGND VPWR VPWR sky130_fd_sc_hd__fill_1
X_4635_ clknet_leaf_7_clk _0285_ _0029_ VGND VGND VPWR VPWR RF0.regs\[30\]\[29\] sky130_fd_sc_hd__dfrtp_1
X_4566_ _2283_ VGND VGND VPWR VPWR _0219_ sky130_fd_sc_hd__inv_2
XFILLER_0_4_475 VGND VGND VPWR VPWR sky130_fd_sc_hd__fill_1
X_3517_ _1003_ _1028_ VGND VGND VPWR VPWR _1672_ sky130_fd_sc_hd__nand2_1
XPHY_EDGE_ROW_31_Left_113 VGND VGND VPWR VPWR sky130_fd_sc_hd__decap_3
X_4497_ _2246_ VGND VGND VPWR VPWR _2274_ sky130_fd_sc_hd__clkbuf_1
X_3448_ RF0.regs\[5\]\[6\] _0633_ _0637_ RF0.regs\[30\]\[6\] _0640_ VGND VGND VPWR
+ VPWR _1604_ sky130_fd_sc_hd__a221o_1
X_3379_ RF0.regs\[20\]\[12\] _0625_ _1091_ RF0.regs\[25\]\[12\] _1535_ VGND VGND VPWR
+ VPWR _1536_ sky130_fd_sc_hd__a221o_1
XPHY_EDGE_ROW_40_Left_122 VGND VGND VPWR VPWR sky130_fd_sc_hd__decap_3
XFILLER_0_75_481 VGND VGND VPWR VPWR sky130_fd_sc_hd__fill_1
XFILLER_0_35_345 VGND VGND VPWR VPWR sky130_fd_sc_hd__decap_3
XFILLER_0_35_356 VGND VGND VPWR VPWR sky130_fd_sc_hd__decap_3
XFILLER_0_62_153 VGND VGND VPWR VPWR sky130_fd_sc_hd__fill_1
XFILLER_0_62_164 VGND VGND VPWR VPWR sky130_fd_sc_hd__fill_1
XFILLER_0_81_29 VPWR VGND VPWR VGND sky130_ef_sc_hd__decap_12
XTAP_TAPCELL_ROW_46_568 VGND VPWR sky130_fd_sc_hd__tapvpwrvgnd_1
XFILLER_0_14_78 VGND VGND VPWR VPWR sky130_fd_sc_hd__decap_6
XFILLER_0_66_481 VGND VGND VPWR VPWR sky130_fd_sc_hd__fill_1
X_2750_ _0623_ _0702_ VGND VGND VPWR VPWR _0911_ sky130_fd_sc_hd__nor2_1
XFILLER_0_38_194 VGND VGND VPWR VPWR sky130_fd_sc_hd__fill_2
XFILLER_0_81_473 VGND VGND VPWR VPWR sky130_fd_sc_hd__decap_3
X_2681_ _0724_ _0726_ VGND VGND VPWR VPWR _0842_ sky130_fd_sc_hd__or2_1
X_4420_ _2262_ VGND VGND VPWR VPWR _0094_ sky130_fd_sc_hd__inv_2
XFILLER_0_41_326 VGND VGND VPWR VPWR sky130_fd_sc_hd__decap_8
X_4351_ _2254_ VGND VGND VPWR VPWR _0033_ sky130_fd_sc_hd__inv_2
X_3302_ _1459_ _1154_ VGND VGND VPWR VPWR _1460_ sky130_fd_sc_hd__and2_1
X_4282_ _1935_ _1821_ _2225_ _1085_ VGND VGND VPWR VPWR _2226_ sky130_fd_sc_hd__o211a_1
XFILLER_0_39_97 VGND VGND VPWR VPWR sky130_fd_sc_hd__fill_1
X_3233_ _1281_ _1285_ _1075_ VGND VGND VPWR VPWR _1392_ sky130_fd_sc_hd__mux2_1
X_3164_ _1316_ _1322_ _1084_ VGND VGND VPWR VPWR _1323_ sky130_fd_sc_hd__mux2_1
X_3095_ _1253_ _1254_ _1011_ VGND VGND VPWR VPWR _1255_ sky130_fd_sc_hd__mux2_1
XFILLER_0_55_63 VGND VGND VPWR VPWR sky130_fd_sc_hd__fill_1
XTAP_TAPCELL_ROW_80_858 VGND VPWR sky130_fd_sc_hd__tapvpwrvgnd_1
XFILLER_0_71_51 VGND VGND VPWR VPWR sky130_fd_sc_hd__decap_4
XFILLER_0_76_278 VGND VGND VPWR VPWR sky130_fd_sc_hd__fill_1
X_3997_ _1956_ RF0.regs\[15\]\[21\] _2071_ VGND VGND VPWR VPWR _2072_ sky130_fd_sc_hd__mux2_1
XFILLER_0_17_345 VGND VGND VPWR VPWR sky130_fd_sc_hd__decap_3
X_2948_ _0883_ _1107_ _1003_ VGND VGND VPWR VPWR _1108_ sky130_fd_sc_hd__mux2_1
XFILLER_0_44_120 VGND VGND VPWR VPWR sky130_fd_sc_hd__decap_8
XFILLER_0_17_389 VGND VGND VPWR VPWR sky130_fd_sc_hd__decap_3
X_4618_ clknet_leaf_1_clk _0268_ _0012_ VGND VGND VPWR VPWR RF0.regs\[30\]\[12\] sky130_fd_sc_hd__dfrtp_1
X_2879_ _1039_ VGND VGND VPWR VPWR _1040_ sky130_fd_sc_hd__buf_2
XTAP_TAPCELL_ROW_9_249 VGND VPWR sky130_fd_sc_hd__tapvpwrvgnd_1
X_4549_ _2282_ VGND VGND VPWR VPWR _0203_ sky130_fd_sc_hd__inv_2
XTAP_TAPCELL_ROW_0_171 VGND VPWR sky130_fd_sc_hd__tapvpwrvgnd_1
XTAP_TAPCELL_ROW_43_538 VGND VPWR sky130_fd_sc_hd__tapvpwrvgnd_1
XFILLER_0_63_473 VGND VGND VPWR VPWR sky130_fd_sc_hd__decap_8
Xclkload19 clknet_leaf_9_clk VGND VGND VPWR VPWR clkload19/Y sky130_fd_sc_hd__clkinv_1
XFILLER_0_50_189 VGND VGND VPWR VPWR sky130_fd_sc_hd__fill_1
XFILLER_0_76_29 VPWR VGND VPWR VGND sky130_ef_sc_hd__decap_12
XFILLER_0_25_88 VGND VGND VPWR VPWR sky130_fd_sc_hd__decap_3
X_3920_ _1857_ RF0.regs\[10\]\[25\] _2024_ VGND VGND VPWR VPWR _2031_ sky130_fd_sc_hd__mux2_1
XFILLER_0_58_245 VGND VGND VPWR VPWR sky130_fd_sc_hd__fill_1
XFILLER_0_18_109 VGND VGND VPWR VPWR sky130_fd_sc_hd__decap_6
X_3851_ _1546_ _1978_ _1506_ VGND VGND VPWR VPWR _1983_ sky130_fd_sc_hd__or3b_1
X_3782_ _1135_ _1872_ _1922_ _1002_ VGND VGND VPWR VPWR _1923_ sky130_fd_sc_hd__a211o_1
X_2802_ _0694_ _0747_ _0962_ VGND VGND VPWR VPWR _0963_ sky130_fd_sc_hd__o21ai_1
XTAP_TAPCELL_ROW_14_295 VGND VPWR sky130_fd_sc_hd__tapvpwrvgnd_1
XFILLER_0_26_164 VGND VGND VPWR VPWR sky130_fd_sc_hd__fill_1
X_2733_ _0841_ _0847_ _0890_ _0893_ VGND VGND VPWR VPWR _0894_ sky130_fd_sc_hd__or4_4
XFILLER_0_81_281 VGND VGND VPWR VPWR sky130_fd_sc_hd__fill_2
XFILLER_0_26_197 VGND VGND VPWR VPWR sky130_fd_sc_hd__decap_6
X_2664_ _0771_ net45 VGND VGND VPWR VPWR _0825_ sky130_fd_sc_hd__nand2_1
X_2595_ _0679_ _0755_ VGND VGND VPWR VPWR _0756_ sky130_fd_sc_hd__or2_1
X_4403_ _2260_ VGND VGND VPWR VPWR _0079_ sky130_fd_sc_hd__inv_2
XFILLER_0_22_381 VPWR VGND VPWR VGND sky130_ef_sc_hd__decap_12
X_4334_ _2251_ VGND VGND VPWR VPWR _0019_ sky130_fd_sc_hd__inv_2
X_4265_ _1018_ VGND VGND VPWR VPWR _2215_ sky130_fd_sc_hd__inv_2
X_4196_ _1859_ net160 _2170_ VGND VGND VPWR VPWR _2178_ sky130_fd_sc_hd__mux2_1
X_3216_ _0653_ _1276_ _1277_ _1374_ VGND VGND VPWR VPWR _1375_ sky130_fd_sc_hd__a31o_1
X_3147_ RF0.regs\[15\]\[25\] _0611_ _0631_ RF0.regs\[10\]\[25\] VGND VGND VPWR VPWR
+ _1306_ sky130_fd_sc_hd__a22o_1
XFILLER_0_49_212 VGND VGND VPWR VPWR sky130_fd_sc_hd__decap_3
X_3078_ RF0.regs\[15\]\[27\] _0611_ _0631_ RF0.regs\[10\]\[27\] VGND VGND VPWR VPWR
+ _1238_ sky130_fd_sc_hd__a22o_1
XFILLER_0_64_215 VPWR VGND VPWR VGND sky130_ef_sc_hd__decap_12
XTAP_TAPCELL_ROW_40_519 VGND VPWR sky130_fd_sc_hd__tapvpwrvgnd_1
XFILLER_0_17_186 VGND VGND VPWR VPWR sky130_fd_sc_hd__decap_4
XFILLER_0_20_307 VGND VGND VPWR VPWR sky130_fd_sc_hd__fill_1
XFILLER_0_32_189 VGND VGND VPWR VPWR sky130_fd_sc_hd__fill_2
XTAP_TAPCELL_ROW_56_652 VGND VPWR sky130_fd_sc_hd__tapvpwrvgnd_1
XFILLER_0_11_57 VGND VGND VPWR VPWR sky130_fd_sc_hd__fill_2
X_2380_ net104 VGND VGND VPWR VPWR _0565_ sky130_fd_sc_hd__clkbuf_1
X_4050_ net120 _1842_ _2098_ VGND VGND VPWR VPWR _2101_ sky130_fd_sc_hd__mux2_1
X_3001_ _1157_ _1160_ _1062_ VGND VGND VPWR VPWR _1161_ sky130_fd_sc_hd__mux2_1
XFILLER_0_78_307 VGND VGND VPWR VPWR sky130_fd_sc_hd__fill_1
X_3903_ _2021_ VGND VGND VPWR VPWR _0417_ sky130_fd_sc_hd__clkbuf_1
XFILLER_0_46_215 VGND VGND VPWR VPWR sky130_fd_sc_hd__fill_1
X_3834_ _1969_ VGND VGND VPWR VPWR _0434_ sky130_fd_sc_hd__clkbuf_1
XTAP_TAPCELL_ROW_62_699 VGND VPWR sky130_fd_sc_hd__tapvpwrvgnd_1
XFILLER_0_14_101 VGND VGND VPWR VPWR sky130_fd_sc_hd__decap_3
X_3765_ _1566_ _1902_ _1572_ _1905_ VGND VGND VPWR VPWR _1906_ sky130_fd_sc_hd__a2bb2o_1
XFILLER_0_42_421 VGND VGND VPWR VPWR sky130_fd_sc_hd__fill_1
X_2716_ _0715_ _0723_ _0713_ VGND VGND VPWR VPWR _0877_ sky130_fd_sc_hd__o21ai_1
X_3696_ _1842_ RF0.regs\[5\]\[29\] _1835_ VGND VGND VPWR VPWR _1843_ sky130_fd_sc_hd__mux2_1
X_2647_ _0655_ net69 net39 VGND VGND VPWR VPWR _0808_ sky130_fd_sc_hd__and3b_1
XFILLER_0_65_3 VPWR VGND VPWR VGND sky130_ef_sc_hd__decap_12
X_2578_ _0736_ _0738_ VGND VGND VPWR VPWR _0739_ sky130_fd_sc_hd__nor2_1
X_4317_ _2248_ VGND VGND VPWR VPWR _0005_ sky130_fd_sc_hd__inv_2
X_4248_ _1883_ VGND VGND VPWR VPWR net1 sky130_fd_sc_hd__inv_2
X_4179_ _2168_ VGND VGND VPWR VPWR _0288_ sky130_fd_sc_hd__clkbuf_1
XFILLER_0_37_237 VPWR VGND VPWR VGND sky130_ef_sc_hd__decap_12
XPHY_EDGE_ROW_14_Right_14 VGND VGND VPWR VPWR sky130_fd_sc_hd__decap_3
XFILLER_0_18_462 VPWR VGND VPWR VGND sky130_ef_sc_hd__decap_12
XFILLER_0_33_410 VPWR VGND VPWR VGND sky130_ef_sc_hd__decap_12
XFILLER_0_45_281 VGND VGND VPWR VPWR sky130_fd_sc_hd__fill_1
XFILLER_0_60_273 VGND VGND VPWR VPWR sky130_fd_sc_hd__fill_1
XFILLER_0_60_262 VGND VGND VPWR VPWR sky130_fd_sc_hd__fill_1
XPHY_EDGE_ROW_23_Right_23 VGND VGND VPWR VPWR sky130_fd_sc_hd__decap_3
XTAP_TAPCELL_ROW_16_313 VGND VPWR sky130_fd_sc_hd__tapvpwrvgnd_1
XPHY_EDGE_ROW_32_Right_32 VGND VGND VPWR VPWR sky130_fd_sc_hd__decap_3
XFILLER_0_7_109 VGND VGND VPWR VPWR sky130_fd_sc_hd__decap_3
XFILLER_0_24_410 VGND VGND VPWR VPWR sky130_fd_sc_hd__decap_8
XFILLER_0_24_421 VGND VGND VPWR VPWR sky130_fd_sc_hd__fill_2
XFILLER_0_3_315 VPWR VGND VPWR VGND sky130_ef_sc_hd__decap_12
X_3550_ _1566_ _1569_ _1572_ VGND VGND VPWR VPWR _1704_ sky130_fd_sc_hd__o21ai_2
X_2501_ _0661_ VGND VGND VPWR VPWR _0662_ sky130_fd_sc_hd__clkbuf_4
X_3481_ _1061_ _1635_ _1636_ VGND VGND VPWR VPWR _1637_ sky130_fd_sc_hd__a21oi_1
X_2432_ _0592_ _0589_ _0591_ _0590_ VGND VGND VPWR VPWR _0593_ sky130_fd_sc_hd__nor4_4
XPHY_EDGE_ROW_41_Right_41 VGND VGND VPWR VPWR sky130_fd_sc_hd__decap_3
X_2363_ _0512_ _0514_ VGND VGND VPWR VPWR _0480_ sky130_fd_sc_hd__xor2_1
X_4102_ net127 _2013_ _2120_ VGND VGND VPWR VPWR _2128_ sky130_fd_sc_hd__mux2_1
X_4033_ _2090_ VGND VGND VPWR VPWR _0356_ sky130_fd_sc_hd__clkbuf_1
X_2294_ IM0.addr\[8\] _0518_ VGND VGND VPWR VPWR _0519_ sky130_fd_sc_hd__and2_1
XFILLER_0_47_86 VPWR VGND VPWR VGND sky130_ef_sc_hd__decap_12
XTAP_TAPCELL_ROW_67_747 VGND VPWR sky130_fd_sc_hd__tapvpwrvgnd_1
XFILLER_0_78_137 VGND VGND VPWR VPWR sky130_fd_sc_hd__decap_3
XPHY_EDGE_ROW_50_Right_50 VGND VGND VPWR VPWR sky130_fd_sc_hd__decap_3
XFILLER_0_59_373 VGND VGND VPWR VPWR sky130_fd_sc_hd__decap_4
XTAP_TAPCELL_ROW_50_603 VGND VPWR sky130_fd_sc_hd__tapvpwrvgnd_1
XFILLER_0_74_365 VGND VGND VPWR VPWR sky130_fd_sc_hd__fill_1
XFILLER_0_34_207 VGND VGND VPWR VPWR sky130_fd_sc_hd__decap_6
X_4797_ clknet_leaf_7_clk _0447_ _0191_ VGND VGND VPWR VPWR RF0.regs\[5\]\[31\] sky130_fd_sc_hd__dfrtp_1
XFILLER_0_6_131 VGND VGND VPWR VPWR sky130_fd_sc_hd__decap_8
X_3817_ _1861_ _1955_ VGND VGND VPWR VPWR _1956_ sky130_fd_sc_hd__xnor2_2
X_3748_ _1616_ _1624_ _1625_ _1888_ VGND VGND VPWR VPWR _1889_ sky130_fd_sc_hd__a22o_1
XFILLER_0_42_251 VGND VGND VPWR VPWR sky130_fd_sc_hd__fill_1
XFILLER_0_42_284 VPWR VGND VPWR VGND sky130_ef_sc_hd__decap_12
X_3679_ _1205_ _1207_ _1213_ _1828_ _1333_ VGND VGND VPWR VPWR _1829_ sky130_fd_sc_hd__a32o_1
XFILLER_0_65_343 VGND VGND VPWR VPWR sky130_fd_sc_hd__decap_3
XFILLER_0_21_402 VPWR VGND VPWR VGND sky130_ef_sc_hd__decap_12
XFILLER_0_21_446 VGND VGND VPWR VPWR sky130_fd_sc_hd__fill_2
XFILLER_0_17_12 VGND VGND VPWR VPWR sky130_fd_sc_hd__fill_1
XTAP_TAPCELL_ROW_64_717 VGND VPWR sky130_fd_sc_hd__tapvpwrvgnd_1
XFILLER_0_33_66 VGND VGND VPWR VPWR sky130_fd_sc_hd__decap_4
X_2981_ RF0.regs\[10\]\[22\] _0617_ _0675_ RF0.regs\[25\]\[22\] VGND VGND VPWR VPWR
+ _1141_ sky130_fd_sc_hd__a22oi_2
X_4720_ clknet_leaf_4_clk _0370_ _0114_ VGND VGND VPWR VPWR RF0.regs\[15\]\[18\] sky130_fd_sc_hd__dfrtp_1
XFILLER_0_56_365 VPWR VGND VPWR VGND sky130_ef_sc_hd__decap_12
XFILLER_0_16_229 VGND VGND VPWR VPWR sky130_fd_sc_hd__fill_1
X_4651_ clknet_leaf_3_clk _0301_ _0045_ VGND VGND VPWR VPWR RF0.regs\[25\]\[13\] sky130_fd_sc_hd__dfrtp_2
XFILLER_0_71_324 VPWR VGND VPWR VGND sky130_ef_sc_hd__decap_12
XFILLER_0_3_101 VGND VGND VPWR VPWR sky130_fd_sc_hd__fill_1
X_3602_ RF0.regs\[10\]\[19\] _0630_ _1751_ _1752_ VGND VGND VPWR VPWR _1753_ sky130_fd_sc_hd__a211o_1
X_4582_ _2285_ VGND VGND VPWR VPWR _0233_ sky130_fd_sc_hd__inv_2
XFILLER_0_24_240 VGND VGND VPWR VPWR sky130_fd_sc_hd__decap_8
XFILLER_0_24_251 VGND VGND VPWR VPWR sky130_fd_sc_hd__fill_1
X_3533_ _1655_ _1659_ _1665_ _1686_ VGND VGND VPWR VPWR _1687_ sky130_fd_sc_hd__a2bb2o_1
XFILLER_0_3_178 VGND VGND VPWR VPWR sky130_fd_sc_hd__decap_6
XFILLER_0_12_457 VPWR VGND VPWR VGND sky130_ef_sc_hd__decap_12
X_3464_ _1037_ _1202_ _1221_ _1619_ _0651_ VGND VGND VPWR VPWR _1620_ sky130_fd_sc_hd__a32o_1
X_2415_ _0582_ VGND VGND VPWR VPWR _0454_ sky130_fd_sc_hd__clkbuf_1
XFILLER_0_58_41 VGND VGND VPWR VPWR sky130_fd_sc_hd__fill_1
X_3395_ RF0.regs\[5\]\[10\] _0634_ _0638_ RF0.regs\[30\]\[10\] _0641_ VGND VGND VPWR
+ VPWR _1552_ sky130_fd_sc_hd__a221o_1
XFILLER_0_58_96 VGND VGND VPWR VPWR sky130_fd_sc_hd__decap_8
X_2346_ net38 _0519_ VGND VGND VPWR VPWR _0489_ sky130_fd_sc_hd__xor2_1
XTAP_TAPCELL_ROW_27_408 VGND VPWR sky130_fd_sc_hd__tapvpwrvgnd_1
XFILLER_0_28_3 VPWR VGND VPWR VGND sky130_ef_sc_hd__decap_12
X_4016_ _2081_ VGND VGND VPWR VPWR _0364_ sky130_fd_sc_hd__clkbuf_1
XTAP_TAPCELL_ROW_35_474 VGND VPWR sky130_fd_sc_hd__tapvpwrvgnd_1
XFILLER_0_7_473 VGND VGND VPWR VPWR sky130_fd_sc_hd__decap_8
X_4849_ clknet_leaf_26_clk _0499_ _0243_ VGND VGND VPWR VPWR IM0.addr\[19\] sky130_fd_sc_hd__dfrtp_1
Xclkbuf_leaf_23_clk clknet_1_0__leaf_clk VGND VGND VPWR VPWR clknet_leaf_23_clk sky130_fd_sc_hd__clkbuf_8
XFILLER_0_38_365 VPWR VGND VPWR VGND sky130_ef_sc_hd__decap_12
XFILLER_0_80_132 VGND VGND VPWR VPWR sky130_fd_sc_hd__decap_8
XFILLER_0_21_276 VGND VGND VPWR VPWR sky130_fd_sc_hd__decap_4
X_3180_ _1048_ _1046_ _1338_ _1064_ VGND VGND VPWR VPWR _1339_ sky130_fd_sc_hd__o211a_1
XTAP_TAPCELL_ROW_77_831 VGND VPWR sky130_fd_sc_hd__tapvpwrvgnd_1
X_2964_ _1123_ VGND VGND VPWR VPWR _1124_ sky130_fd_sc_hd__inv_2
Xclkbuf_leaf_14_clk clknet_1_1__leaf_clk VGND VGND VPWR VPWR clknet_leaf_14_clk sky130_fd_sc_hd__clkbuf_8
X_4703_ clknet_leaf_25_clk _0353_ _0097_ VGND VGND VPWR VPWR RF0.regs\[15\]\[1\] sky130_fd_sc_hd__dfrtp_1
XFILLER_0_29_365 VGND VGND VPWR VPWR sky130_fd_sc_hd__decap_3
XFILLER_0_29_376 VPWR VGND VPWR VGND sky130_ef_sc_hd__decap_12
XTAP_TAPCELL_ROW_32_444 VGND VPWR sky130_fd_sc_hd__tapvpwrvgnd_1
XFILLER_0_44_302 VGND VGND VPWR VPWR sky130_fd_sc_hd__decap_6
XFILLER_0_60_53 VGND VGND VPWR VPWR sky130_fd_sc_hd__decap_8
X_2895_ _1053_ _1055_ _1049_ VGND VGND VPWR VPWR _1056_ sky130_fd_sc_hd__mux2_1
XFILLER_0_71_121 VGND VGND VPWR VPWR sky130_fd_sc_hd__decap_8
X_4634_ clknet_leaf_7_clk _0284_ _0028_ VGND VGND VPWR VPWR RF0.regs\[30\]\[28\] sky130_fd_sc_hd__dfrtp_1
XFILLER_0_4_421 VPWR VGND VPWR VGND sky130_ef_sc_hd__decap_12
X_4565_ _2283_ VGND VGND VPWR VPWR _0218_ sky130_fd_sc_hd__inv_2
X_3516_ _1669_ VGND VGND VPWR VPWR _1671_ sky130_fd_sc_hd__inv_2
XFILLER_0_69_51 VGND VGND VPWR VPWR sky130_fd_sc_hd__decap_4
X_4496_ _2273_ VGND VGND VPWR VPWR _0159_ sky130_fd_sc_hd__inv_2
XFILLER_0_12_287 VGND VGND VPWR VPWR sky130_fd_sc_hd__decap_8
XPHY_EDGE_ROW_4_Right_4 VGND VGND VPWR VPWR sky130_fd_sc_hd__decap_3
X_3447_ RF0.regs\[10\]\[6\] _0629_ _0617_ RF0.regs\[25\]\[6\] VGND VGND VPWR VPWR
+ _1603_ sky130_fd_sc_hd__a22o_1
X_3378_ RF0.regs\[15\]\[12\] _0609_ _0629_ RF0.regs\[10\]\[12\] VGND VGND VPWR VPWR
+ _1535_ sky130_fd_sc_hd__a22o_1
X_2329_ IM0.addr\[18\] _0525_ net61 VGND VGND VPWR VPWR _0542_ sky130_fd_sc_hd__a21oi_1
XFILLER_0_79_210 VGND VGND VPWR VPWR sky130_fd_sc_hd__decap_4
XFILLER_0_67_449 VPWR VGND VPWR VGND sky130_ef_sc_hd__decap_12
XFILLER_0_7_281 VGND VGND VPWR VPWR sky130_fd_sc_hd__fill_2
XFILLER_0_50_327 VGND VGND VPWR VPWR sky130_fd_sc_hd__decap_8
XFILLER_0_50_349 VGND VGND VPWR VPWR sky130_fd_sc_hd__fill_1
XFILLER_0_43_390 VGND VGND VPWR VPWR sky130_fd_sc_hd__fill_2
XTAP_TAPCELL_ROW_74_801 VGND VPWR sky130_fd_sc_hd__tapvpwrvgnd_1
XFILLER_0_58_405 VGND VGND VPWR VPWR sky130_fd_sc_hd__decap_3
XTAP_TAPCELL_ROW_46_569 VGND VPWR sky130_fd_sc_hd__tapvpwrvgnd_1
XFILLER_0_26_302 VGND VGND VPWR VPWR sky130_fd_sc_hd__decap_6
XFILLER_0_53_121 VGND VGND VPWR VPWR sky130_fd_sc_hd__fill_1
X_2680_ _0839_ _0840_ VGND VGND VPWR VPWR _0841_ sky130_fd_sc_hd__or2_1
X_4350_ _2254_ VGND VGND VPWR VPWR _0032_ sky130_fd_sc_hd__inv_2
X_3301_ _1329_ _1458_ _1020_ VGND VGND VPWR VPWR _1459_ sky130_fd_sc_hd__mux2_1
X_4281_ _1935_ _1816_ VGND VGND VPWR VPWR _2225_ sky130_fd_sc_hd__nand2_1
Xclkbuf_leaf_3_clk clknet_1_0__leaf_clk VGND VGND VPWR VPWR clknet_leaf_3_clk sky130_fd_sc_hd__clkbuf_8
X_3232_ _1390_ _1280_ _1076_ VGND VGND VPWR VPWR _1391_ sky130_fd_sc_hd__mux2_1
X_3163_ _1319_ _1321_ _1135_ VGND VGND VPWR VPWR _1322_ sky130_fd_sc_hd__mux2_1
X_3094_ _1177_ _1174_ _1014_ VGND VGND VPWR VPWR _1254_ sky130_fd_sc_hd__mux2_1
XTAP_TAPCELL_ROW_80_859 VGND VPWR sky130_fd_sc_hd__tapvpwrvgnd_1
X_3996_ _2059_ VGND VGND VPWR VPWR _2071_ sky130_fd_sc_hd__clkbuf_4
X_2947_ RF0.regs\[10\]\[3\] _0809_ _0670_ RF0.regs\[25\]\[3\] VGND VGND VPWR VPWR
+ _1107_ sky130_fd_sc_hd__a22o_1
XFILLER_0_32_305 VGND VGND VPWR VPWR sky130_fd_sc_hd__decap_3
X_4617_ clknet_leaf_1_clk _0267_ _0011_ VGND VGND VPWR VPWR RF0.regs\[30\]\[11\] sky130_fd_sc_hd__dfrtp_1
X_2878_ _1038_ VGND VGND VPWR VPWR _1039_ sky130_fd_sc_hd__buf_2
X_4548_ _2282_ VGND VGND VPWR VPWR _0202_ sky130_fd_sc_hd__inv_2
X_4479_ _2271_ VGND VGND VPWR VPWR _0144_ sky130_fd_sc_hd__inv_2
XPHY_EDGE_ROW_79_Right_79 VGND VGND VPWR VPWR sky130_fd_sc_hd__decap_3
XTAP_TAPCELL_ROW_0_172 VGND VPWR sky130_fd_sc_hd__tapvpwrvgnd_1
XTAP_TAPCELL_ROW_43_539 VGND VPWR sky130_fd_sc_hd__tapvpwrvgnd_1
XFILLER_0_67_279 VGND VGND VPWR VPWR sky130_fd_sc_hd__fill_1
XFILLER_0_31_393 VGND VGND VPWR VPWR sky130_fd_sc_hd__decap_8
XFILLER_0_46_408 VGND VGND VPWR VPWR sky130_fd_sc_hd__decap_8
X_3850_ _1982_ VGND VGND VPWR VPWR _0431_ sky130_fd_sc_hd__clkbuf_1
XFILLER_0_26_110 VPWR VGND VPWR VGND sky130_ef_sc_hd__decap_12
X_3781_ _1066_ _1525_ _1921_ _1040_ VGND VGND VPWR VPWR _1922_ sky130_fd_sc_hd__o211a_1
X_2801_ _0694_ _0747_ _0624_ VGND VGND VPWR VPWR _0962_ sky130_fd_sc_hd__a21oi_1
XTAP_TAPCELL_ROW_14_296 VGND VPWR sky130_fd_sc_hd__tapvpwrvgnd_1
X_2732_ _0817_ _0818_ _0812_ _0892_ VGND VGND VPWR VPWR _0893_ sky130_fd_sc_hd__or4bb_4
XFILLER_0_54_441 VGND VGND VPWR VPWR sky130_fd_sc_hd__decap_4
XFILLER_0_26_176 VGND VGND VPWR VPWR sky130_fd_sc_hd__fill_1
X_2663_ _0822_ _0823_ VGND VGND VPWR VPWR _0824_ sky130_fd_sc_hd__and2_1
XFILLER_0_41_146 VGND VGND VPWR VPWR sky130_fd_sc_hd__decap_8
X_2594_ _0659_ _0680_ _0754_ VGND VGND VPWR VPWR _0755_ sky130_fd_sc_hd__a21o_1
X_4402_ _2260_ VGND VGND VPWR VPWR _0078_ sky130_fd_sc_hd__inv_2
XFILLER_0_22_393 VGND VGND VPWR VPWR sky130_fd_sc_hd__fill_2
X_4333_ _2251_ VGND VGND VPWR VPWR _0018_ sky130_fd_sc_hd__inv_2
X_4264_ _1085_ _1301_ _2214_ VGND VGND VPWR VPWR net2 sky130_fd_sc_hd__a21bo_1
X_3215_ _1152_ _1365_ _1373_ _1002_ VGND VGND VPWR VPWR _1374_ sky130_fd_sc_hd__o2bb2a_1
XFILLER_0_66_41 VPWR VGND VPWR VGND sky130_ef_sc_hd__decap_12
XFILLER_0_66_85 VGND VGND VPWR VPWR sky130_fd_sc_hd__decap_4
X_4195_ _2177_ VGND VGND VPWR VPWR _0281_ sky130_fd_sc_hd__clkbuf_1
X_3146_ RF0.regs\[5\]\[25\] _0635_ _0639_ RF0.regs\[30\]\[25\] _0642_ VGND VGND VPWR
+ VPWR _1305_ sky130_fd_sc_hd__a221o_1
X_3077_ RF0.regs\[5\]\[27\] _0635_ _0639_ RF0.regs\[30\]\[27\] _0642_ VGND VGND VPWR
+ VPWR _1237_ sky130_fd_sc_hd__a221o_1
XFILLER_0_10_3 VPWR VGND VPWR VGND sky130_ef_sc_hd__decap_12
XFILLER_0_49_235 VGND VGND VPWR VPWR sky130_fd_sc_hd__fill_1
XFILLER_0_64_205 VGND VGND VPWR VPWR sky130_fd_sc_hd__decap_4
XFILLER_0_9_354 VGND VGND VPWR VPWR sky130_fd_sc_hd__decap_8
XFILLER_0_45_430 VGND VGND VPWR VPWR sky130_fd_sc_hd__decap_8
XFILLER_0_64_227 VGND VGND VPWR VPWR sky130_fd_sc_hd__fill_1
X_3979_ _2062_ VGND VGND VPWR VPWR _0382_ sky130_fd_sc_hd__clkbuf_1
XFILLER_0_9_387 VGND VGND VPWR VPWR sky130_fd_sc_hd__fill_2
XFILLER_0_60_477 VGND VGND VPWR VPWR sky130_fd_sc_hd__fill_1
XTAP_TAPCELL_ROW_5_220 VGND VPWR sky130_fd_sc_hd__tapvpwrvgnd_1
XTAP_TAPCELL_ROW_56_653 VGND VPWR sky130_fd_sc_hd__tapvpwrvgnd_1
XFILLER_0_28_419 VGND VGND VPWR VPWR sky130_fd_sc_hd__fill_1
XFILLER_0_23_102 VGND VGND VPWR VPWR sky130_fd_sc_hd__decap_4
XFILLER_0_23_113 VGND VGND VPWR VPWR sky130_fd_sc_hd__decap_4
XTAP_TAPCELL_ROW_11_266 VGND VPWR sky130_fd_sc_hd__tapvpwrvgnd_1
X_3000_ _1158_ _1159_ _1010_ VGND VGND VPWR VPWR _1160_ sky130_fd_sc_hd__mux2_1
X_3902_ _2020_ RF0.regs\[5\]\[1\] _1834_ VGND VGND VPWR VPWR _2021_ sky130_fd_sc_hd__mux2_1
X_3833_ _1968_ RF0.regs\[5\]\[18\] _1957_ VGND VGND VPWR VPWR _1969_ sky130_fd_sc_hd__mux2_1
X_3764_ _1555_ _1904_ VGND VGND VPWR VPWR _1905_ sky130_fd_sc_hd__nor2_1
X_3695_ _1840_ _1841_ VGND VGND VPWR VPWR _1842_ sky130_fd_sc_hd__xor2_4
X_2715_ RF0.regs\[10\]\[3\] _0613_ _0669_ RF0.regs\[25\]\[3\] VGND VGND VPWR VPWR
+ _0876_ sky130_fd_sc_hd__a22o_1
XFILLER_0_42_444 VGND VGND VPWR VPWR sky130_fd_sc_hd__fill_1
X_2646_ _0622_ _0804_ _0805_ _0806_ VGND VGND VPWR VPWR _0807_ sky130_fd_sc_hd__nor4_1
XFILLER_0_42_477 VGND VGND VPWR VPWR sky130_fd_sc_hd__fill_1
XFILLER_0_77_51 VGND VGND VPWR VPWR sky130_fd_sc_hd__decap_4
XFILLER_0_10_363 VGND VGND VPWR VPWR sky130_fd_sc_hd__fill_1
X_2577_ _0657_ _0737_ VGND VGND VPWR VPWR _0738_ sky130_fd_sc_hd__and2_1
XFILLER_0_58_3 VPWR VGND VPWR VGND sky130_ef_sc_hd__decap_12
X_4316_ _2248_ VGND VGND VPWR VPWR _0004_ sky130_fd_sc_hd__inv_2
X_4247_ _2204_ VGND VGND VPWR VPWR _0256_ sky130_fd_sc_hd__clkbuf_1
X_4178_ _2095_ RF0.regs\[25\]\[0\] _2133_ VGND VGND VPWR VPWR _2168_ sky130_fd_sc_hd__mux2_1
X_3129_ _1057_ _1117_ _1288_ VGND VGND VPWR VPWR _1289_ sky130_fd_sc_hd__a21oi_1
XTAP_TAPCELL_ROW_53_623 VGND VPWR sky130_fd_sc_hd__tapvpwrvgnd_1
XFILLER_0_18_474 VGND VGND VPWR VPWR sky130_fd_sc_hd__fill_2
XFILLER_0_33_422 VPWR VGND VPWR VGND sky130_ef_sc_hd__decap_12
XFILLER_0_20_116 VGND VGND VPWR VPWR sky130_fd_sc_hd__decap_4
XTAP_TAPCELL_ROW_16_314 VGND VPWR sky130_fd_sc_hd__tapvpwrvgnd_1
XFILLER_0_68_352 VPWR VGND VPWR VGND sky130_ef_sc_hd__decap_12
XTAP_TAPCELL_ROW_24_380 VGND VPWR sky130_fd_sc_hd__tapvpwrvgnd_1
XFILLER_0_3_327 VGND VGND VPWR VPWR sky130_fd_sc_hd__decap_8
X_2500_ _0594_ _0600_ _0660_ VGND VGND VPWR VPWR _0661_ sky130_fd_sc_hd__and3_1
X_3480_ _1072_ _1292_ _1019_ VGND VGND VPWR VPWR _1636_ sky130_fd_sc_hd__o21a_1
XFILLER_0_24_466 VGND VGND VPWR VPWR sky130_fd_sc_hd__decap_8
XFILLER_0_24_477 VGND VGND VPWR VPWR sky130_fd_sc_hd__fill_1
XFILLER_0_51_263 VPWR VGND VPWR VGND sky130_ef_sc_hd__decap_12
X_2431_ IM0.addr\[2\] IM0.addr\[1\] IM0.addr\[28\] IM0.addr\[27\] VGND VGND VPWR VPWR
+ _0592_ sky130_fd_sc_hd__a211o_1
XFILLER_0_11_127 VGND VGND VPWR VPWR sky130_fd_sc_hd__fill_2
X_2362_ _0556_ VGND VGND VPWR VPWR _0481_ sky130_fd_sc_hd__clkbuf_1
X_2293_ IM0.addr\[7\] IM0.addr\[6\] _0517_ VGND VGND VPWR VPWR _0518_ sky130_fd_sc_hd__and3_1
X_4101_ _2127_ VGND VGND VPWR VPWR _0325_ sky130_fd_sc_hd__clkbuf_1
X_4032_ _2013_ RF0.regs\[15\]\[4\] _2082_ VGND VGND VPWR VPWR _2090_ sky130_fd_sc_hd__mux2_1
XFILLER_0_47_98 VGND VGND VPWR VPWR sky130_fd_sc_hd__decap_6
XTAP_TAPCELL_ROW_67_748 VGND VPWR sky130_fd_sc_hd__tapvpwrvgnd_1
XFILLER_0_63_97 VPWR VGND VPWR VGND sky130_ef_sc_hd__decap_12
XTAP_TAPCELL_ROW_50_604 VGND VPWR sky130_fd_sc_hd__tapvpwrvgnd_1
X_4796_ clknet_leaf_7_clk _0446_ _0190_ VGND VGND VPWR VPWR RF0.regs\[5\]\[30\] sky130_fd_sc_hd__dfrtp_1
XFILLER_0_27_271 VGND VGND VPWR VPWR sky130_fd_sc_hd__decap_8
X_3816_ _1862_ _1934_ _1946_ VGND VGND VPWR VPWR _1955_ sky130_fd_sc_hd__a21oi_1
X_3747_ _1629_ _1639_ _1640_ _1887_ VGND VGND VPWR VPWR _1888_ sky130_fd_sc_hd__a2bb2o_1
X_3678_ _1464_ _1459_ _1135_ VGND VGND VPWR VPWR _1828_ sky130_fd_sc_hd__mux2_1
XFILLER_0_42_296 VGND VGND VPWR VPWR sky130_fd_sc_hd__fill_2
X_2629_ _0788_ _0789_ VGND VGND VPWR VPWR _0790_ sky130_fd_sc_hd__nor2_1
XFILLER_0_21_414 VGND VGND VPWR VPWR sky130_fd_sc_hd__decap_3
XFILLER_0_21_436 VGND VGND VPWR VPWR sky130_fd_sc_hd__fill_1
XTAP_TAPCELL_ROW_64_718 VGND VPWR sky130_fd_sc_hd__tapvpwrvgnd_1
XFILLER_0_8_408 VPWR VGND VPWR VGND sky130_ef_sc_hd__decap_12
X_2980_ _1054_ _1041_ _1080_ VGND VGND VPWR VPWR _1140_ sky130_fd_sc_hd__mux2_1
XTAP_TAPCELL_ROW_72_784 VGND VPWR sky130_fd_sc_hd__tapvpwrvgnd_1
X_4650_ clknet_leaf_3_clk _0300_ _0044_ VGND VGND VPWR VPWR RF0.regs\[25\]\[12\] sky130_fd_sc_hd__dfrtp_2
XFILLER_0_56_377 VGND VGND VPWR VPWR sky130_fd_sc_hd__decap_3
X_3601_ RF0.regs\[15\]\[19\] _0609_ _0617_ RF0.regs\[25\]\[19\] VGND VGND VPWR VPWR
+ _1752_ sky130_fd_sc_hd__a22o_1
XFILLER_0_3_113 VGND VGND VPWR VPWR sky130_fd_sc_hd__fill_1
X_4581_ _2285_ VGND VGND VPWR VPWR _0232_ sky130_fd_sc_hd__inv_2
XFILLER_0_24_263 VPWR VGND VPWR VGND sky130_ef_sc_hd__decap_12
X_3532_ _1676_ _1684_ _1685_ VGND VGND VPWR VPWR _1686_ sky130_fd_sc_hd__a21o_1
X_3463_ _1617_ _1618_ VGND VGND VPWR VPWR _1619_ sky130_fd_sc_hd__xor2_1
XFILLER_0_12_469 VGND VGND VPWR VPWR sky130_fd_sc_hd__decap_6
X_2414_ net115 VGND VGND VPWR VPWR _0582_ sky130_fd_sc_hd__clkbuf_1
X_3394_ _1495_ _1503_ _1509_ _1546_ _1550_ VGND VGND VPWR VPWR _1551_ sky130_fd_sc_hd__a221o_1
X_2345_ _0520_ net75 VGND VGND VPWR VPWR _0490_ sky130_fd_sc_hd__nor2_1
XFILLER_0_74_41 VPWR VGND VPWR VGND sky130_ef_sc_hd__decap_12
XFILLER_0_74_85 VGND VGND VPWR VPWR sky130_fd_sc_hd__fill_1
X_4015_ _1990_ RF0.regs\[15\]\[12\] _2071_ VGND VGND VPWR VPWR _2081_ sky130_fd_sc_hd__mux2_1
XFILLER_0_79_447 VGND VGND VPWR VPWR sky130_fd_sc_hd__fill_1
XTAP_TAPCELL_ROW_27_409 VGND VPWR sky130_fd_sc_hd__tapvpwrvgnd_1
XTAP_TAPCELL_ROW_35_475 VGND VPWR sky130_fd_sc_hd__tapvpwrvgnd_1
XFILLER_0_74_152 VGND VGND VPWR VPWR sky130_fd_sc_hd__fill_2
X_4848_ clknet_leaf_26_clk _0498_ _0242_ VGND VGND VPWR VPWR IM0.addr\[18\] sky130_fd_sc_hd__dfrtp_1
XFILLER_0_62_303 VGND VGND VPWR VPWR sky130_fd_sc_hd__decap_4
XFILLER_0_62_358 VGND VGND VPWR VPWR sky130_fd_sc_hd__decap_6
X_4779_ clknet_leaf_1_clk _0429_ _0173_ VGND VGND VPWR VPWR RF0.regs\[5\]\[13\] sky130_fd_sc_hd__dfrtp_1
XFILLER_0_70_391 VGND VGND VPWR VPWR sky130_fd_sc_hd__fill_1
XFILLER_0_65_141 VGND VGND VPWR VPWR sky130_fd_sc_hd__fill_1
XFILLER_0_38_377 VGND VGND VPWR VPWR sky130_fd_sc_hd__fill_1
XFILLER_0_65_163 VGND VGND VPWR VPWR sky130_fd_sc_hd__decap_4
XFILLER_0_28_56 VGND VGND VPWR VPWR sky130_fd_sc_hd__decap_4
XTAP_TAPCELL_ROW_77_832 VGND VPWR sky130_fd_sc_hd__tapvpwrvgnd_1
XTAP_TAPCELL_ROW_49_589 VGND VPWR sky130_fd_sc_hd__tapvpwrvgnd_1
XFILLER_0_29_355 VGND VGND VPWR VPWR sky130_fd_sc_hd__decap_4
X_2963_ _1112_ _1122_ _1037_ VGND VGND VPWR VPWR _1123_ sky130_fd_sc_hd__mux2_1
XFILLER_0_56_141 VGND VGND VPWR VPWR sky130_fd_sc_hd__decap_4
X_4702_ clknet_leaf_25_clk _0352_ _0096_ VGND VGND VPWR VPWR RF0.regs\[15\]\[0\] sky130_fd_sc_hd__dfrtp_1
XFILLER_0_29_388 VGND VGND VPWR VPWR sky130_fd_sc_hd__decap_4
XTAP_TAPCELL_ROW_32_445 VGND VPWR sky130_fd_sc_hd__tapvpwrvgnd_1
X_2894_ _1054_ _0937_ _1042_ VGND VGND VPWR VPWR _1055_ sky130_fd_sc_hd__mux2_1
XFILLER_0_71_111 VGND VGND VPWR VPWR sky130_fd_sc_hd__fill_1
XFILLER_0_4_433 VPWR VGND VPWR VGND sky130_ef_sc_hd__decap_12
X_4633_ clknet_leaf_7_clk _0283_ _0027_ VGND VGND VPWR VPWR RF0.regs\[30\]\[27\] sky130_fd_sc_hd__dfrtp_1
XFILLER_0_71_166 VGND VGND VPWR VPWR sky130_fd_sc_hd__fill_2
X_4564_ _2283_ VGND VGND VPWR VPWR _0217_ sky130_fd_sc_hd__inv_2
X_3515_ RF0.regs\[0\]\[1\] _0602_ _1669_ VGND VGND VPWR VPWR _1670_ sky130_fd_sc_hd__o21a_1
XFILLER_0_4_477 VGND VGND VPWR VPWR sky130_fd_sc_hd__decap_4
X_4495_ _2273_ VGND VGND VPWR VPWR _0158_ sky130_fd_sc_hd__inv_2
X_3446_ _1599_ _1600_ net30 VGND VGND VPWR VPWR _1602_ sky130_fd_sc_hd__mux2_2
X_3377_ RF0.regs\[5\]\[12\] _0634_ _0638_ RF0.regs\[30\]\[12\] _0641_ VGND VGND VPWR
+ VPWR _1534_ sky130_fd_sc_hd__a221o_1
XFILLER_0_40_3 VPWR VGND VPWR VGND sky130_ef_sc_hd__decap_12
X_2328_ _0527_ _0541_ VGND VGND VPWR VPWR _0500_ sky130_fd_sc_hd__nor2_1
XFILLER_0_75_461 VPWR VGND VPWR VGND sky130_ef_sc_hd__decap_12
XTAP_TAPCELL_ROW_74_802 VGND VPWR sky130_fd_sc_hd__tapvpwrvgnd_1
XFILLER_0_58_417 VGND VGND VPWR VPWR sky130_fd_sc_hd__decap_3
XFILLER_0_58_428 VGND VGND VPWR VPWR sky130_fd_sc_hd__decap_8
XFILLER_0_38_130 VGND VGND VPWR VPWR sky130_fd_sc_hd__decap_8
XFILLER_0_26_314 VPWR VGND VPWR VGND sky130_ef_sc_hd__decap_12
XFILLER_0_38_141 VPWR VGND VPWR VGND sky130_ef_sc_hd__decap_12
XFILLER_0_5_208 VGND VGND VPWR VPWR sky130_fd_sc_hd__decap_8
XFILLER_0_1_447 VGND VGND VPWR VPWR sky130_fd_sc_hd__fill_1
X_3300_ _1073_ _1029_ VGND VGND VPWR VPWR _1458_ sky130_fd_sc_hd__nor2_1
X_4280_ _1099_ _1760_ _1761_ _2224_ VGND VGND VPWR VPWR net11 sky130_fd_sc_hd__o31ai_1
X_3231_ _1278_ VGND VGND VPWR VPWR _1390_ sky130_fd_sc_hd__inv_2
X_3162_ _1320_ _1227_ _1020_ VGND VGND VPWR VPWR _1321_ sky130_fd_sc_hd__mux2_1
X_3093_ _1171_ _1175_ _1052_ VGND VGND VPWR VPWR _1253_ sky130_fd_sc_hd__mux2_1
XFILLER_0_49_439 VGND VGND VPWR VPWR sky130_fd_sc_hd__decap_3
X_3995_ _2070_ VGND VGND VPWR VPWR _0374_ sky130_fd_sc_hd__clkbuf_1
XFILLER_0_71_75 VGND VGND VPWR VPWR sky130_fd_sc_hd__decap_3
X_2946_ _1072_ _1052_ _0866_ _1105_ VGND VGND VPWR VPWR _1106_ sky130_fd_sc_hd__a31o_1
XFILLER_0_72_475 VGND VGND VPWR VPWR sky130_fd_sc_hd__fill_1
X_2877_ _1037_ VGND VGND VPWR VPWR _1038_ sky130_fd_sc_hd__clkbuf_4
X_4616_ clknet_leaf_0_clk _0266_ _0010_ VGND VGND VPWR VPWR RF0.regs\[30\]\[10\] sky130_fd_sc_hd__dfrtp_1
XFILLER_0_32_317 VPWR VGND VPWR VGND sky130_ef_sc_hd__decap_12
XFILLER_0_32_339 VPWR VGND VPWR VGND sky130_ef_sc_hd__decap_12
XFILLER_0_25_380 VGND VGND VPWR VPWR sky130_fd_sc_hd__decap_4
XFILLER_0_4_296 VGND VGND VPWR VPWR sky130_fd_sc_hd__decap_3
X_4547_ _2282_ VGND VGND VPWR VPWR _0201_ sky130_fd_sc_hd__inv_2
X_4478_ _2271_ VGND VGND VPWR VPWR _0143_ sky130_fd_sc_hd__inv_2
XFILLER_0_40_383 VGND VGND VPWR VPWR sky130_fd_sc_hd__decap_4
X_3429_ RF0.regs\[15\]\[7\] _0609_ _0629_ RF0.regs\[10\]\[7\] VGND VGND VPWR VPWR
+ _1586_ sky130_fd_sc_hd__a22o_1
XFILLER_0_67_225 VGND VGND VPWR VPWR sky130_fd_sc_hd__fill_1
XTAP_TAPCELL_ROW_0_173 VGND VPWR sky130_fd_sc_hd__tapvpwrvgnd_1
XFILLER_0_48_472 VGND VGND VPWR VPWR sky130_fd_sc_hd__decap_4
XFILLER_0_35_122 VGND VGND VPWR VPWR sky130_fd_sc_hd__decap_3
XFILLER_0_35_155 VGND VGND VPWR VPWR sky130_fd_sc_hd__fill_1
XFILLER_0_23_328 VGND VGND VPWR VPWR sky130_fd_sc_hd__fill_2
XFILLER_0_31_361 VGND VGND VPWR VPWR sky130_fd_sc_hd__decap_6
XTAP_TAPCELL_ROW_8_240 VGND VPWR sky130_fd_sc_hd__tapvpwrvgnd_1
XFILLER_0_25_35 VGND VGND VPWR VPWR sky130_fd_sc_hd__fill_1
XFILLER_0_25_57 VGND VGND VPWR VPWR sky130_fd_sc_hd__decap_4
XFILLER_0_26_122 VGND VGND VPWR VPWR sky130_fd_sc_hd__decap_8
X_3780_ _1065_ _1920_ VGND VGND VPWR VPWR _1921_ sky130_fd_sc_hd__nand2_1
X_2800_ _0959_ _0960_ VGND VGND VPWR VPWR _0961_ sky130_fd_sc_hd__xor2_2
XFILLER_0_66_291 VGND VGND VPWR VPWR sky130_fd_sc_hd__fill_1
XTAP_TAPCELL_ROW_14_297 VGND VPWR sky130_fd_sc_hd__tapvpwrvgnd_1
XFILLER_0_26_133 VGND VGND VPWR VPWR sky130_fd_sc_hd__decap_6
X_2731_ _0822_ _0891_ VGND VGND VPWR VPWR _0892_ sky130_fd_sc_hd__xnor2_2
X_2662_ RF0.regs\[10\]\[9\] _0615_ _0671_ RF0.regs\[25\]\[9\] VGND VGND VPWR VPWR
+ _0823_ sky130_fd_sc_hd__a22oi_4
X_4401_ _2260_ VGND VGND VPWR VPWR _0077_ sky130_fd_sc_hd__inv_2
X_2593_ _0682_ _0753_ VGND VGND VPWR VPWR _0754_ sky130_fd_sc_hd__nand2_1
X_4332_ _2249_ VGND VGND VPWR VPWR _2251_ sky130_fd_sc_hd__buf_4
X_4263_ _1099_ _1559_ _1560_ VGND VGND VPWR VPWR _2214_ sky130_fd_sc_hd__or3_1
X_3214_ _1369_ _1372_ _1135_ VGND VGND VPWR VPWR _1373_ sky130_fd_sc_hd__mux2_1
XFILLER_0_66_53 VPWR VGND VPWR VGND sky130_ef_sc_hd__decap_12
XPHY_EDGE_ROW_19_Left_101 VGND VGND VPWR VPWR sky130_fd_sc_hd__decap_3
X_4194_ _1857_ net153 _2170_ VGND VGND VPWR VPWR _2177_ sky130_fd_sc_hd__mux2_1
X_3145_ _1303_ VGND VGND VPWR VPWR _1304_ sky130_fd_sc_hd__inv_2
X_3076_ _1214_ _1231_ _1235_ VGND VGND VPWR VPWR _1236_ sky130_fd_sc_hd__o21a_1
X_3978_ _1838_ RF0.regs\[15\]\[30\] _2060_ VGND VGND VPWR VPWR _2062_ sky130_fd_sc_hd__mux2_2
X_2929_ RF0.regs\[5\]\[30\] _0635_ _0639_ RF0.regs\[30\]\[30\] _0642_ VGND VGND VPWR
+ VPWR _1089_ sky130_fd_sc_hd__a221o_1
XFILLER_0_72_250 VGND VGND VPWR VPWR sky130_fd_sc_hd__fill_2
XPHY_EDGE_ROW_28_Left_110 VGND VGND VPWR VPWR sky130_fd_sc_hd__decap_3
XFILLER_0_17_199 VGND VGND VPWR VPWR sky130_fd_sc_hd__decap_8
XTAP_TAPCELL_ROW_5_221 VGND VPWR sky130_fd_sc_hd__tapvpwrvgnd_1
XTAP_TAPCELL_ROW_56_654 VGND VPWR sky130_fd_sc_hd__tapvpwrvgnd_1
XFILLER_0_11_15 VGND VGND VPWR VPWR sky130_fd_sc_hd__fill_1
XFILLER_0_36_475 VGND VGND VPWR VPWR sky130_fd_sc_hd__fill_1
XTAP_TAPCELL_ROW_11_267 VGND VPWR sky130_fd_sc_hd__tapvpwrvgnd_1
XFILLER_0_23_147 VPWR VGND VPWR VGND sky130_ef_sc_hd__decap_12
XFILLER_0_23_169 VPWR VGND VPWR VGND sky130_ef_sc_hd__decap_12
XFILLER_0_36_78 VGND VGND VPWR VPWR sky130_fd_sc_hd__decap_6
XTAP_TAPCELL_ROW_19_334 VGND VPWR sky130_fd_sc_hd__tapvpwrvgnd_1
X_3901_ _1676_ _1684_ VGND VGND VPWR VPWR _2020_ sky130_fd_sc_hd__xor2_4
XFILLER_0_46_239 VPWR VGND VPWR VGND sky130_ef_sc_hd__decap_12
X_3832_ _1963_ _1967_ VGND VGND VPWR VPWR _1968_ sky130_fd_sc_hd__nor2_1
XFILLER_0_27_453 VGND VGND VPWR VPWR sky130_fd_sc_hd__decap_4
XFILLER_0_6_369 VGND VGND VPWR VPWR sky130_fd_sc_hd__decap_8
X_3763_ _1097_ _1559_ _1560_ _1001_ _1903_ VGND VGND VPWR VPWR _1904_ sky130_fd_sc_hd__o32a_1
XFILLER_0_42_401 VPWR VGND VPWR VGND sky130_ef_sc_hd__decap_12
X_3694_ _1201_ _1826_ VGND VGND VPWR VPWR _1841_ sky130_fd_sc_hd__nor2_1
X_2714_ _0870_ _0873_ _0874_ VGND VGND VPWR VPWR _0875_ sky130_fd_sc_hd__a21bo_1
X_2645_ RF0.regs\[10\]\[11\] _0613_ _0669_ RF0.regs\[25\]\[11\] VGND VGND VPWR VPWR
+ _0806_ sky130_fd_sc_hd__a22o_1
X_4315_ _2248_ VGND VGND VPWR VPWR _0003_ sky130_fd_sc_hd__inv_2
X_2576_ RF0.regs\[15\]\[14\] _0663_ _0668_ RF0.regs\[5\]\[14\] VGND VGND VPWR VPWR
+ _0737_ sky130_fd_sc_hd__a22o_1
X_4246_ _2095_ net154 _2169_ VGND VGND VPWR VPWR _2204_ sky130_fd_sc_hd__mux2_1
X_4177_ _2167_ VGND VGND VPWR VPWR _0289_ sky130_fd_sc_hd__clkbuf_1
X_3128_ _1057_ _1287_ VGND VGND VPWR VPWR _1288_ sky130_fd_sc_hd__nor2_1
X_3059_ _1217_ _1218_ _1010_ VGND VGND VPWR VPWR _1219_ sky130_fd_sc_hd__mux2_1
XTAP_TAPCELL_ROW_53_624 VGND VPWR sky130_fd_sc_hd__tapvpwrvgnd_1
XFILLER_0_33_434 VPWR VGND VPWR VGND sky130_ef_sc_hd__decap_12
XFILLER_0_5_380 VGND VGND VPWR VPWR sky130_fd_sc_hd__fill_1
XTAP_TAPCELL_ROW_16_315 VGND VPWR sky130_fd_sc_hd__tapvpwrvgnd_1
XFILLER_0_68_342 VGND VGND VPWR VPWR sky130_fd_sc_hd__decap_3
XFILLER_0_22_14 VGND VGND VPWR VPWR sky130_fd_sc_hd__fill_1
XFILLER_0_22_25 VGND VGND VPWR VPWR sky130_fd_sc_hd__decap_3
XFILLER_0_28_217 VGND VGND VPWR VPWR sky130_fd_sc_hd__fill_1
XTAP_TAPCELL_ROW_24_381 VGND VPWR sky130_fd_sc_hd__tapvpwrvgnd_1
X_2430_ IM0.addr\[9\] IM0.addr\[6\] IM0.addr\[5\] IM0.addr\[3\] VGND VGND VPWR VPWR
+ _0591_ sky130_fd_sc_hd__or4_4
XFILLER_0_11_117 VGND VGND VPWR VPWR sky130_fd_sc_hd__fill_1
XFILLER_0_51_275 VGND VGND VPWR VPWR sky130_fd_sc_hd__decap_4
X_2361_ _0513_ _0555_ _0512_ VGND VGND VPWR VPWR _0556_ sky130_fd_sc_hd__mux2_1
X_2292_ IM0.addr\[5\] _0516_ VGND VGND VPWR VPWR _0517_ sky130_fd_sc_hd__and2_1
X_4100_ RF0.regs\[20\]\[5\] _2011_ _2120_ VGND VGND VPWR VPWR _2127_ sky130_fd_sc_hd__mux2_1
XFILLER_0_47_55 VGND VGND VPWR VPWR sky130_fd_sc_hd__fill_1
X_4031_ _2089_ VGND VGND VPWR VPWR _0357_ sky130_fd_sc_hd__clkbuf_1
XTAP_TAPCELL_ROW_67_749 VGND VPWR sky130_fd_sc_hd__tapvpwrvgnd_1
XFILLER_0_63_87 VGND VGND VPWR VPWR sky130_fd_sc_hd__fill_1
XTAP_TAPCELL_ROW_50_605 VGND VPWR sky130_fd_sc_hd__tapvpwrvgnd_1
XFILLER_0_6_100 VGND VGND VPWR VPWR sky130_fd_sc_hd__decap_3
X_4795_ clknet_leaf_7_clk _0445_ _0189_ VGND VGND VPWR VPWR RF0.regs\[5\]\[29\] sky130_fd_sc_hd__dfrtp_1
X_3815_ _1954_ VGND VGND VPWR VPWR _0438_ sky130_fd_sc_hd__clkbuf_1
X_3746_ _1651_ _1886_ _1688_ VGND VGND VPWR VPWR _1887_ sky130_fd_sc_hd__a21o_1
XFILLER_0_42_253 VGND VGND VPWR VPWR sky130_fd_sc_hd__decap_6
X_3677_ RF0.regs\[0\]\[29\] _0605_ _1235_ VGND VGND VPWR VPWR _1827_ sky130_fd_sc_hd__o21a_1
XFILLER_0_42_275 VGND VGND VPWR VPWR sky130_fd_sc_hd__decap_4
XFILLER_0_70_3 VPWR VGND VPWR VGND sky130_ef_sc_hd__decap_12
X_2628_ RF0.regs\[10\]\[24\] _0617_ _0675_ RF0.regs\[25\]\[24\] VGND VGND VPWR VPWR
+ _0789_ sky130_fd_sc_hd__a22o_1
X_2559_ RF0.regs\[15\]\[0\] net69 net39 _0660_ VGND VGND VPWR VPWR _0720_ sky130_fd_sc_hd__and4_1
X_4229_ _2195_ VGND VGND VPWR VPWR _0265_ sky130_fd_sc_hd__clkbuf_1
XFILLER_0_77_150 VGND VGND VPWR VPWR sky130_fd_sc_hd__decap_3
XTAP_TAPCELL_ROW_38_495 VGND VPWR sky130_fd_sc_hd__tapvpwrvgnd_1
XFILLER_0_77_161 VGND VGND VPWR VPWR sky130_fd_sc_hd__decap_6
XFILLER_0_65_334 VGND VGND VPWR VPWR sky130_fd_sc_hd__fill_2
XTAP_TAPCELL_ROW_21_351 VGND VPWR sky130_fd_sc_hd__tapvpwrvgnd_1
XFILLER_0_33_297 VGND VGND VPWR VPWR sky130_fd_sc_hd__fill_1
XTAP_TAPCELL_ROW_64_719 VGND VPWR sky130_fd_sc_hd__tapvpwrvgnd_1
XFILLER_0_33_35 VGND VGND VPWR VPWR sky130_fd_sc_hd__fill_1
XFILLER_0_68_172 VPWR VGND VPWR VGND sky130_ef_sc_hd__decap_12
XTAP_TAPCELL_ROW_72_785 VGND VPWR sky130_fd_sc_hd__tapvpwrvgnd_1
X_4580_ _2285_ VGND VGND VPWR VPWR _0231_ sky130_fd_sc_hd__inv_2
X_3600_ RF0.regs\[5\]\[19\] _0633_ _0637_ RF0.regs\[30\]\[19\] _0640_ VGND VGND VPWR
+ VPWR _1751_ sky130_fd_sc_hd__a221o_1
XFILLER_0_71_337 VPWR VGND VPWR VGND sky130_ef_sc_hd__decap_12
X_3531_ _1669_ net12 VGND VGND VPWR VPWR _1685_ sky130_fd_sc_hd__and2_1
XFILLER_0_24_253 VGND VGND VPWR VPWR sky130_fd_sc_hd__decap_6
XFILLER_0_24_275 VGND VGND VPWR VPWR sky130_fd_sc_hd__decap_4
X_3462_ _0856_ _0885_ VGND VGND VPWR VPWR _1618_ sky130_fd_sc_hd__nor2_1
X_2413_ _0581_ VGND VGND VPWR VPWR _0455_ sky130_fd_sc_hd__clkbuf_1
X_3393_ _1547_ _1549_ _1499_ VGND VGND VPWR VPWR _1550_ sky130_fd_sc_hd__a21boi_1
XFILLER_0_20_481 VGND VGND VPWR VPWR sky130_fd_sc_hd__fill_1
X_2344_ IM0.addr\[9\] _0519_ net74 VGND VGND VPWR VPWR _0548_ sky130_fd_sc_hd__a21oi_1
Xclkbuf_1_0__f_clk clknet_0_clk VGND VGND VPWR VPWR clknet_1_0__leaf_clk sky130_fd_sc_hd__clkbuf_16
XFILLER_0_74_53 VPWR VGND VPWR VGND sky130_ef_sc_hd__decap_12
X_4014_ _2080_ VGND VGND VPWR VPWR _0365_ sky130_fd_sc_hd__clkbuf_1
XTAP_TAPCELL_ROW_35_476 VGND VPWR sky130_fd_sc_hd__tapvpwrvgnd_1
X_4847_ clknet_leaf_26_clk _0497_ _0241_ VGND VGND VPWR VPWR IM0.addr\[17\] sky130_fd_sc_hd__dfrtp_1
XFILLER_0_74_186 VGND VGND VPWR VPWR sky130_fd_sc_hd__fill_1
X_4778_ clknet_leaf_0_clk _0428_ _0172_ VGND VGND VPWR VPWR RF0.regs\[5\]\[12\] sky130_fd_sc_hd__dfrtp_1
XFILLER_0_15_275 VGND VGND VPWR VPWR sky130_fd_sc_hd__decap_4
X_3729_ _1538_ _1869_ _1541_ VGND VGND VPWR VPWR _1870_ sky130_fd_sc_hd__a21o_1
XFILLER_0_30_289 VGND VGND VPWR VPWR sky130_fd_sc_hd__decap_6
XFILLER_0_11_481 VGND VGND VPWR VPWR sky130_fd_sc_hd__fill_1
XFILLER_0_78_481 VGND VGND VPWR VPWR sky130_fd_sc_hd__fill_1
XFILLER_0_80_112 VGND VGND VPWR VPWR sky130_fd_sc_hd__decap_4
XFILLER_0_80_167 VGND VGND VPWR VPWR sky130_fd_sc_hd__fill_2
XFILLER_0_53_359 VGND VGND VPWR VPWR sky130_fd_sc_hd__fill_1
XFILLER_0_61_381 VGND VGND VPWR VPWR sky130_fd_sc_hd__decap_8
XFILLER_0_21_245 VGND VGND VPWR VPWR sky130_fd_sc_hd__fill_1
XFILLER_0_0_139 VGND VGND VPWR VPWR sky130_fd_sc_hd__fill_1
XFILLER_0_28_35 VGND VGND VPWR VPWR sky130_fd_sc_hd__fill_1
XTAP_TAPCELL_ROW_77_833 VGND VPWR sky130_fd_sc_hd__tapvpwrvgnd_1
XFILLER_0_29_301 VGND VGND VPWR VPWR sky130_fd_sc_hd__decap_4
XFILLER_0_69_481 VGND VGND VPWR VPWR sky130_fd_sc_hd__fill_1
X_2962_ _1117_ _1121_ _1020_ VGND VGND VPWR VPWR _1122_ sky130_fd_sc_hd__mux2_1
X_4701_ clknet_leaf_8_clk _0351_ _0095_ VGND VGND VPWR VPWR RF0.regs\[20\]\[31\] sky130_fd_sc_hd__dfrtp_1
XTAP_TAPCELL_ROW_32_446 VGND VPWR sky130_fd_sc_hd__tapvpwrvgnd_1
X_2893_ RF0.regs\[10\]\[19\] _0616_ _0673_ RF0.regs\[25\]\[19\] VGND VGND VPWR VPWR
+ _1054_ sky130_fd_sc_hd__a22oi_4
XFILLER_0_56_197 VGND VGND VPWR VPWR sky130_fd_sc_hd__fill_2
X_4632_ clknet_leaf_7_clk _0282_ _0026_ VGND VGND VPWR VPWR RF0.regs\[30\]\[26\] sky130_fd_sc_hd__dfrtp_1
XFILLER_0_8_34 VGND VGND VPWR VPWR sky130_fd_sc_hd__decap_4
XFILLER_0_4_445 VPWR VGND VPWR VGND sky130_ef_sc_hd__decap_12
X_4563_ _2283_ VGND VGND VPWR VPWR _0216_ sky130_fd_sc_hd__inv_2
X_4494_ _2273_ VGND VGND VPWR VPWR _0157_ sky130_fd_sc_hd__inv_2
X_3514_ RF0.regs\[20\]\[1\] _0622_ _1668_ VGND VGND VPWR VPWR _1669_ sky130_fd_sc_hd__a21o_1
XFILLER_0_8_89 VGND VGND VPWR VPWR sky130_fd_sc_hd__fill_1
X_3445_ _0651_ _1595_ _1596_ _1083_ _1601_ VGND VGND VPWR VPWR net30 sky130_fd_sc_hd__a32o_1
X_3376_ RF0.regs\[0\]\[13\] _0604_ _1513_ _1532_ VGND VGND VPWR VPWR _1533_ sky130_fd_sc_hd__a2bb2o_1
X_2327_ net82 _0526_ VGND VGND VPWR VPWR _0541_ sky130_fd_sc_hd__nor2_1
XFILLER_0_33_3 VPWR VGND VPWR VGND sky130_ef_sc_hd__decap_12
XFILLER_0_39_109 VGND VGND VPWR VPWR sky130_fd_sc_hd__decap_3
XFILLER_0_75_473 VGND VGND VPWR VPWR sky130_fd_sc_hd__decap_8
XFILLER_0_35_337 VGND VGND VPWR VPWR sky130_fd_sc_hd__fill_2
XTAP_TAPCELL_ROW_74_803 VGND VPWR sky130_fd_sc_hd__tapvpwrvgnd_1
XFILLER_0_14_37 VGND VGND VPWR VPWR sky130_fd_sc_hd__decap_6
XFILLER_0_38_153 VGND VGND VPWR VPWR sky130_fd_sc_hd__decap_4
XFILLER_0_81_421 VPWR VGND VPWR VGND sky130_ef_sc_hd__decap_12
XFILLER_0_26_326 VPWR VGND VPWR VGND sky130_ef_sc_hd__decap_12
XFILLER_0_38_197 VPWR VGND VPWR VGND sky130_ef_sc_hd__decap_12
XFILLER_0_53_101 VGND VGND VPWR VPWR sky130_fd_sc_hd__decap_8
X_3230_ _1039_ _1388_ VGND VGND VPWR VPWR _1389_ sky130_fd_sc_hd__nor2_1
X_3161_ _1253_ _1256_ _1073_ VGND VGND VPWR VPWR _1320_ sky130_fd_sc_hd__mux2_1
XFILLER_0_55_55 VGND VGND VPWR VPWR sky130_fd_sc_hd__fill_1
X_3092_ _1248_ _1251_ _1058_ VGND VGND VPWR VPWR _1252_ sky130_fd_sc_hd__mux2_1
XTAP_TAPCELL_ROW_45_560 VGND VPWR sky130_fd_sc_hd__tapvpwrvgnd_1
X_3994_ _1953_ RF0.regs\[15\]\[22\] _2060_ VGND VGND VPWR VPWR _2070_ sky130_fd_sc_hd__mux2_1
XFILLER_0_72_421 VPWR VGND VPWR VGND sky130_ef_sc_hd__decap_12
X_2945_ _1009_ _1104_ VGND VGND VPWR VPWR _1105_ sky130_fd_sc_hd__and2_1
XFILLER_0_17_337 VGND VGND VPWR VPWR sky130_fd_sc_hd__decap_8
X_2876_ _1036_ VGND VGND VPWR VPWR _1037_ sky130_fd_sc_hd__clkbuf_4
X_4615_ clknet_leaf_0_clk _0265_ _0009_ VGND VGND VPWR VPWR RF0.regs\[30\]\[9\] sky130_fd_sc_hd__dfrtp_1
XFILLER_0_32_329 VGND VGND VPWR VPWR sky130_fd_sc_hd__fill_1
XFILLER_0_4_275 VPWR VGND VPWR VGND sky130_ef_sc_hd__decap_12
X_4546_ _2282_ VGND VGND VPWR VPWR _0200_ sky130_fd_sc_hd__inv_2
X_4477_ _2271_ VGND VGND VPWR VPWR _0142_ sky130_fd_sc_hd__inv_2
XFILLER_0_0_481 VGND VGND VPWR VPWR sky130_fd_sc_hd__fill_1
X_3428_ RF0.regs\[5\]\[7\] _0633_ _0637_ RF0.regs\[30\]\[7\] _0640_ VGND VGND VPWR
+ VPWR _1585_ sky130_fd_sc_hd__a221o_1
X_3359_ _1072_ _1515_ VGND VGND VPWR VPWR _1516_ sky130_fd_sc_hd__nor2_1
XPHY_EDGE_ROW_13_Left_95 VGND VGND VPWR VPWR sky130_fd_sc_hd__decap_3
XTAP_TAPCELL_ROW_0_174 VGND VPWR sky130_fd_sc_hd__tapvpwrvgnd_1
XTAP_TAPCELL_ROW_8_241 VGND VPWR sky130_fd_sc_hd__tapvpwrvgnd_1
XTAP_TAPCELL_ROW_59_674 VGND VPWR sky130_fd_sc_hd__tapvpwrvgnd_1
XTAP_TAPCELL_ROW_42_530 VGND VPWR sky130_fd_sc_hd__tapvpwrvgnd_1
XFILLER_0_26_101 VGND VGND VPWR VPWR sky130_fd_sc_hd__fill_1
XFILLER_0_41_35 VGND VGND VPWR VPWR sky130_fd_sc_hd__fill_1
XTAP_TAPCELL_ROW_14_298 VGND VPWR sky130_fd_sc_hd__tapvpwrvgnd_1
X_2730_ RF0.regs\[10\]\[9\] _0614_ _0670_ RF0.regs\[25\]\[9\] VGND VGND VPWR VPWR
+ _0891_ sky130_fd_sc_hd__a22o_1
XFILLER_0_54_454 VGND VGND VPWR VPWR sky130_fd_sc_hd__fill_1
X_2661_ _0658_ _0820_ _0821_ _0717_ VGND VGND VPWR VPWR _0822_ sky130_fd_sc_hd__a31o_4
X_4400_ _2260_ VGND VGND VPWR VPWR _0076_ sky130_fd_sc_hd__inv_2
X_2592_ _0684_ _0752_ VGND VGND VPWR VPWR _0753_ sky130_fd_sc_hd__nor2_1
X_4331_ _2250_ VGND VGND VPWR VPWR _0017_ sky130_fd_sc_hd__inv_2
XFILLER_0_1_278 VGND VGND VPWR VPWR sky130_fd_sc_hd__fill_2
X_4262_ _1085_ _1402_ _1892_ VGND VGND VPWR VPWR net31 sky130_fd_sc_hd__a21o_1
X_3213_ _1370_ _1371_ _1063_ VGND VGND VPWR VPWR _1372_ sky130_fd_sc_hd__mux2_1
XFILLER_0_66_65 VPWR VGND VPWR VGND sky130_ef_sc_hd__decap_12
X_4193_ _2176_ VGND VGND VPWR VPWR _0282_ sky130_fd_sc_hd__clkbuf_1
X_3144_ _1275_ _1274_ net19 VGND VGND VPWR VPWR _1303_ sky130_fd_sc_hd__mux2_1
X_3075_ _1232_ _1234_ VGND VGND VPWR VPWR _1235_ sky130_fd_sc_hd__or2_1
XFILLER_0_9_301 VGND VGND VPWR VPWR sky130_fd_sc_hd__decap_8
XFILLER_0_9_334 VGND VGND VPWR VPWR sky130_fd_sc_hd__fill_2
X_3977_ _2061_ VGND VGND VPWR VPWR _0383_ sky130_fd_sc_hd__clkbuf_1
XFILLER_0_57_281 VGND VGND VPWR VPWR sky130_fd_sc_hd__decap_8
X_2928_ _0646_ _0645_ net25 VGND VGND VPWR VPWR _1088_ sky130_fd_sc_hd__mux2_1
XFILLER_0_60_402 VPWR VGND VPWR VGND sky130_ef_sc_hd__decap_12
X_2859_ _1019_ VGND VGND VPWR VPWR _1020_ sky130_fd_sc_hd__clkbuf_4
XFILLER_0_60_468 VGND VGND VPWR VPWR sky130_fd_sc_hd__decap_8
XFILLER_0_13_373 VGND VGND VPWR VPWR sky130_fd_sc_hd__decap_8
XFILLER_0_40_181 VGND VGND VPWR VPWR sky130_fd_sc_hd__fill_2
X_4529_ _2278_ VGND VGND VPWR VPWR _0187_ sky130_fd_sc_hd__inv_2
XTAP_TAPCELL_ROW_5_222 VGND VPWR sky130_fd_sc_hd__tapvpwrvgnd_1
XTAP_TAPCELL_ROW_56_655 VGND VPWR sky130_fd_sc_hd__tapvpwrvgnd_1
XFILLER_0_36_421 VGND VGND VPWR VPWR sky130_fd_sc_hd__decap_4
XFILLER_0_51_402 VGND VGND VPWR VPWR sky130_fd_sc_hd__decap_8
XTAP_TAPCELL_ROW_11_268 VGND VPWR sky130_fd_sc_hd__tapvpwrvgnd_1
XFILLER_0_23_137 VGND VGND VPWR VPWR sky130_fd_sc_hd__decap_4
XTAP_TAPCELL_ROW_19_335 VGND VPWR sky130_fd_sc_hd__tapvpwrvgnd_1
X_3900_ _2019_ VGND VGND VPWR VPWR _0418_ sky130_fd_sc_hd__clkbuf_1
XFILLER_0_27_410 VGND VGND VPWR VPWR sky130_fd_sc_hd__decap_6
X_3831_ _1787_ _1961_ _1962_ VGND VGND VPWR VPWR _1967_ sky130_fd_sc_hd__and3_1
XFILLER_0_52_78 VGND VGND VPWR VPWR sky130_fd_sc_hd__fill_2
X_3762_ _1291_ _1662_ _1780_ _1300_ VGND VGND VPWR VPWR _1903_ sky130_fd_sc_hd__a22oi_1
XFILLER_0_42_413 VGND VGND VPWR VPWR sky130_fd_sc_hd__decap_6
X_3693_ _1235_ net22 _1830_ VGND VGND VPWR VPWR _1840_ sky130_fd_sc_hd__a21bo_1
X_2713_ _0716_ _0871_ _0872_ VGND VGND VPWR VPWR _0874_ sky130_fd_sc_hd__nand3_1
X_2644_ _0729_ _0733_ _0705_ VGND VGND VPWR VPWR _0805_ sky130_fd_sc_hd__o21a_1
X_2575_ _0657_ _0735_ VGND VGND VPWR VPWR _0736_ sky130_fd_sc_hd__and2_1
X_4314_ _2248_ VGND VGND VPWR VPWR _0002_ sky130_fd_sc_hd__inv_2
XFILLER_0_22_192 VGND VGND VPWR VPWR sky130_fd_sc_hd__decap_4
XFILLER_0_10_387 VGND VGND VPWR VPWR sky130_fd_sc_hd__decap_3
XFILLER_0_10_365 VGND VGND VPWR VPWR sky130_fd_sc_hd__fill_1
X_4245_ _2203_ VGND VGND VPWR VPWR _0257_ sky130_fd_sc_hd__clkbuf_1
X_4176_ _2020_ RF0.regs\[25\]\[1\] _2133_ VGND VGND VPWR VPWR _2167_ sky130_fd_sc_hd__mux2_1
X_3127_ _1285_ _1286_ _1074_ VGND VGND VPWR VPWR _1287_ sky130_fd_sc_hd__mux2_1
XFILLER_0_77_332 VGND VGND VPWR VPWR sky130_fd_sc_hd__fill_1
XFILLER_0_77_321 VGND VGND VPWR VPWR sky130_fd_sc_hd__fill_2
X_3058_ _1109_ _0883_ _1003_ VGND VGND VPWR VPWR _1218_ sky130_fd_sc_hd__mux2_1
XTAP_TAPCELL_ROW_53_625 VGND VPWR sky130_fd_sc_hd__tapvpwrvgnd_1
XFILLER_0_37_207 VGND VGND VPWR VPWR sky130_fd_sc_hd__decap_4
XFILLER_0_18_421 VGND VGND VPWR VPWR sky130_fd_sc_hd__decap_8
XFILLER_0_33_402 VGND VGND VPWR VPWR sky130_fd_sc_hd__decap_4
XTAP_TAPCELL_ROW_61_691 VGND VPWR sky130_fd_sc_hd__tapvpwrvgnd_1
XFILLER_0_33_446 VGND VGND VPWR VPWR sky130_fd_sc_hd__fill_2
XFILLER_0_60_287 VGND VGND VPWR VPWR sky130_fd_sc_hd__decap_4
XTAP_TAPCELL_ROW_16_316 VGND VPWR sky130_fd_sc_hd__tapvpwrvgnd_1
XFILLER_0_68_365 VGND VGND VPWR VPWR sky130_fd_sc_hd__fill_2
XFILLER_0_22_48 VGND VGND VPWR VPWR sky130_fd_sc_hd__decap_6
XTAP_TAPCELL_ROW_24_382 VGND VPWR sky130_fd_sc_hd__tapvpwrvgnd_1
XFILLER_0_36_273 VGND VGND VPWR VPWR sky130_fd_sc_hd__decap_4
XFILLER_0_36_295 VGND VGND VPWR VPWR sky130_fd_sc_hd__decap_8
XPHY_EDGE_ROW_47_Left_129 VGND VGND VPWR VPWR sky130_fd_sc_hd__decap_3
X_2360_ IM0.addr\[1\] IM0.addr\[0\] VGND VGND VPWR VPWR _0555_ sky130_fd_sc_hd__xor2_1
X_2291_ IM0.addr\[4\] IM0.addr\[3\] _0515_ VGND VGND VPWR VPWR _0516_ sky130_fd_sc_hd__and3_1
XPHY_EDGE_ROW_10_Right_10 VGND VGND VPWR VPWR sky130_fd_sc_hd__decap_3
X_4030_ _2011_ RF0.regs\[15\]\[5\] _2082_ VGND VGND VPWR VPWR _2089_ sky130_fd_sc_hd__mux2_1
XPHY_EDGE_ROW_56_Left_138 VGND VGND VPWR VPWR sky130_fd_sc_hd__decap_3
XFILLER_0_63_55 VGND VGND VPWR VPWR sky130_fd_sc_hd__fill_1
XFILLER_0_19_218 VGND VGND VPWR VPWR sky130_fd_sc_hd__decap_6
XFILLER_0_74_357 VGND VGND VPWR VPWR sky130_fd_sc_hd__decap_6
X_4794_ clknet_leaf_7_clk _0444_ _0188_ VGND VGND VPWR VPWR RF0.regs\[5\]\[28\] sky130_fd_sc_hd__dfrtp_1
XFILLER_0_6_123 VGND VGND VPWR VPWR sky130_fd_sc_hd__decap_4
XFILLER_0_27_251 VGND VGND VPWR VPWR sky130_fd_sc_hd__fill_1
X_3814_ _1953_ RF0.regs\[5\]\[22\] _1835_ VGND VGND VPWR VPWR _1954_ sky130_fd_sc_hd__mux2_1
XFILLER_0_12_81 VGND VGND VPWR VPWR sky130_fd_sc_hd__decap_3
X_3745_ _1655_ _1664_ _1665_ _1885_ VGND VGND VPWR VPWR _1886_ sky130_fd_sc_hd__a2bb2o_1
XFILLER_0_6_178 VPWR VGND VPWR VGND sky130_ef_sc_hd__decap_12
XPHY_EDGE_ROW_65_Left_147 VGND VGND VPWR VPWR sky130_fd_sc_hd__decap_3
X_3676_ _1380_ _1814_ _1825_ VGND VGND VPWR VPWR _1826_ sky130_fd_sc_hd__a21oi_4
XFILLER_0_2_384 VPWR VGND VPWR VGND sky130_ef_sc_hd__decap_12
XFILLER_0_63_3 VPWR VGND VPWR VGND sky130_ef_sc_hd__decap_12
X_2627_ _0787_ VGND VGND VPWR VPWR _0788_ sky130_fd_sc_hd__inv_2
X_2558_ RF0.regs\[5\]\[0\] net69 net39 _0665_ VGND VGND VPWR VPWR _0719_ sky130_fd_sc_hd__and4_1
X_2489_ _0649_ VGND VGND VPWR VPWR _0650_ sky130_fd_sc_hd__buf_2
X_4228_ _2001_ net156 _2192_ VGND VGND VPWR VPWR _2195_ sky130_fd_sc_hd__mux2_1
XPHY_EDGE_ROW_74_Left_156 VGND VGND VPWR VPWR sky130_fd_sc_hd__decap_3
X_4159_ _2158_ VGND VGND VPWR VPWR _0298_ sky130_fd_sc_hd__clkbuf_1
XFILLER_0_77_140 VGND VGND VPWR VPWR sky130_fd_sc_hd__fill_1
XTAP_TAPCELL_ROW_38_496 VGND VPWR sky130_fd_sc_hd__tapvpwrvgnd_1
XTAP_TAPCELL_ROW_21_352 VGND VPWR sky130_fd_sc_hd__tapvpwrvgnd_1
XFILLER_0_33_221 VGND VGND VPWR VPWR sky130_fd_sc_hd__decap_3
XFILLER_0_21_449 VPWR VGND VPWR VGND sky130_ef_sc_hd__decap_12
XPHY_EDGE_ROW_1_Left_83 VGND VGND VPWR VPWR sky130_fd_sc_hd__decap_3
Xclkbuf_leaf_26_clk clknet_1_0__leaf_clk VGND VGND VPWR VPWR clknet_leaf_26_clk sky130_fd_sc_hd__clkbuf_8
XFILLER_0_68_184 VGND VGND VPWR VPWR sky130_fd_sc_hd__fill_1
XTAP_TAPCELL_ROW_72_786 VGND VPWR sky130_fd_sc_hd__tapvpwrvgnd_1
XFILLER_0_24_210 VGND VGND VPWR VPWR sky130_fd_sc_hd__decap_8
XFILLER_0_71_349 VPWR VGND VPWR VGND sky130_ef_sc_hd__decap_12
X_3530_ _1680_ _1683_ VGND VGND VPWR VPWR _1684_ sky130_fd_sc_hd__nor2_2
XFILLER_0_24_287 VPWR VGND VPWR VGND sky130_ef_sc_hd__decap_12
X_3461_ _0861_ _0882_ _0884_ VGND VGND VPWR VPWR _1617_ sky130_fd_sc_hd__a21o_1
X_2412_ net149 VGND VGND VPWR VPWR _0581_ sky130_fd_sc_hd__clkbuf_1
XFILLER_0_20_460 VPWR VGND VPWR VGND sky130_ef_sc_hd__decap_12
X_3392_ _1548_ _1204_ VGND VGND VPWR VPWR _1549_ sky130_fd_sc_hd__nand2_1
X_2343_ _0521_ _0547_ VGND VGND VPWR VPWR _0491_ sky130_fd_sc_hd__nor2_1
X_4013_ _1988_ RF0.regs\[15\]\[13\] _2071_ VGND VGND VPWR VPWR _2080_ sky130_fd_sc_hd__mux2_1
XFILLER_0_79_405 VPWR VGND VPWR VGND sky130_ef_sc_hd__decap_12
XFILLER_0_74_65 VPWR VGND VPWR VGND sky130_ef_sc_hd__decap_12
XFILLER_0_79_449 VPWR VGND VPWR VGND sky130_ef_sc_hd__decap_12
Xclkbuf_leaf_17_clk clknet_1_0__leaf_clk VGND VGND VPWR VPWR clknet_leaf_17_clk sky130_fd_sc_hd__clkbuf_8
XFILLER_0_59_173 VPWR VGND VPWR VGND sky130_ef_sc_hd__decap_12
XTAP_TAPCELL_ROW_35_477 VGND VPWR sky130_fd_sc_hd__tapvpwrvgnd_1
X_4846_ clknet_leaf_27_clk _0496_ _0240_ VGND VGND VPWR VPWR IM0.addr\[16\] sky130_fd_sc_hd__dfrtp_1
XFILLER_0_7_410 VPWR VGND VPWR VGND sky130_ef_sc_hd__decap_12
XFILLER_0_15_221 VGND VGND VPWR VPWR sky130_fd_sc_hd__decap_3
X_4777_ clknet_leaf_0_clk _0427_ _0171_ VGND VGND VPWR VPWR RF0.regs\[5\]\[11\] sky130_fd_sc_hd__dfrtp_1
X_3728_ _1300_ _1868_ _1637_ _1291_ VGND VGND VPWR VPWR _1869_ sky130_fd_sc_hd__a22o_1
XFILLER_0_30_246 VGND VGND VPWR VPWR sky130_fd_sc_hd__decap_6
X_3659_ _1409_ VGND VGND VPWR VPWR _1810_ sky130_fd_sc_hd__inv_2
XFILLER_0_2_181 VGND VGND VPWR VPWR sky130_fd_sc_hd__decap_3
XTAP_TAPCELL_ROW_26_400 VGND VPWR sky130_fd_sc_hd__tapvpwrvgnd_1
XFILLER_0_38_324 VGND VGND VPWR VPWR sky130_fd_sc_hd__decap_6
XFILLER_0_38_346 VPWR VGND VPWR VGND sky130_ef_sc_hd__decap_12
XFILLER_0_53_316 VGND VGND VPWR VPWR sky130_fd_sc_hd__decap_3
XFILLER_0_65_198 VGND VGND VPWR VPWR sky130_fd_sc_hd__fill_1
XFILLER_0_61_393 VPWR VGND VPWR VGND sky130_ef_sc_hd__decap_12
XTAP_TAPCELL_ROW_77_834 VGND VPWR sky130_fd_sc_hd__tapvpwrvgnd_1
XFILLER_0_29_335 VGND VGND VPWR VPWR sky130_fd_sc_hd__fill_1
XFILLER_0_29_346 VGND VGND VPWR VPWR sky130_fd_sc_hd__fill_1
X_2961_ _1118_ _1120_ _1010_ VGND VGND VPWR VPWR _1121_ sky130_fd_sc_hd__mux2_1
X_4700_ clknet_leaf_8_clk _0350_ _0094_ VGND VGND VPWR VPWR RF0.regs\[20\]\[30\] sky130_fd_sc_hd__dfrtp_1
XTAP_TAPCELL_ROW_32_447 VGND VPWR sky130_fd_sc_hd__tapvpwrvgnd_1
XFILLER_0_56_165 VGND VGND VPWR VPWR sky130_fd_sc_hd__fill_1
X_2892_ _1051_ _0945_ _1052_ VGND VGND VPWR VPWR _1053_ sky130_fd_sc_hd__mux2_1
X_4631_ clknet_leaf_7_clk _0281_ _0025_ VGND VGND VPWR VPWR RF0.regs\[30\]\[25\] sky130_fd_sc_hd__dfrtp_1
XFILLER_0_8_24 VGND VGND VPWR VPWR sky130_fd_sc_hd__decap_4
XFILLER_0_4_457 VPWR VGND VPWR VGND sky130_ef_sc_hd__decap_12
X_4562_ _2283_ VGND VGND VPWR VPWR _0215_ sky130_fd_sc_hd__inv_2
X_4493_ _2273_ VGND VGND VPWR VPWR _0156_ sky130_fd_sc_hd__inv_2
X_3513_ RF0.regs\[10\]\[1\] _0628_ _0614_ RF0.regs\[25\]\[1\] _1667_ VGND VGND VPWR
+ VPWR _1668_ sky130_fd_sc_hd__a221o_1
X_3444_ _1033_ _1433_ VGND VGND VPWR VPWR _1601_ sky130_fd_sc_hd__nor2_1
Xclkbuf_leaf_6_clk clknet_1_1__leaf_clk VGND VGND VPWR VPWR clknet_leaf_6_clk sky130_fd_sc_hd__clkbuf_8
X_3375_ _1204_ _1527_ _1531_ VGND VGND VPWR VPWR _1532_ sky130_fd_sc_hd__a21oi_1
X_2326_ net81 _0527_ VGND VGND VPWR VPWR _0501_ sky130_fd_sc_hd__xor2_1
XFILLER_0_26_3 VGND VGND VPWR VPWR sky130_fd_sc_hd__decap_3
XTAP_TAPCELL_ROW_48_580 VGND VPWR sky130_fd_sc_hd__tapvpwrvgnd_1
XFILLER_0_79_279 VGND VGND VPWR VPWR sky130_fd_sc_hd__fill_1
X_4829_ clknet_leaf_13_clk _0479_ _0223_ VGND VGND VPWR VPWR RF0.regs\[0\]\[31\] sky130_fd_sc_hd__dfrtp_1
XFILLER_0_62_157 VGND VGND VPWR VPWR sky130_fd_sc_hd__decap_4
XFILLER_0_62_168 VPWR VGND VPWR VGND sky130_ef_sc_hd__decap_12
XFILLER_0_43_393 VPWR VGND VPWR VGND sky130_ef_sc_hd__decap_12
XTAP_TAPCELL_ROW_74_804 VGND VPWR sky130_fd_sc_hd__tapvpwrvgnd_1
XFILLER_0_14_27 VGND VGND VPWR VPWR sky130_fd_sc_hd__fill_1
XFILLER_0_81_433 VPWR VGND VPWR VGND sky130_ef_sc_hd__decap_12
XFILLER_0_26_338 VPWR VGND VPWR VGND sky130_ef_sc_hd__decap_12
XFILLER_0_53_113 VGND VGND VPWR VPWR sky130_fd_sc_hd__decap_8
XFILLER_0_66_474 VGND VGND VPWR VPWR sky130_fd_sc_hd__fill_2
XFILLER_0_30_15 VPWR VGND VPWR VGND sky130_ef_sc_hd__decap_12
XFILLER_0_81_477 VGND VGND VPWR VPWR sky130_fd_sc_hd__decap_4
XFILLER_0_34_360 VGND VGND VPWR VPWR sky130_fd_sc_hd__decap_4
XFILLER_0_34_371 VGND VGND VPWR VPWR sky130_fd_sc_hd__decap_3
XFILLER_0_1_405 VPWR VGND VPWR VGND sky130_ef_sc_hd__decap_12
XFILLER_0_34_382 VGND VGND VPWR VPWR sky130_fd_sc_hd__fill_1
XFILLER_0_1_449 VPWR VGND VPWR VGND sky130_ef_sc_hd__decap_12
XFILLER_0_39_35 VGND VGND VPWR VPWR sky130_fd_sc_hd__fill_1
XFILLER_0_39_57 VGND VGND VPWR VPWR sky130_fd_sc_hd__fill_2
X_3160_ _1317_ _1318_ _1058_ VGND VGND VPWR VPWR _1319_ sky130_fd_sc_hd__mux2_1
X_3091_ _1249_ _1250_ _1075_ VGND VGND VPWR VPWR _1251_ sky130_fd_sc_hd__mux2_1
XPHY_EDGE_ROW_8_Right_8 VGND VGND VPWR VPWR sky130_fd_sc_hd__decap_3
XTAP_TAPCELL_ROW_45_561 VGND VPWR sky130_fd_sc_hd__tapvpwrvgnd_1
XFILLER_0_71_55 VGND VGND VPWR VPWR sky130_fd_sc_hd__fill_1
X_3993_ _2069_ VGND VGND VPWR VPWR _0375_ sky130_fd_sc_hd__clkbuf_1
X_2944_ _1102_ _1103_ _0865_ VGND VGND VPWR VPWR _1104_ sky130_fd_sc_hd__mux2_1
XFILLER_0_72_433 VPWR VGND VPWR VGND sky130_ef_sc_hd__decap_12
X_2875_ _0658_ _0712_ _0607_ VGND VGND VPWR VPWR _1036_ sky130_fd_sc_hd__a21oi_2
XFILLER_0_44_135 VGND VGND VPWR VPWR sky130_fd_sc_hd__fill_2
XFILLER_0_72_477 VGND VGND VPWR VPWR sky130_fd_sc_hd__decap_4
X_4614_ clknet_leaf_0_clk _0264_ _0008_ VGND VGND VPWR VPWR RF0.regs\[30\]\[8\] sky130_fd_sc_hd__dfrtp_1
X_4545_ _2280_ VGND VGND VPWR VPWR _2282_ sky130_fd_sc_hd__buf_4
XFILLER_0_4_287 VGND VGND VPWR VPWR sky130_fd_sc_hd__decap_6
XFILLER_0_20_81 VGND VGND VPWR VPWR sky130_fd_sc_hd__decap_3
X_4476_ _2271_ VGND VGND VPWR VPWR _0141_ sky130_fd_sc_hd__inv_2
X_3427_ _1582_ _1583_ VGND VGND VPWR VPWR _1584_ sky130_fd_sc_hd__nand2_1
XPHY_EDGE_ROW_39_Right_39 VGND VGND VPWR VPWR sky130_fd_sc_hd__decap_3
X_3358_ _1022_ _1023_ _1003_ VGND VGND VPWR VPWR _1515_ sky130_fd_sc_hd__mux2_1
X_2309_ net51 _0533_ VGND VGND VPWR VPWR _0511_ sky130_fd_sc_hd__xor2_1
X_3289_ _1112_ _1300_ _1203_ VGND VGND VPWR VPWR _1447_ sky130_fd_sc_hd__a21o_1
XTAP_TAPCELL_ROW_0_164 VGND VPWR sky130_fd_sc_hd__tapvpwrvgnd_1
XTAP_TAPCELL_ROW_0_175 VGND VPWR sky130_fd_sc_hd__tapvpwrvgnd_1
XFILLER_0_67_249 VGND VGND VPWR VPWR sky130_fd_sc_hd__decap_6
XPHY_EDGE_ROW_48_Right_48 VGND VGND VPWR VPWR sky130_fd_sc_hd__decap_3
XFILLER_0_16_382 VGND VGND VPWR VPWR sky130_fd_sc_hd__fill_1
XFILLER_0_50_127 VGND VGND VPWR VPWR sky130_fd_sc_hd__fill_2
XFILLER_0_50_138 VGND VGND VPWR VPWR sky130_fd_sc_hd__fill_2
XFILLER_0_31_330 VGND VGND VPWR VPWR sky130_fd_sc_hd__decap_6
XPHY_EDGE_ROW_57_Right_57 VGND VGND VPWR VPWR sky130_fd_sc_hd__decap_3
XTAP_TAPCELL_ROW_8_242 VGND VPWR sky130_fd_sc_hd__tapvpwrvgnd_1
XTAP_TAPCELL_ROW_59_675 VGND VPWR sky130_fd_sc_hd__tapvpwrvgnd_1
XFILLER_0_58_205 VGND VGND VPWR VPWR sky130_fd_sc_hd__fill_1
XPHY_EDGE_ROW_66_Right_66 VGND VGND VPWR VPWR sky130_fd_sc_hd__decap_3
XFILLER_0_39_441 VGND VGND VPWR VPWR sky130_fd_sc_hd__decap_6
XTAP_TAPCELL_ROW_42_531 VGND VPWR sky130_fd_sc_hd__tapvpwrvgnd_1
XFILLER_0_41_69 VGND VGND VPWR VPWR sky130_fd_sc_hd__decap_4
XFILLER_0_54_433 VGND VGND VPWR VPWR sky130_fd_sc_hd__fill_1
XTAP_TAPCELL_ROW_14_299 VGND VPWR sky130_fd_sc_hd__tapvpwrvgnd_1
XFILLER_0_26_168 VGND VGND VPWR VPWR sky130_fd_sc_hd__decap_8
X_2660_ net45 _0730_ _0732_ VGND VGND VPWR VPWR _0821_ sky130_fd_sc_hd__o21ai_1
XFILLER_0_54_477 VGND VGND VPWR VPWR sky130_fd_sc_hd__decap_4
XPHY_EDGE_ROW_75_Right_75 VGND VGND VPWR VPWR sky130_fd_sc_hd__decap_3
X_2591_ _0686_ _0751_ VGND VGND VPWR VPWR _0752_ sky130_fd_sc_hd__nand2_1
X_4330_ _2250_ VGND VGND VPWR VPWR _0016_ sky130_fd_sc_hd__inv_2
X_4261_ _1085_ _2212_ _2213_ VGND VGND VPWR VPWR net29 sky130_fd_sc_hd__a21bo_1
X_3212_ _1172_ _1176_ _1047_ VGND VGND VPWR VPWR _1371_ sky130_fd_sc_hd__mux2_1
XFILLER_0_66_77 VGND VGND VPWR VPWR sky130_fd_sc_hd__decap_6
X_4192_ _1853_ net147 _2170_ VGND VGND VPWR VPWR _2176_ sky130_fd_sc_hd__mux2_1
X_3143_ _0653_ _1276_ _1277_ _1302_ VGND VGND VPWR VPWR net19 sky130_fd_sc_hd__a31o_1
X_3074_ RF0.regs\[20\]\[29\] _0627_ _1091_ RF0.regs\[25\]\[29\] _1233_ VGND VGND VPWR
+ VPWR _1234_ sky130_fd_sc_hd__a221o_1
X_3976_ _1833_ RF0.regs\[15\]\[31\] _2060_ VGND VGND VPWR VPWR _2061_ sky130_fd_sc_hd__mux2_4
X_2927_ _0654_ _0998_ _0999_ _1087_ VGND VGND VPWR VPWR net25 sky130_fd_sc_hd__a31o_1
XFILLER_0_17_157 VGND VGND VPWR VPWR sky130_fd_sc_hd__decap_8
XFILLER_0_32_105 VGND VGND VPWR VPWR sky130_fd_sc_hd__decap_6
XFILLER_0_45_477 VGND VGND VPWR VPWR sky130_fd_sc_hd__fill_1
X_2858_ _0715_ VGND VGND VPWR VPWR _1019_ sky130_fd_sc_hd__buf_2
XFILLER_0_60_436 VGND VGND VPWR VPWR sky130_fd_sc_hd__fill_1
X_2789_ _0944_ _0945_ VGND VGND VPWR VPWR _0950_ sky130_fd_sc_hd__nor2_1
X_4528_ _2278_ VGND VGND VPWR VPWR _0186_ sky130_fd_sc_hd__inv_2
X_4459_ _2268_ VGND VGND VPWR VPWR _0127_ sky130_fd_sc_hd__inv_2
XTAP_TAPCELL_ROW_56_656 VGND VPWR sky130_fd_sc_hd__tapvpwrvgnd_1
XFILLER_0_36_444 VGND VGND VPWR VPWR sky130_fd_sc_hd__decap_4
XFILLER_0_11_39 VPWR VGND VPWR VGND sky130_ef_sc_hd__decap_12
XFILLER_0_36_477 VGND VGND VPWR VPWR sky130_fd_sc_hd__fill_1
XTAP_TAPCELL_ROW_11_269 VGND VPWR sky130_fd_sc_hd__tapvpwrvgnd_1
XTAP_TAPCELL_ROW_19_336 VGND VPWR sky130_fd_sc_hd__tapvpwrvgnd_1
X_3830_ _1966_ VGND VGND VPWR VPWR _0435_ sky130_fd_sc_hd__clkbuf_1
XFILLER_0_27_433 VPWR VGND VPWR VGND sky130_ef_sc_hd__decap_12
X_3761_ _1098_ _1567_ _1568_ _1152_ _1901_ VGND VGND VPWR VPWR _1902_ sky130_fd_sc_hd__o32a_1
X_2712_ _0716_ _0871_ _0872_ VGND VGND VPWR VPWR _0873_ sky130_fd_sc_hd__a21o_1
X_3692_ _1839_ VGND VGND VPWR VPWR _0446_ sky130_fd_sc_hd__clkbuf_1
X_2643_ _0705_ _0729_ _0733_ VGND VGND VPWR VPWR _0804_ sky130_fd_sc_hd__nor3_2
X_2574_ RF0.regs\[15\]\[15\] _0663_ _0668_ RF0.regs\[5\]\[15\] VGND VGND VPWR VPWR
+ _0735_ sky130_fd_sc_hd__a22o_1
X_4313_ _2248_ VGND VGND VPWR VPWR _0001_ sky130_fd_sc_hd__inv_2
XFILLER_0_10_333 VPWR VGND VPWR VGND sky130_ef_sc_hd__decap_12
XFILLER_0_77_98 VPWR VGND VPWR VGND sky130_ef_sc_hd__decap_12
X_4244_ _2020_ net135 _2169_ VGND VGND VPWR VPWR _2203_ sky130_fd_sc_hd__mux2_1
X_4175_ _2166_ VGND VGND VPWR VPWR _0290_ sky130_fd_sc_hd__clkbuf_1
X_3126_ _0898_ _1051_ _1080_ VGND VGND VPWR VPWR _1286_ sky130_fd_sc_hd__mux2_1
X_3057_ _1103_ _1107_ _1052_ VGND VGND VPWR VPWR _1217_ sky130_fd_sc_hd__mux2_1
XTAP_TAPCELL_ROW_53_626 VGND VPWR sky130_fd_sc_hd__tapvpwrvgnd_1
XFILLER_0_9_143 VPWR VGND VPWR VGND sky130_ef_sc_hd__decap_12
XFILLER_0_18_411 VGND VGND VPWR VPWR sky130_fd_sc_hd__fill_1
XFILLER_0_18_477 VGND VGND VPWR VPWR sky130_fd_sc_hd__decap_4
X_3959_ _2051_ VGND VGND VPWR VPWR _0391_ sky130_fd_sc_hd__clkbuf_1
XTAP_TAPCELL_ROW_61_692 VGND VPWR sky130_fd_sc_hd__tapvpwrvgnd_1
XFILLER_0_5_360 VPWR VGND VPWR VGND sky130_ef_sc_hd__decap_12
XFILLER_0_13_160 VGND VGND VPWR VPWR sky130_fd_sc_hd__decap_8
XTAP_TAPCELL_ROW_24_383 VGND VPWR sky130_fd_sc_hd__tapvpwrvgnd_1
X_2290_ _0512_ IM0.addr\[2\] _0513_ _0514_ VGND VGND VPWR VPWR _0515_ sky130_fd_sc_hd__and4_1
XFILLER_0_2_15 VPWR VGND VPWR VGND sky130_ef_sc_hd__decap_12
XFILLER_0_74_303 VGND VGND VPWR VPWR sky130_fd_sc_hd__fill_1
XFILLER_0_59_377 VGND VGND VPWR VPWR sky130_fd_sc_hd__fill_1
X_3813_ _1450_ _1948_ VGND VGND VPWR VPWR _1953_ sky130_fd_sc_hd__xor2_2
X_4793_ clknet_leaf_6_clk _0443_ _0187_ VGND VGND VPWR VPWR RF0.regs\[5\]\[27\] sky130_fd_sc_hd__dfrtp_1
X_3744_ _1676_ _1884_ _1685_ VGND VGND VPWR VPWR _1885_ sky130_fd_sc_hd__a21o_1
XFILLER_0_42_211 VPWR VGND VPWR VGND sky130_ef_sc_hd__decap_12
X_3675_ _1815_ _1200_ net21 VGND VGND VPWR VPWR _1825_ sky130_fd_sc_hd__mux2_1
XFILLER_0_12_93 VGND VGND VPWR VPWR sky130_fd_sc_hd__decap_4
X_2626_ _0751_ _0786_ VGND VGND VPWR VPWR _0787_ sky130_fd_sc_hd__nor2_1
X_2557_ RF0.regs\[15\]\[1\] _0661_ _0666_ RF0.regs\[5\]\[1\] _0717_ VGND VGND VPWR
+ VPWR _0718_ sky130_fd_sc_hd__a221o_2
XFILLER_0_10_141 VPWR VGND VPWR VGND sky130_ef_sc_hd__decap_12
XFILLER_0_2_396 VPWR VGND VPWR VGND sky130_ef_sc_hd__decap_12
XFILLER_0_56_3 VPWR VGND VPWR VGND sky130_ef_sc_hd__decap_12
X_2488_ net34 _0599_ _0648_ VGND VGND VPWR VPWR _0649_ sky130_fd_sc_hd__and3_1
X_4227_ _2194_ VGND VGND VPWR VPWR _0266_ sky130_fd_sc_hd__clkbuf_1
X_4158_ _1997_ RF0.regs\[25\]\[10\] _2156_ VGND VGND VPWR VPWR _2158_ sky130_fd_sc_hd__mux2_1
X_4089_ _2121_ VGND VGND VPWR VPWR _0331_ sky130_fd_sc_hd__clkbuf_1
XTAP_TAPCELL_ROW_66_740 VGND VPWR sky130_fd_sc_hd__tapvpwrvgnd_1
X_3109_ _0653_ _0983_ _1242_ _1268_ VGND VGND VPWR VPWR _1269_ sky130_fd_sc_hd__a31oi_2
XTAP_TAPCELL_ROW_38_497 VGND VPWR sky130_fd_sc_hd__tapvpwrvgnd_1
XFILLER_0_65_314 VGND VGND VPWR VPWR sky130_fd_sc_hd__fill_1
XTAP_TAPCELL_ROW_21_353 VGND VPWR sky130_fd_sc_hd__tapvpwrvgnd_1
XFILLER_0_21_428 VGND VGND VPWR VPWR sky130_fd_sc_hd__decap_8
XTAP_TAPCELL_ROW_29_420 VGND VPWR sky130_fd_sc_hd__tapvpwrvgnd_1
XFILLER_0_33_15 VPWR VGND VPWR VGND sky130_ef_sc_hd__decap_12
XTAP_TAPCELL_ROW_72_787 VGND VPWR sky130_fd_sc_hd__tapvpwrvgnd_1
X_3460_ RF0.regs\[20\]\[5\] _0624_ _1614_ _1615_ VGND VGND VPWR VPWR _1616_ sky130_fd_sc_hd__a211o_2
XFILLER_0_24_299 VGND VGND VPWR VPWR sky130_fd_sc_hd__decap_8
X_2411_ _0580_ VGND VGND VPWR VPWR _0456_ sky130_fd_sc_hd__clkbuf_1
X_3391_ _1260_ _1262_ _1263_ _1257_ _1065_ _1039_ VGND VGND VPWR VPWR _1548_ sky130_fd_sc_hd__mux4_1
XFILLER_0_20_472 VGND VGND VPWR VPWR sky130_fd_sc_hd__decap_4
X_2342_ net83 _0520_ VGND VGND VPWR VPWR _0547_ sky130_fd_sc_hd__nor2_1
X_4012_ _2079_ VGND VGND VPWR VPWR _0366_ sky130_fd_sc_hd__clkbuf_1
XFILLER_0_74_77 VGND VGND VPWR VPWR sky130_fd_sc_hd__fill_2
XFILLER_0_79_417 VPWR VGND VPWR VGND sky130_ef_sc_hd__decap_12
XTAP_TAPCELL_ROW_63_710 VGND VPWR sky130_fd_sc_hd__tapvpwrvgnd_1
XFILLER_0_59_185 VPWR VGND VPWR VGND sky130_ef_sc_hd__decap_12
XFILLER_0_74_144 VGND VGND VPWR VPWR sky130_fd_sc_hd__decap_8
X_4845_ clknet_leaf_27_clk _0495_ _0239_ VGND VGND VPWR VPWR IM0.addr\[15\] sky130_fd_sc_hd__dfrtp_1
XFILLER_0_7_422 VPWR VGND VPWR VGND sky130_ef_sc_hd__decap_12
X_4776_ clknet_leaf_0_clk _0426_ _0170_ VGND VGND VPWR VPWR RF0.regs\[5\]\[10\] sky130_fd_sc_hd__dfrtp_1
X_3727_ _1741_ _1867_ _1065_ VGND VGND VPWR VPWR _1868_ sky130_fd_sc_hd__mux2_1
XFILLER_0_55_391 VGND VGND VPWR VPWR sky130_fd_sc_hd__fill_1
XFILLER_0_70_361 VGND VGND VPWR VPWR sky130_fd_sc_hd__decap_3
X_3658_ _1422_ _1450_ _1808_ VGND VGND VPWR VPWR _1809_ sky130_fd_sc_hd__or3_1
X_2609_ _0768_ _0769_ VGND VGND VPWR VPWR _0770_ sky130_fd_sc_hd__nor2_1
X_3589_ _0652_ _1719_ _1736_ _1738_ _1740_ VGND VGND VPWR VPWR net8 sky130_fd_sc_hd__a32o_1
XFILLER_0_11_461 VPWR VGND VPWR VGND sky130_ef_sc_hd__decap_12
XTAP_TAPCELL_ROW_26_401 VGND VPWR sky130_fd_sc_hd__tapvpwrvgnd_1
XFILLER_0_38_358 VGND VGND VPWR VPWR sky130_fd_sc_hd__decap_6
XFILLER_0_65_133 VGND VGND VPWR VPWR sky130_fd_sc_hd__decap_8
XFILLER_0_21_225 VGND VGND VPWR VPWR sky130_fd_sc_hd__fill_1
XFILLER_0_28_15 VPWR VGND VPWR VGND sky130_ef_sc_hd__decap_12
XFILLER_0_69_461 VPWR VGND VPWR VGND sky130_ef_sc_hd__decap_12
X_2960_ _0891_ _1119_ _1052_ VGND VGND VPWR VPWR _1120_ sky130_fd_sc_hd__mux2_1
X_2891_ _0865_ VGND VGND VPWR VPWR _1052_ sky130_fd_sc_hd__clkbuf_4
XTAP_TAPCELL_ROW_32_448 VGND VPWR sky130_fd_sc_hd__tapvpwrvgnd_1
X_4630_ clknet_leaf_6_clk _0280_ _0024_ VGND VGND VPWR VPWR RF0.regs\[30\]\[24\] sky130_fd_sc_hd__dfrtp_1
XFILLER_0_71_103 VGND VGND VPWR VPWR sky130_fd_sc_hd__decap_8
XFILLER_0_4_403 VPWR VGND VPWR VGND sky130_ef_sc_hd__decap_12
XFILLER_0_71_158 VGND VGND VPWR VPWR sky130_fd_sc_hd__decap_4
X_4561_ _2283_ VGND VGND VPWR VPWR _0214_ sky130_fd_sc_hd__inv_2
X_4492_ _2269_ VGND VGND VPWR VPWR _2273_ sky130_fd_sc_hd__clkbuf_2
X_3512_ _0514_ RF0.regs\[15\]\[1\] _0607_ _1666_ VGND VGND VPWR VPWR _1667_ sky130_fd_sc_hd__a31o_1
XFILLER_0_4_469 VGND VGND VPWR VPWR sky130_fd_sc_hd__decap_6
XFILLER_0_69_55 VGND VGND VPWR VPWR sky130_fd_sc_hd__fill_1
XFILLER_0_12_247 VGND VGND VPWR VPWR sky130_fd_sc_hd__fill_2
X_3443_ _1588_ VGND VGND VPWR VPWR _1600_ sky130_fd_sc_hd__inv_2
XFILLER_0_20_280 VGND VGND VPWR VPWR sky130_fd_sc_hd__decap_3
X_3374_ _0652_ _1529_ _1530_ VGND VGND VPWR VPWR _1531_ sky130_fd_sc_hd__and3_1
X_2325_ _0528_ net77 VGND VGND VPWR VPWR _0502_ sky130_fd_sc_hd__nor2_1
XFILLER_0_79_225 VGND VGND VPWR VPWR sky130_fd_sc_hd__fill_2
XFILLER_0_79_214 VGND VGND VPWR VPWR sky130_fd_sc_hd__fill_1
XFILLER_0_19_3 VGND VGND VPWR VPWR sky130_fd_sc_hd__decap_8
XTAP_TAPCELL_ROW_48_581 VGND VPWR sky130_fd_sc_hd__tapvpwrvgnd_1
XFILLER_0_47_155 VPWR VGND VPWR VGND sky130_ef_sc_hd__decap_12
X_4828_ clknet_leaf_13_clk _0478_ _0222_ VGND VGND VPWR VPWR RF0.regs\[0\]\[30\] sky130_fd_sc_hd__dfrtp_1
X_4759_ clknet_leaf_11_clk _0409_ _0153_ VGND VGND VPWR VPWR RF0.regs\[10\]\[25\]
+ sky130_fd_sc_hd__dfrtp_1
XTAP_TAPCELL_ROW_74_805 VGND VPWR sky130_fd_sc_hd__tapvpwrvgnd_1
XFILLER_0_66_442 VPWR VGND VPWR VGND sky130_ef_sc_hd__decap_12
XFILLER_0_81_445 VGND VGND VPWR VPWR sky130_fd_sc_hd__decap_3
XFILLER_0_30_27 VGND VGND VPWR VPWR sky130_fd_sc_hd__fill_1
XFILLER_0_53_169 VGND VGND VPWR VPWR sky130_fd_sc_hd__fill_1
XFILLER_0_1_417 VPWR VGND VPWR VGND sky130_ef_sc_hd__decap_12
X_3090_ _0970_ _0971_ _1042_ VGND VGND VPWR VPWR _1250_ sky130_fd_sc_hd__mux2_1
XFILLER_0_55_57 VGND VGND VPWR VPWR sky130_fd_sc_hd__decap_6
XTAP_TAPCELL_ROW_45_562 VGND VPWR sky130_fd_sc_hd__tapvpwrvgnd_1
X_3992_ _1951_ RF0.regs\[15\]\[23\] _2060_ VGND VGND VPWR VPWR _2069_ sky130_fd_sc_hd__mux2_1
X_2943_ RF0.regs\[10\]\[2\] _0809_ _0668_ RF0.regs\[25\]\[2\] VGND VGND VPWR VPWR
+ _1103_ sky130_fd_sc_hd__a22o_1
XFILLER_0_72_445 VPWR VGND VPWR VGND sky130_ef_sc_hd__decap_12
X_2874_ _1021_ _1033_ _1034_ VGND VGND VPWR VPWR _1035_ sky130_fd_sc_hd__mux2_2
X_4613_ clknet_leaf_22_clk _0263_ _0007_ VGND VGND VPWR VPWR RF0.regs\[30\]\[7\] sky130_fd_sc_hd__dfrtp_1
XFILLER_0_25_350 VPWR VGND VPWR VGND sky130_ef_sc_hd__decap_12
XFILLER_0_32_309 VGND VGND VPWR VPWR sky130_fd_sc_hd__fill_1
X_4544_ _2281_ VGND VGND VPWR VPWR _0199_ sky130_fd_sc_hd__inv_2
XFILLER_0_20_60 VGND VGND VPWR VPWR sky130_fd_sc_hd__decap_8
X_4475_ _2271_ VGND VGND VPWR VPWR _0140_ sky130_fd_sc_hd__inv_2
XFILLER_0_0_461 VPWR VGND VPWR VGND sky130_ef_sc_hd__decap_12
X_3426_ _1577_ _1581_ VGND VGND VPWR VPWR _1583_ sky130_fd_sc_hd__nand2_1
X_3357_ _0880_ _1030_ _1003_ VGND VGND VPWR VPWR _1514_ sky130_fd_sc_hd__mux2_1
X_2308_ IM0.addr\[30\] IM0.addr\[29\] _0532_ VGND VGND VPWR VPWR _0533_ sky130_fd_sc_hd__and3_1
X_3288_ _1362_ _1370_ _1371_ _1368_ _1064_ _1038_ VGND VGND VPWR VPWR _1446_ sky130_fd_sc_hd__mux4_1
XTAP_TAPCELL_ROW_0_165 VGND VPWR sky130_fd_sc_hd__tapvpwrvgnd_1
XTAP_TAPCELL_ROW_0_176 VGND VPWR sky130_fd_sc_hd__tapvpwrvgnd_1
XFILLER_0_0_81 VGND VGND VPWR VPWR sky130_fd_sc_hd__decap_3
XFILLER_0_35_103 VGND VGND VPWR VPWR sky130_fd_sc_hd__fill_1
XFILLER_0_63_434 VGND VGND VPWR VPWR sky130_fd_sc_hd__decap_3
XFILLER_0_23_309 VGND VGND VPWR VPWR sky130_fd_sc_hd__fill_1
XTAP_TAPCELL_ROW_8_243 VGND VPWR sky130_fd_sc_hd__tapvpwrvgnd_1
XFILLER_0_8_3 VPWR VGND VPWR VGND sky130_ef_sc_hd__decap_12
XTAP_TAPCELL_ROW_59_676 VGND VPWR sky130_fd_sc_hd__tapvpwrvgnd_1
XFILLER_0_73_209 VGND VGND VPWR VPWR sky130_fd_sc_hd__decap_4
XFILLER_0_41_15 VPWR VGND VPWR VGND sky130_ef_sc_hd__decap_12
XTAP_TAPCELL_ROW_42_532 VGND VPWR sky130_fd_sc_hd__tapvpwrvgnd_1
XFILLER_0_66_250 VGND VGND VPWR VPWR sky130_fd_sc_hd__fill_2
XFILLER_0_81_253 VPWR VGND VPWR VGND sky130_ef_sc_hd__decap_12
XFILLER_0_1_225 VGND VGND VPWR VPWR sky130_fd_sc_hd__fill_1
X_2590_ _0688_ _0690_ _0750_ VGND VGND VPWR VPWR _0751_ sky130_fd_sc_hd__and3_1
X_4260_ _1099_ _1592_ _1607_ VGND VGND VPWR VPWR _2213_ sky130_fd_sc_hd__or3_1
X_3211_ _1159_ _1169_ _1047_ VGND VGND VPWR VPWR _1370_ sky130_fd_sc_hd__mux2_1
X_4191_ _2175_ VGND VGND VPWR VPWR _0283_ sky130_fd_sc_hd__clkbuf_1
X_3142_ _1001_ _1284_ _1290_ _1204_ _1301_ VGND VGND VPWR VPWR _1302_ sky130_fd_sc_hd__o32a_1
X_3073_ RF0.regs\[15\]\[29\] _0611_ _0631_ RF0.regs\[10\]\[29\] VGND VGND VPWR VPWR
+ _1233_ sky130_fd_sc_hd__a22o_1
X_3975_ _2059_ VGND VGND VPWR VPWR _2060_ sky130_fd_sc_hd__clkbuf_4
X_2926_ _1002_ _1035_ _1086_ _0647_ VGND VGND VPWR VPWR _1087_ sky130_fd_sc_hd__a211oi_1
XFILLER_0_72_253 VPWR VGND VPWR VGND sky130_ef_sc_hd__decap_12
X_2857_ _1015_ _1017_ _1011_ VGND VGND VPWR VPWR _1018_ sky130_fd_sc_hd__mux2_1
XFILLER_0_72_297 VGND VGND VPWR VPWR sky130_fd_sc_hd__fill_2
XFILLER_0_32_139 VGND VGND VPWR VPWR sky130_fd_sc_hd__fill_1
X_2788_ _0940_ _0941_ VGND VGND VPWR VPWR _0949_ sky130_fd_sc_hd__and2_1
X_4527_ _2278_ VGND VGND VPWR VPWR _0185_ sky130_fd_sc_hd__inv_2
X_4458_ _2268_ VGND VGND VPWR VPWR _0126_ sky130_fd_sc_hd__inv_2
X_3409_ _1563_ _1565_ VGND VGND VPWR VPWR _1566_ sky130_fd_sc_hd__nor2_1
X_4389_ _2259_ VGND VGND VPWR VPWR _0066_ sky130_fd_sc_hd__inv_2
XFILLER_0_36_15 VPWR VGND VPWR VGND sky130_ef_sc_hd__decap_12
XFILLER_0_36_59 VGND VGND VPWR VPWR sky130_fd_sc_hd__decap_4
XTAP_TAPCELL_ROW_19_337 VGND VPWR sky130_fd_sc_hd__tapvpwrvgnd_1
XFILLER_0_6_306 VGND VGND VPWR VPWR sky130_fd_sc_hd__fill_2
XFILLER_0_27_445 VGND VGND VPWR VPWR sky130_fd_sc_hd__decap_3
X_3760_ _1897_ _1900_ _1039_ VGND VGND VPWR VPWR _1901_ sky130_fd_sc_hd__mux2_1
X_2711_ RF0.regs\[10\]\[2\] _0613_ _0668_ RF0.regs\[25\]\[2\] VGND VGND VPWR VPWR
+ _0872_ sky130_fd_sc_hd__a22o_1
XFILLER_0_54_264 VGND VGND VPWR VPWR sky130_fd_sc_hd__decap_4
X_3691_ _1838_ RF0.regs\[5\]\[30\] _1835_ VGND VGND VPWR VPWR _1839_ sky130_fd_sc_hd__mux2_2
XFILLER_0_42_437 VGND VGND VPWR VPWR sky130_fd_sc_hd__fill_1
XFILLER_0_14_139 VGND VGND VPWR VPWR sky130_fd_sc_hd__fill_1
XFILLER_0_42_448 VGND VGND VPWR VPWR sky130_fd_sc_hd__decap_4
X_2642_ _0795_ _0796_ _0801_ _0802_ VGND VGND VPWR VPWR _0803_ sky130_fd_sc_hd__o31a_1
XFILLER_0_22_161 VGND VGND VPWR VPWR sky130_fd_sc_hd__fill_2
X_2573_ _0702_ _0705_ _0729_ _0733_ VGND VGND VPWR VPWR _0734_ sky130_fd_sc_hd__or4_4
XFILLER_0_77_55 VGND VGND VPWR VPWR sky130_fd_sc_hd__fill_1
X_4312_ _2248_ VGND VGND VPWR VPWR _0000_ sky130_fd_sc_hd__inv_2
XFILLER_0_50_481 VGND VGND VPWR VPWR sky130_fd_sc_hd__fill_1
XFILLER_0_10_345 VPWR VGND VPWR VGND sky130_ef_sc_hd__decap_12
X_4243_ _2202_ VGND VGND VPWR VPWR _0258_ sky130_fd_sc_hd__clkbuf_1
X_4174_ _2018_ RF0.regs\[25\]\[2\] _2156_ VGND VGND VPWR VPWR _2166_ sky130_fd_sc_hd__mux2_1
X_3125_ _0937_ _0945_ _1042_ VGND VGND VPWR VPWR _1285_ sky130_fd_sc_hd__mux2_1
X_3056_ _1014_ _1102_ _0868_ VGND VGND VPWR VPWR _1216_ sky130_fd_sc_hd__o21a_1
XFILLER_0_9_100 VPWR VGND VPWR VGND sky130_ef_sc_hd__decap_12
XTAP_TAPCELL_ROW_53_627 VGND VPWR sky130_fd_sc_hd__tapvpwrvgnd_1
XFILLER_0_77_367 VPWR VGND VPWR VGND sky130_ef_sc_hd__decap_12
XFILLER_0_9_155 VPWR VGND VPWR VGND sky130_ef_sc_hd__decap_12
XFILLER_0_42_80 VGND VGND VPWR VPWR sky130_fd_sc_hd__decap_4
X_3958_ _2007_ RF0.regs\[10\]\[7\] _2046_ VGND VGND VPWR VPWR _2051_ sky130_fd_sc_hd__mux2_1
XTAP_TAPCELL_ROW_61_693 VGND VPWR sky130_fd_sc_hd__tapvpwrvgnd_1
X_3889_ _2011_ RF0.regs\[5\]\[5\] _1994_ VGND VGND VPWR VPWR _2012_ sky130_fd_sc_hd__mux2_1
X_2909_ _1067_ _1069_ _1049_ VGND VGND VPWR VPWR _1070_ sky130_fd_sc_hd__mux2_1
XFILLER_0_5_372 VGND VGND VPWR VPWR sky130_fd_sc_hd__decap_8
XFILLER_0_60_256 VGND VGND VPWR VPWR sky130_fd_sc_hd__decap_6
XFILLER_0_20_109 VGND VGND VPWR VPWR sky130_fd_sc_hd__decap_4
XFILLER_0_6_80 VGND VGND VPWR VPWR sky130_fd_sc_hd__decap_4
XTAP_TAPCELL_ROW_69_760 VGND VPWR sky130_fd_sc_hd__tapvpwrvgnd_1
XFILLER_0_36_220 VGND VGND VPWR VPWR sky130_fd_sc_hd__fill_1
XTAP_TAPCELL_ROW_24_384 VGND VPWR sky130_fd_sc_hd__tapvpwrvgnd_1
XFILLER_0_51_223 VGND VGND VPWR VPWR sky130_fd_sc_hd__fill_1
XFILLER_0_11_109 VGND VGND VPWR VPWR sky130_fd_sc_hd__decap_3
XFILLER_0_47_47 VGND VGND VPWR VPWR sky130_fd_sc_hd__fill_1
XFILLER_0_2_27 VGND VGND VPWR VPWR sky130_fd_sc_hd__fill_1
XFILLER_0_63_57 VPWR VGND VPWR VGND sky130_ef_sc_hd__decap_12
XFILLER_0_59_334 VGND VGND VPWR VPWR sky130_fd_sc_hd__fill_2
X_4861_ clknet_leaf_26_clk _0511_ _0255_ VGND VGND VPWR VPWR IM0.addr\[31\] sky130_fd_sc_hd__dfrtp_1
X_3812_ _1952_ VGND VGND VPWR VPWR _0439_ sky130_fd_sc_hd__clkbuf_1
XFILLER_0_27_231 VPWR VGND VPWR VGND sky130_ef_sc_hd__decap_12
X_4792_ clknet_leaf_7_clk _0442_ _0186_ VGND VGND VPWR VPWR RF0.regs\[5\]\[26\] sky130_fd_sc_hd__dfrtp_1
X_3743_ _1680_ _1883_ VGND VGND VPWR VPWR _1884_ sky130_fd_sc_hd__nor2_1
XFILLER_0_6_147 VGND VGND VPWR VPWR sky130_fd_sc_hd__fill_2
X_3674_ _1098_ _0986_ _1195_ _1824_ VGND VGND VPWR VPWR net21 sky130_fd_sc_hd__o31ai_2
XFILLER_0_42_223 VPWR VGND VPWR VGND sky130_ef_sc_hd__decap_12
X_2625_ _0771_ _0688_ _0690_ _0750_ VGND VGND VPWR VPWR _0786_ sky130_fd_sc_hd__a22oi_1
XFILLER_0_23_470 VPWR VGND VPWR VGND sky130_ef_sc_hd__decap_12
X_2556_ _0513_ _0594_ _0600_ _0647_ VGND VGND VPWR VPWR _0717_ sky130_fd_sc_hd__and4b_1
XFILLER_0_10_153 VGND VGND VPWR VPWR sky130_fd_sc_hd__decap_6
X_2487_ IM0.addr\[1\] _0647_ VGND VGND VPWR VPWR _0648_ sky130_fd_sc_hd__or2_1
XFILLER_0_10_197 VGND VGND VPWR VPWR sky130_fd_sc_hd__fill_2
X_4226_ _1997_ net155 _2192_ VGND VGND VPWR VPWR _2194_ sky130_fd_sc_hd__mux2_1
XFILLER_0_49_3 VPWR VGND VPWR VGND sky130_ef_sc_hd__decap_12
X_4157_ _2157_ VGND VGND VPWR VPWR _0299_ sky130_fd_sc_hd__clkbuf_1
X_3108_ _1002_ _1259_ _1267_ _1150_ VGND VGND VPWR VPWR _1268_ sky130_fd_sc_hd__o211a_1
X_4088_ net132 _1993_ _2120_ VGND VGND VPWR VPWR _2121_ sky130_fd_sc_hd__mux2_1
XTAP_TAPCELL_ROW_66_741 VGND VPWR sky130_fd_sc_hd__tapvpwrvgnd_1
X_3039_ RF0.regs\[20\]\[28\] _0627_ _0611_ RF0.regs\[15\]\[28\] _1198_ VGND VGND VPWR
+ VPWR _1199_ sky130_fd_sc_hd__a221o_1
XTAP_TAPCELL_ROW_38_498 VGND VPWR sky130_fd_sc_hd__tapvpwrvgnd_1
XFILLER_0_65_326 VGND VGND VPWR VPWR sky130_fd_sc_hd__fill_1
XFILLER_0_65_337 VGND VGND VPWR VPWR sky130_fd_sc_hd__decap_3
XFILLER_0_18_242 VGND VGND VPWR VPWR sky130_fd_sc_hd__fill_1
XFILLER_0_80_318 VGND VGND VPWR VPWR sky130_fd_sc_hd__fill_2
XFILLER_0_18_264 VPWR VGND VPWR VGND sky130_ef_sc_hd__decap_12
XTAP_TAPCELL_ROW_21_354 VGND VPWR sky130_fd_sc_hd__tapvpwrvgnd_1
XFILLER_0_33_278 VGND VGND VPWR VPWR sky130_fd_sc_hd__fill_2
XFILLER_0_14_481 VGND VGND VPWR VPWR sky130_fd_sc_hd__fill_1
XTAP_TAPCELL_ROW_29_421 VGND VPWR sky130_fd_sc_hd__tapvpwrvgnd_1
XFILLER_0_33_27 VGND VGND VPWR VPWR sky130_fd_sc_hd__decap_8
XFILLER_0_68_153 VGND VGND VPWR VPWR sky130_fd_sc_hd__decap_6
XTAP_TAPCELL_ROW_72_788 VGND VPWR sky130_fd_sc_hd__tapvpwrvgnd_1
XFILLER_0_68_197 VGND VGND VPWR VPWR sky130_fd_sc_hd__decap_8
XFILLER_0_56_359 VGND VGND VPWR VPWR sky130_fd_sc_hd__decap_4
X_2410_ net95 VGND VGND VPWR VPWR _0580_ sky130_fd_sc_hd__clkbuf_1
XFILLER_0_20_440 VGND VGND VPWR VPWR sky130_fd_sc_hd__fill_2
X_3390_ _1097_ _1501_ _1502_ VGND VGND VPWR VPWR _1547_ sky130_fd_sc_hd__or3_1
X_2341_ net80 _0521_ VGND VGND VPWR VPWR _0492_ sky130_fd_sc_hd__xor2_1
XFILLER_0_58_68 VGND VGND VPWR VPWR sky130_fd_sc_hd__fill_1
X_4011_ _1984_ RF0.regs\[15\]\[14\] _2071_ VGND VGND VPWR VPWR _2079_ sky130_fd_sc_hd__mux2_1
XFILLER_0_79_429 VPWR VGND VPWR VGND sky130_ef_sc_hd__decap_12
XFILLER_0_74_89 VGND VGND VPWR VPWR sky130_fd_sc_hd__fill_2
XTAP_TAPCELL_ROW_63_711 VGND VPWR sky130_fd_sc_hd__tapvpwrvgnd_1
XFILLER_0_47_337 VGND VGND VPWR VPWR sky130_fd_sc_hd__decap_4
XFILLER_0_59_197 VGND VGND VPWR VPWR sky130_fd_sc_hd__decap_4
XFILLER_0_74_134 VGND VGND VPWR VPWR sky130_fd_sc_hd__decap_6
X_4844_ clknet_leaf_27_clk _0494_ _0238_ VGND VGND VPWR VPWR IM0.addr\[14\] sky130_fd_sc_hd__dfrtp_1
XFILLER_0_23_82 VPWR VGND VPWR VGND sky130_ef_sc_hd__decap_12
XFILLER_0_62_307 VGND VGND VPWR VPWR sky130_fd_sc_hd__fill_1
XFILLER_0_7_434 VPWR VGND VPWR VGND sky130_ef_sc_hd__decap_12
X_4775_ clknet_leaf_0_clk _0425_ _0169_ VGND VGND VPWR VPWR RF0.regs\[5\]\[9\] sky130_fd_sc_hd__dfrtp_1
X_3726_ _1866_ VGND VGND VPWR VPWR _1867_ sky130_fd_sc_hd__inv_2
XFILLER_0_70_373 VPWR VGND VPWR VGND sky130_ef_sc_hd__decap_12
X_3657_ _1454_ _1807_ _1468_ _1480_ VGND VGND VPWR VPWR _1808_ sky130_fd_sc_hd__o22a_1
X_2608_ RF0.regs\[10\]\[28\] _0619_ _0676_ RF0.regs\[25\]\[28\] VGND VGND VPWR VPWR
+ _0769_ sky130_fd_sc_hd__a22oi_4
X_3588_ _1134_ _1401_ _1739_ _1000_ VGND VGND VPWR VPWR _1740_ sky130_fd_sc_hd__a211o_1
XFILLER_0_11_473 VGND VGND VPWR VPWR sky130_fd_sc_hd__decap_8
X_2539_ _0657_ _0699_ VGND VGND VPWR VPWR _0700_ sky130_fd_sc_hd__nand2_1
X_4209_ _1968_ RF0.regs\[30\]\[18\] _2181_ VGND VGND VPWR VPWR _2185_ sky130_fd_sc_hd__mux2_1
XFILLER_0_65_167 VGND VGND VPWR VPWR sky130_fd_sc_hd__fill_1
XFILLER_0_28_27 VGND VGND VPWR VPWR sky130_fd_sc_hd__fill_1
XFILLER_0_44_15 VPWR VGND VPWR VGND sky130_ef_sc_hd__decap_12
XFILLER_0_29_337 VGND VGND VPWR VPWR sky130_fd_sc_hd__decap_4
XFILLER_0_69_473 VGND VGND VPWR VPWR sky130_fd_sc_hd__decap_8
X_2890_ RF0.regs\[10\]\[16\] _0616_ _0673_ RF0.regs\[25\]\[16\] VGND VGND VPWR VPWR
+ _1051_ sky130_fd_sc_hd__a22oi_4
XTAP_TAPCELL_ROW_32_449 VGND VPWR sky130_fd_sc_hd__tapvpwrvgnd_1
XFILLER_0_4_415 VGND VGND VPWR VPWR sky130_fd_sc_hd__decap_4
X_4560_ _2283_ VGND VGND VPWR VPWR _0213_ sky130_fd_sc_hd__inv_2
XFILLER_0_8_15 VGND VGND VPWR VPWR sky130_fd_sc_hd__fill_2
XFILLER_0_52_362 VGND VGND VPWR VPWR sky130_fd_sc_hd__fill_2
X_3511_ RF0.regs\[5\]\[1\] _0632_ _0636_ RF0.regs\[30\]\[1\] _0606_ VGND VGND VPWR
+ VPWR _1666_ sky130_fd_sc_hd__a221o_1
XFILLER_0_52_373 VGND VGND VPWR VPWR sky130_fd_sc_hd__fill_1
X_4491_ _2272_ VGND VGND VPWR VPWR _0155_ sky130_fd_sc_hd__inv_2
X_3442_ RF0.regs\[0\]\[7\] _0603_ _1588_ VGND VGND VPWR VPWR _1599_ sky130_fd_sc_hd__o21a_1
X_3373_ _1528_ _0924_ _1489_ VGND VGND VPWR VPWR _1530_ sky130_fd_sc_hd__or3b_1
X_2324_ IM0.addr\[21\] _0527_ net76 VGND VGND VPWR VPWR _0540_ sky130_fd_sc_hd__a21oi_1
XTAP_TAPCELL_ROW_48_582 VGND VPWR sky130_fd_sc_hd__tapvpwrvgnd_1
X_4827_ clknet_leaf_14_clk _0477_ _0221_ VGND VGND VPWR VPWR RF0.regs\[0\]\[29\] sky130_fd_sc_hd__dfrtp_1
XFILLER_0_35_307 VGND VGND VPWR VPWR sky130_fd_sc_hd__fill_2
XFILLER_0_47_167 VGND VGND VPWR VPWR sky130_fd_sc_hd__fill_1
X_4758_ clknet_leaf_11_clk _0408_ _0152_ VGND VGND VPWR VPWR RF0.regs\[10\]\[24\]
+ sky130_fd_sc_hd__dfrtp_1
X_4689_ clknet_leaf_9_clk _0339_ _0083_ VGND VGND VPWR VPWR RF0.regs\[20\]\[19\] sky130_fd_sc_hd__dfrtp_1
X_3709_ _1848_ _1852_ VGND VGND VPWR VPWR _1853_ sky130_fd_sc_hd__and2_2
XFILLER_0_3_481 VGND VGND VPWR VPWR sky130_fd_sc_hd__fill_1
XFILLER_0_70_192 VGND VGND VPWR VPWR sky130_fd_sc_hd__decap_4
XTAP_TAPCELL_ROW_74_806 VGND VPWR sky130_fd_sc_hd__tapvpwrvgnd_1
XFILLER_0_14_29 VGND VGND VPWR VPWR sky130_fd_sc_hd__fill_1
XFILLER_0_66_421 VGND VGND VPWR VPWR sky130_fd_sc_hd__decap_3
XFILLER_0_66_454 VPWR VGND VPWR VGND sky130_ef_sc_hd__decap_12
XFILLER_0_19_381 VGND VGND VPWR VPWR sky130_fd_sc_hd__decap_8
XFILLER_0_1_429 VPWR VGND VPWR VGND sky130_ef_sc_hd__decap_12
XFILLER_0_39_15 VPWR VGND VPWR VGND sky130_ef_sc_hd__decap_12
XFILLER_0_57_410 VPWR VGND VPWR VGND sky130_ef_sc_hd__decap_12
X_3991_ _2068_ VGND VGND VPWR VPWR _0376_ sky130_fd_sc_hd__clkbuf_1
X_2942_ RF0.regs\[10\]\[1\] _0809_ _0668_ RF0.regs\[25\]\[1\] VGND VGND VPWR VPWR
+ _1102_ sky130_fd_sc_hd__a22o_1
XFILLER_0_29_123 VGND VGND VPWR VPWR sky130_fd_sc_hd__fill_1
XFILLER_0_71_57 VPWR VGND VPWR VGND sky130_ef_sc_hd__decap_12
XFILLER_0_57_476 VGND VGND VPWR VPWR sky130_fd_sc_hd__fill_2
XFILLER_0_72_457 VPWR VGND VPWR VGND sky130_ef_sc_hd__decap_12
X_2873_ _0713_ VGND VGND VPWR VPWR _1034_ sky130_fd_sc_hd__buf_2
X_4612_ clknet_leaf_25_clk _0262_ _0006_ VGND VGND VPWR VPWR RF0.regs\[30\]\[6\] sky130_fd_sc_hd__dfrtp_1
XFILLER_0_4_212 VGND VGND VPWR VPWR sky130_fd_sc_hd__fill_1
X_4543_ _2281_ VGND VGND VPWR VPWR _0198_ sky130_fd_sc_hd__inv_2
XFILLER_0_25_362 VGND VGND VPWR VPWR sky130_fd_sc_hd__decap_3
XFILLER_0_25_384 VGND VGND VPWR VPWR sky130_fd_sc_hd__fill_1
X_4474_ _2271_ VGND VGND VPWR VPWR _0139_ sky130_fd_sc_hd__inv_2
XFILLER_0_40_387 VGND VGND VPWR VPWR sky130_fd_sc_hd__fill_1
XFILLER_0_0_473 VGND VGND VPWR VPWR sky130_fd_sc_hd__decap_3
X_3425_ _1578_ _1581_ VGND VGND VPWR VPWR _1582_ sky130_fd_sc_hd__or2_1
X_3356_ _1510_ _1512_ VGND VGND VPWR VPWR _1513_ sky130_fd_sc_hd__nor2_1
X_2307_ IM0.addr\[28\] IM0.addr\[27\] _0531_ VGND VGND VPWR VPWR _0532_ sky130_fd_sc_hd__and3_1
X_3287_ _1434_ _1442_ _1444_ VGND VGND VPWR VPWR _1445_ sky130_fd_sc_hd__o21a_1
XFILLER_0_31_3 VPWR VGND VPWR VGND sky130_ef_sc_hd__decap_12
XTAP_TAPCELL_ROW_0_166 VGND VPWR sky130_fd_sc_hd__tapvpwrvgnd_1
XTAP_TAPCELL_ROW_0_177 VGND VPWR sky130_fd_sc_hd__tapvpwrvgnd_1
XFILLER_0_67_218 VGND VGND VPWR VPWR sky130_fd_sc_hd__decap_6
XFILLER_0_63_424 VGND VGND VPWR VPWR sky130_fd_sc_hd__fill_1
XFILLER_0_63_446 VGND VGND VPWR VPWR sky130_fd_sc_hd__fill_2
XFILLER_0_16_373 VGND VGND VPWR VPWR sky130_fd_sc_hd__fill_1
XFILLER_0_43_181 VGND VGND VPWR VPWR sky130_fd_sc_hd__fill_1
XTAP_TAPCELL_ROW_8_244 VGND VPWR sky130_fd_sc_hd__tapvpwrvgnd_1
XTAP_TAPCELL_ROW_59_677 VGND VPWR sky130_fd_sc_hd__tapvpwrvgnd_1
XFILLER_0_39_432 VGND VGND VPWR VPWR sky130_fd_sc_hd__decap_3
XFILLER_0_41_27 VGND VGND VPWR VPWR sky130_fd_sc_hd__decap_8
XTAP_TAPCELL_ROW_42_533 VGND VPWR sky130_fd_sc_hd__tapvpwrvgnd_1
XFILLER_0_66_273 VPWR VGND VPWR VGND sky130_ef_sc_hd__decap_12
XFILLER_0_81_265 VPWR VGND VPWR VGND sky130_ef_sc_hd__decap_12
XFILLER_0_41_107 VGND VGND VPWR VPWR sky130_fd_sc_hd__decap_4
XFILLER_0_22_321 VGND VGND VPWR VPWR sky130_fd_sc_hd__decap_8
X_3210_ _1367_ _1368_ _1058_ VGND VGND VPWR VPWR _1369_ sky130_fd_sc_hd__mux2_1
X_4190_ _1850_ RF0.regs\[30\]\[27\] _2170_ VGND VGND VPWR VPWR _2175_ sky130_fd_sc_hd__mux2_1
X_3141_ _1291_ _1295_ _1299_ _1300_ VGND VGND VPWR VPWR _1301_ sky130_fd_sc_hd__a22o_1
X_3072_ RF0.regs\[5\]\[29\] _0635_ _0639_ RF0.regs\[30\]\[29\] _0642_ VGND VGND VPWR
+ VPWR _1232_ sky130_fd_sc_hd__a221o_1
X_3974_ _0512_ _0611_ VGND VGND VPWR VPWR _2059_ sky130_fd_sc_hd__nand2_2
XFILLER_0_72_232 VGND VGND VPWR VPWR sky130_fd_sc_hd__decap_3
X_2925_ _1040_ _1060_ _1071_ _1082_ _1085_ VGND VGND VPWR VPWR _1086_ sky130_fd_sc_hd__o221a_1
XFILLER_0_72_265 VPWR VGND VPWR VGND sky130_ef_sc_hd__decap_12
XPHY_EDGE_ROW_17_Left_99 VGND VGND VPWR VPWR sky130_fd_sc_hd__decap_3
X_2856_ _1016_ _0816_ _1004_ VGND VGND VPWR VPWR _1017_ sky130_fd_sc_hd__mux2_1
XTAP_TAPCELL_ROW_13_290 VGND VPWR sky130_fd_sc_hd__tapvpwrvgnd_1
XFILLER_0_79_3 VPWR VGND VPWR VGND sky130_ef_sc_hd__decap_12
X_2787_ _0920_ _0927_ _0947_ VGND VGND VPWR VPWR _0948_ sky130_fd_sc_hd__a21o_1
XFILLER_0_60_449 VGND VGND VPWR VPWR sky130_fd_sc_hd__fill_1
X_4526_ _2278_ VGND VGND VPWR VPWR _0184_ sky130_fd_sc_hd__inv_2
X_4457_ _2268_ VGND VGND VPWR VPWR _0125_ sky130_fd_sc_hd__inv_2
XFILLER_0_0_281 VPWR VGND VPWR VGND sky130_ef_sc_hd__decap_12
X_3408_ RF0.regs\[20\]\[11\] _0625_ _0610_ RF0.regs\[15\]\[11\] _1564_ VGND VGND VPWR
+ VPWR _1565_ sky130_fd_sc_hd__a221o_1
X_4388_ _2259_ VGND VGND VPWR VPWR _0065_ sky130_fd_sc_hd__inv_2
X_3339_ RF0.regs\[15\]\[15\] _0609_ _0629_ RF0.regs\[10\]\[15\] VGND VGND VPWR VPWR
+ _1497_ sky130_fd_sc_hd__a22o_1
XFILLER_0_63_210 VGND VGND VPWR VPWR sky130_fd_sc_hd__fill_1
XFILLER_0_16_181 VGND VGND VPWR VPWR sky130_fd_sc_hd__fill_1
XFILLER_0_51_449 VGND VGND VPWR VPWR sky130_fd_sc_hd__decap_4
XFILLER_0_36_27 VGND VGND VPWR VPWR sky130_fd_sc_hd__fill_1
XTAP_TAPCELL_ROW_19_338 VGND VPWR sky130_fd_sc_hd__tapvpwrvgnd_1
XFILLER_0_52_15 VPWR VGND VPWR VGND sky130_ef_sc_hd__decap_12
X_2710_ _0715_ _0723_ VGND VGND VPWR VPWR _0871_ sky130_fd_sc_hd__xnor2_1
XFILLER_0_27_457 VGND VGND VPWR VPWR sky130_fd_sc_hd__fill_1
XFILLER_0_27_479 VGND VGND VPWR VPWR sky130_fd_sc_hd__decap_3
X_3690_ _1837_ net37 VGND VGND VPWR VPWR _1838_ sky130_fd_sc_hd__xnor2_4
XTAP_TAPCELL_ROW_10_260 VGND VPWR sky130_fd_sc_hd__tapvpwrvgnd_1
X_2641_ _0798_ _0799_ VGND VGND VPWR VPWR _0802_ sky130_fd_sc_hd__or2_4
X_2572_ _0730_ _0731_ _0732_ _0656_ VGND VGND VPWR VPWR _0733_ sky130_fd_sc_hd__o31a_1
X_4311_ _2247_ VGND VGND VPWR VPWR _2248_ sky130_fd_sc_hd__clkbuf_4
XFILLER_0_10_357 VGND VGND VPWR VPWR sky130_fd_sc_hd__decap_6
X_4242_ _2018_ RF0.regs\[30\]\[2\] _2192_ VGND VGND VPWR VPWR _2202_ sky130_fd_sc_hd__mux2_1
XFILLER_0_77_89 VGND VGND VPWR VPWR sky130_fd_sc_hd__decap_3
XFILLER_0_10_379 VGND VGND VPWR VPWR sky130_fd_sc_hd__decap_8
X_4173_ _2165_ VGND VGND VPWR VPWR _0291_ sky130_fd_sc_hd__clkbuf_1
X_3124_ _1058_ _1279_ _1283_ _1039_ VGND VGND VPWR VPWR _1284_ sky130_fd_sc_hd__o211a_1
X_3055_ _0988_ _0770_ _0986_ VGND VGND VPWR VPWR _1215_ sky130_fd_sc_hd__or3_1
XFILLER_0_26_71 VGND VGND VPWR VPWR sky130_fd_sc_hd__fill_2
XFILLER_0_26_82 VGND VGND VPWR VPWR sky130_fd_sc_hd__fill_2
XTAP_TAPCELL_ROW_53_628 VGND VPWR sky130_fd_sc_hd__tapvpwrvgnd_1
XFILLER_0_77_379 VPWR VGND VPWR VGND sky130_ef_sc_hd__decap_12
XFILLER_0_9_167 VGND VGND VPWR VPWR sky130_fd_sc_hd__fill_1
X_3957_ _2050_ VGND VGND VPWR VPWR _0392_ sky130_fd_sc_hd__clkbuf_1
XTAP_TAPCELL_ROW_61_694 VGND VPWR sky130_fd_sc_hd__tapvpwrvgnd_1
X_2908_ _0774_ _0778_ _1068_ VGND VGND VPWR VPWR _1069_ sky130_fd_sc_hd__mux2_1
X_3888_ _1625_ _1690_ VGND VGND VPWR VPWR _2011_ sky130_fd_sc_hd__xor2_4
X_2839_ _0711_ VGND VGND VPWR VPWR _1000_ sky130_fd_sc_hd__buf_2
XFILLER_0_33_449 VPWR VGND VPWR VGND sky130_ef_sc_hd__decap_12
X_4509_ _2277_ VGND VGND VPWR VPWR _0168_ sky130_fd_sc_hd__inv_2
XFILLER_0_6_92 VGND VGND VPWR VPWR sky130_fd_sc_hd__decap_8
XTAP_TAPCELL_ROW_69_761 VGND VPWR sky130_fd_sc_hd__tapvpwrvgnd_1
XTAP_TAPCELL_ROW_16_308 VGND VPWR sky130_fd_sc_hd__tapvpwrvgnd_1
XFILLER_0_22_29 VPWR VGND VPWR VGND sky130_ef_sc_hd__decap_12
XFILLER_0_51_279 VGND VGND VPWR VPWR sky130_fd_sc_hd__fill_1
XFILLER_0_47_15 VPWR VGND VPWR VGND sky130_ef_sc_hd__decap_12
XFILLER_0_63_69 VPWR VGND VPWR VGND sky130_ef_sc_hd__decap_12
X_4860_ clknet_leaf_26_clk _0510_ _0254_ VGND VGND VPWR VPWR IM0.addr\[30\] sky130_fd_sc_hd__dfrtp_1
XFILLER_0_74_338 VGND VGND VPWR VPWR sky130_fd_sc_hd__decap_4
XPHY_EDGE_ROW_25_Left_107 VGND VGND VPWR VPWR sky130_fd_sc_hd__decap_3
X_3811_ _1951_ RF0.regs\[5\]\[23\] _1835_ VGND VGND VPWR VPWR _1952_ sky130_fd_sc_hd__mux2_1
XFILLER_0_27_243 VGND VGND VPWR VPWR sky130_fd_sc_hd__decap_3
X_4791_ clknet_leaf_7_clk _0441_ _0185_ VGND VGND VPWR VPWR RF0.regs\[5\]\[25\] sky130_fd_sc_hd__dfrtp_1
XFILLER_0_15_405 VGND VGND VPWR VPWR sky130_fd_sc_hd__fill_1
X_3742_ _0711_ _1737_ _1882_ _1096_ VGND VGND VPWR VPWR _1883_ sky130_fd_sc_hd__o22a_1
XFILLER_0_15_449 VPWR VGND VPWR VGND sky130_ef_sc_hd__decap_12
XFILLER_0_42_235 VPWR VGND VPWR VGND sky130_ef_sc_hd__decap_12
X_3673_ _1205_ _1818_ _1823_ VGND VGND VPWR VPWR _1824_ sky130_fd_sc_hd__o21ai_1
XFILLER_0_2_321 VGND VGND VPWR VPWR sky130_fd_sc_hd__fill_1
XFILLER_0_42_279 VGND VGND VPWR VPWR sky130_fd_sc_hd__fill_1
X_2624_ _0783_ _0784_ VGND VGND VPWR VPWR _0785_ sky130_fd_sc_hd__or2_1
X_2555_ _0513_ IM0.addr\[0\] _0602_ VGND VGND VPWR VPWR _0716_ sky130_fd_sc_hd__nand3_4
XPHY_EDGE_ROW_34_Left_116 VGND VGND VPWR VPWR sky130_fd_sc_hd__decap_3
X_2486_ IM0.addr\[2\] IM0.addr\[0\] VGND VGND VPWR VPWR _0647_ sky130_fd_sc_hd__nand2_4
X_4225_ _2193_ VGND VGND VPWR VPWR _0267_ sky130_fd_sc_hd__clkbuf_1
X_4156_ _1993_ RF0.regs\[25\]\[11\] _2156_ VGND VGND VPWR VPWR _2157_ sky130_fd_sc_hd__mux2_1
X_3107_ _1001_ _1266_ VGND VGND VPWR VPWR _1267_ sky130_fd_sc_hd__nand2_1
X_4087_ _2097_ VGND VGND VPWR VPWR _2120_ sky130_fd_sc_hd__buf_4
XFILLER_0_77_110 VGND VGND VPWR VPWR sky130_fd_sc_hd__fill_2
X_3038_ RF0.regs\[5\]\[28\] _0635_ _0639_ RF0.regs\[30\]\[28\] _0642_ VGND VGND VPWR
+ VPWR _1198_ sky130_fd_sc_hd__a221o_1
XTAP_TAPCELL_ROW_38_499 VGND VPWR sky130_fd_sc_hd__tapvpwrvgnd_1
XPHY_EDGE_ROW_43_Left_125 VGND VGND VPWR VPWR sky130_fd_sc_hd__decap_3
XFILLER_0_77_187 VPWR VGND VPWR VGND sky130_ef_sc_hd__decap_12
XFILLER_0_77_176 VGND VGND VPWR VPWR sky130_fd_sc_hd__decap_8
XFILLER_0_18_276 VGND VGND VPWR VPWR sky130_fd_sc_hd__decap_4
XTAP_TAPCELL_ROW_21_355 VGND VPWR sky130_fd_sc_hd__tapvpwrvgnd_1
XFILLER_0_33_213 VGND VGND VPWR VPWR sky130_fd_sc_hd__fill_1
XFILLER_0_33_257 VGND VGND VPWR VPWR sky130_fd_sc_hd__decap_4
XPHY_EDGE_ROW_52_Left_134 VGND VGND VPWR VPWR sky130_fd_sc_hd__decap_3
XFILLER_0_17_18 VPWR VGND VPWR VGND sky130_ef_sc_hd__decap_12
XTAP_TAPCELL_ROW_29_422 VGND VPWR sky130_fd_sc_hd__tapvpwrvgnd_1
XPHY_EDGE_ROW_61_Left_143 VGND VGND VPWR VPWR sky130_fd_sc_hd__decap_3
XTAP_TAPCELL_ROW_72_789 VGND VPWR sky130_fd_sc_hd__tapvpwrvgnd_1
XFILLER_0_56_349 VGND VGND VPWR VPWR sky130_fd_sc_hd__fill_1
XFILLER_0_12_419 VGND VGND VPWR VPWR sky130_fd_sc_hd__fill_1
XPHY_EDGE_ROW_70_Left_152 VGND VGND VPWR VPWR sky130_fd_sc_hd__decap_3
X_2340_ _0522_ net67 VGND VGND VPWR VPWR _0493_ sky130_fd_sc_hd__nor2_1
X_4010_ _2078_ VGND VGND VPWR VPWR _0367_ sky130_fd_sc_hd__clkbuf_1
XTAP_TAPCELL_ROW_63_712 VGND VPWR sky130_fd_sc_hd__tapvpwrvgnd_1
XFILLER_0_59_165 VGND VGND VPWR VPWR sky130_fd_sc_hd__decap_3
XFILLER_0_74_157 VGND VGND VPWR VPWR sky130_fd_sc_hd__decap_3
X_4843_ clknet_leaf_0_clk _0493_ _0237_ VGND VGND VPWR VPWR IM0.addr\[13\] sky130_fd_sc_hd__dfrtp_1
XFILLER_0_23_61 VGND VGND VPWR VPWR sky130_fd_sc_hd__decap_8
XFILLER_0_7_446 VGND VGND VPWR VPWR sky130_fd_sc_hd__fill_2
X_4774_ clknet_leaf_0_clk _0424_ _0168_ VGND VGND VPWR VPWR RF0.regs\[5\]\[8\] sky130_fd_sc_hd__dfrtp_1
XFILLER_0_23_94 VGND VGND VPWR VPWR sky130_fd_sc_hd__decap_4
X_3725_ _1435_ _1439_ _1048_ VGND VGND VPWR VPWR _1866_ sky130_fd_sc_hd__mux2_1
XFILLER_0_55_393 VGND VGND VPWR VPWR sky130_fd_sc_hd__fill_2
Xclkbuf_leaf_9_clk clknet_1_1__leaf_clk VGND VGND VPWR VPWR clknet_leaf_9_clk sky130_fd_sc_hd__clkbuf_8
XFILLER_0_15_279 VGND VGND VPWR VPWR sky130_fd_sc_hd__fill_1
X_3656_ _1098_ _1456_ _1457_ _1804_ _1806_ VGND VGND VPWR VPWR _1807_ sky130_fd_sc_hd__o32a_1
XFILLER_0_70_385 VGND VGND VPWR VPWR sky130_fd_sc_hd__decap_6
X_2607_ _0767_ _0755_ VGND VGND VPWR VPWR _0768_ sky130_fd_sc_hd__and2b_1
XFILLER_0_11_430 VPWR VGND VPWR VGND sky130_ef_sc_hd__decap_12
X_3587_ _1134_ _1388_ VGND VGND VPWR VPWR _1739_ sky130_fd_sc_hd__nor2_1
XFILLER_0_61_3 VPWR VGND VPWR VGND sky130_ef_sc_hd__decap_12
X_2538_ RF0.regs\[15\]\[17\] _0663_ _0669_ RF0.regs\[5\]\[17\] VGND VGND VPWR VPWR
+ _0699_ sky130_fd_sc_hd__a22o_1
X_4208_ _2184_ VGND VGND VPWR VPWR _0275_ sky130_fd_sc_hd__clkbuf_1
X_2469_ _0629_ VGND VGND VPWR VPWR _0630_ sky130_fd_sc_hd__clkbuf_4
XFILLER_0_3_60 VGND VGND VPWR VPWR sky130_fd_sc_hd__decap_6
X_4139_ _1965_ RF0.regs\[25\]\[19\] _2145_ VGND VGND VPWR VPWR _2148_ sky130_fd_sc_hd__mux2_1
XFILLER_0_80_116 VGND VGND VPWR VPWR sky130_fd_sc_hd__fill_1
XFILLER_0_53_308 VGND VGND VPWR VPWR sky130_fd_sc_hd__decap_8
XFILLER_0_80_149 VGND VGND VPWR VPWR sky130_fd_sc_hd__fill_1
XPHY_EDGE_ROW_5_Left_87 VGND VGND VPWR VPWR sky130_fd_sc_hd__decap_3
XFILLER_0_44_27 VGND VGND VPWR VPWR sky130_fd_sc_hd__fill_1
XFILLER_0_44_49 VGND VGND VPWR VPWR sky130_fd_sc_hd__fill_1
XFILLER_0_29_305 VGND VGND VPWR VPWR sky130_fd_sc_hd__fill_1
XFILLER_0_56_135 VGND VGND VPWR VPWR sky130_fd_sc_hd__decap_4
XFILLER_0_60_15 VPWR VGND VPWR VGND sky130_ef_sc_hd__decap_12
XFILLER_0_37_360 VGND VGND VPWR VPWR sky130_fd_sc_hd__fill_2
XFILLER_0_37_371 VGND VGND VPWR VPWR sky130_fd_sc_hd__decap_6
X_3510_ _1655_ _1660_ _1664_ VGND VGND VPWR VPWR _1665_ sky130_fd_sc_hd__o21ai_1
XFILLER_0_52_341 VGND VGND VPWR VPWR sky130_fd_sc_hd__decap_3
XFILLER_0_69_57 VPWR VGND VPWR VGND sky130_ef_sc_hd__decap_12
X_4490_ _2272_ VGND VGND VPWR VPWR _0154_ sky130_fd_sc_hd__inv_2
X_3441_ _1038_ _1418_ _1203_ _1597_ _0651_ VGND VGND VPWR VPWR _1598_ sky130_fd_sc_hd__a32o_1
X_3372_ _0925_ _1489_ _1528_ VGND VGND VPWR VPWR _1529_ sky130_fd_sc_hd__a21bo_1
X_2323_ _0529_ _0539_ VGND VGND VPWR VPWR _0503_ sky130_fd_sc_hd__nor2_1
XTAP_TAPCELL_ROW_48_583 VGND VPWR sky130_fd_sc_hd__tapvpwrvgnd_1
XFILLER_0_47_113 VGND VGND VPWR VPWR sky130_fd_sc_hd__decap_6
X_4826_ clknet_leaf_14_clk _0476_ _0220_ VGND VGND VPWR VPWR RF0.regs\[0\]\[28\] sky130_fd_sc_hd__dfrtp_1
XFILLER_0_7_232 VGND VGND VPWR VPWR sky130_fd_sc_hd__fill_1
XFILLER_0_43_330 VGND VGND VPWR VPWR sky130_fd_sc_hd__decap_6
XFILLER_0_43_352 VGND VGND VPWR VPWR sky130_fd_sc_hd__fill_1
X_4757_ clknet_leaf_10_clk _0407_ _0151_ VGND VGND VPWR VPWR RF0.regs\[10\]\[23\]
+ sky130_fd_sc_hd__dfrtp_1
X_3708_ _1304_ _1360_ _1847_ VGND VGND VPWR VPWR _1852_ sky130_fd_sc_hd__or3_1
X_4688_ clknet_leaf_4_clk _0338_ _0082_ VGND VGND VPWR VPWR RF0.regs\[20\]\[18\] sky130_fd_sc_hd__dfrtp_1
X_3639_ _1433_ _1346_ VGND VGND VPWR VPWR _1790_ sky130_fd_sc_hd__nor2_1
XTAP_TAPCELL_ROW_74_807 VGND VPWR sky130_fd_sc_hd__tapvpwrvgnd_1
XFILLER_0_38_157 VGND VGND VPWR VPWR sky130_fd_sc_hd__fill_1
XFILLER_0_66_466 VGND VGND VPWR VPWR sky130_fd_sc_hd__decap_8
XFILLER_0_66_477 VGND VGND VPWR VPWR sky130_fd_sc_hd__decap_4
XFILLER_0_30_29 VPWR VGND VPWR VGND sky130_ef_sc_hd__decap_12
XFILLER_0_34_352 VGND VGND VPWR VPWR sky130_fd_sc_hd__fill_1
XFILLER_0_39_27 VGND VGND VPWR VPWR sky130_fd_sc_hd__decap_8
XFILLER_0_55_15 VPWR VGND VPWR VGND sky130_ef_sc_hd__decap_12
X_3990_ _1859_ RF0.regs\[15\]\[24\] _2060_ VGND VGND VPWR VPWR _2068_ sky130_fd_sc_hd__mux2_1
X_2941_ _0602_ _0636_ VGND VGND VPWR VPWR _1101_ sky130_fd_sc_hd__nand2_4
XFILLER_0_57_422 VGND VGND VPWR VPWR sky130_fd_sc_hd__fill_1
XFILLER_0_71_69 VGND VGND VPWR VPWR sky130_fd_sc_hd__decap_3
XFILLER_0_17_308 VGND VGND VPWR VPWR sky130_fd_sc_hd__decap_8
X_4611_ clknet_leaf_24_clk _0261_ _0005_ VGND VGND VPWR VPWR RF0.regs\[30\]\[5\] sky130_fd_sc_hd__dfrtp_1
X_2872_ _1027_ _1032_ _1019_ VGND VGND VPWR VPWR _1033_ sky130_fd_sc_hd__mux2_1
XFILLER_0_72_469 VGND VGND VPWR VPWR sky130_fd_sc_hd__decap_6
X_4542_ _2281_ VGND VGND VPWR VPWR _0197_ sky130_fd_sc_hd__inv_2
XFILLER_0_20_73 VGND VGND VPWR VPWR sky130_fd_sc_hd__decap_4
X_4473_ _2271_ VGND VGND VPWR VPWR _0138_ sky130_fd_sc_hd__inv_2
X_3424_ _1083_ _1348_ _1580_ _0651_ VGND VGND VPWR VPWR _1581_ sky130_fd_sc_hd__a22o_1
X_3355_ RF0.regs\[20\]\[13\] _0626_ _0630_ RF0.regs\[10\]\[13\] _1511_ VGND VGND VPWR
+ VPWR _1512_ sky130_fd_sc_hd__a221o_1
X_2306_ IM0.addr\[26\] _0530_ VGND VGND VPWR VPWR _0531_ sky130_fd_sc_hd__and2_1
X_3286_ _1097_ _1414_ _1443_ VGND VGND VPWR VPWR _1444_ sky130_fd_sc_hd__or3_4
XFILLER_0_24_3 VGND VGND VPWR VPWR sky130_fd_sc_hd__decap_3
XTAP_TAPCELL_ROW_0_167 VGND VPWR sky130_fd_sc_hd__tapvpwrvgnd_1
XTAP_TAPCELL_ROW_0_178 VGND VPWR sky130_fd_sc_hd__tapvpwrvgnd_1
XFILLER_0_48_477 VGND VGND VPWR VPWR sky130_fd_sc_hd__fill_1
XFILLER_0_63_414 VGND VGND VPWR VPWR sky130_fd_sc_hd__decap_6
XPHY_EDGE_ROW_17_Right_17 VGND VGND VPWR VPWR sky130_fd_sc_hd__decap_3
X_4809_ clknet_leaf_21_clk _0459_ _0203_ VGND VGND VPWR VPWR RF0.regs\[0\]\[11\] sky130_fd_sc_hd__dfrtp_1
XFILLER_0_16_363 VGND VGND VPWR VPWR sky130_fd_sc_hd__fill_1
XTAP_TAPCELL_ROW_8_245 VGND VPWR sky130_fd_sc_hd__tapvpwrvgnd_1
XPHY_EDGE_ROW_26_Right_26 VGND VGND VPWR VPWR sky130_fd_sc_hd__decap_3
XTAP_TAPCELL_ROW_59_678 VGND VPWR sky130_fd_sc_hd__tapvpwrvgnd_1
XFILLER_0_41_39 VGND VGND VPWR VPWR sky130_fd_sc_hd__fill_2
XTAP_TAPCELL_ROW_42_534 VGND VPWR sky130_fd_sc_hd__tapvpwrvgnd_1
XFILLER_0_66_241 VGND VGND VPWR VPWR sky130_fd_sc_hd__decap_3
XPHY_EDGE_ROW_35_Right_35 VGND VGND VPWR VPWR sky130_fd_sc_hd__decap_3
XFILLER_0_54_414 VGND VGND VPWR VPWR sky130_fd_sc_hd__decap_6
XFILLER_0_66_285 VGND VGND VPWR VPWR sky130_fd_sc_hd__decap_6
XFILLER_0_81_277 VGND VGND VPWR VPWR sky130_fd_sc_hd__decap_3
XFILLER_0_34_193 VGND VGND VPWR VPWR sky130_fd_sc_hd__decap_3
XFILLER_0_1_238 VGND VGND VPWR VPWR sky130_fd_sc_hd__decap_3
XPHY_EDGE_ROW_44_Right_44 VGND VGND VPWR VPWR sky130_fd_sc_hd__decap_3
XPHY_EDGE_ROW_8_Left_90 VGND VGND VPWR VPWR sky130_fd_sc_hd__decap_3
X_3140_ _1154_ VGND VGND VPWR VPWR _1300_ sky130_fd_sc_hd__buf_2
X_3071_ _0654_ _0989_ _1215_ _1230_ VGND VGND VPWR VPWR _1231_ sky130_fd_sc_hd__a31o_1
XFILLER_0_15_40 VGND VGND VPWR VPWR sky130_fd_sc_hd__fill_1
X_3973_ _2058_ VGND VGND VPWR VPWR _0384_ sky130_fd_sc_hd__clkbuf_1
XPHY_EDGE_ROW_53_Right_53 VGND VGND VPWR VPWR sky130_fd_sc_hd__decap_3
X_2924_ _1084_ VGND VGND VPWR VPWR _1085_ sky130_fd_sc_hd__clkbuf_4
X_2855_ RF0.regs\[10\]\[11\] _0616_ _0673_ RF0.regs\[25\]\[11\] VGND VGND VPWR VPWR
+ _1016_ sky130_fd_sc_hd__a22oi_2
XFILLER_0_45_447 VGND VGND VPWR VPWR sky130_fd_sc_hd__fill_1
XFILLER_0_45_469 VGND VGND VPWR VPWR sky130_fd_sc_hd__decap_8
XFILLER_0_72_277 VPWR VGND VPWR VGND sky130_ef_sc_hd__decap_12
XFILLER_0_60_428 VGND VGND VPWR VPWR sky130_fd_sc_hd__decap_8
XFILLER_0_13_344 VGND VGND VPWR VPWR sky130_fd_sc_hd__fill_2
XFILLER_0_13_322 VGND VGND VPWR VPWR sky130_fd_sc_hd__decap_4
XFILLER_0_13_311 VGND VGND VPWR VPWR sky130_fd_sc_hd__decap_6
X_2786_ _0933_ _0938_ _0942_ _0946_ VGND VGND VPWR VPWR _0947_ sky130_fd_sc_hd__or4_4
X_4525_ _2278_ VGND VGND VPWR VPWR _0183_ sky130_fd_sc_hd__inv_2
X_4456_ _2268_ VGND VGND VPWR VPWR _0124_ sky130_fd_sc_hd__inv_2
XPHY_EDGE_ROW_62_Right_62 VGND VGND VPWR VPWR sky130_fd_sc_hd__decap_3
X_4387_ _2259_ VGND VGND VPWR VPWR _0064_ sky130_fd_sc_hd__inv_2
X_3407_ RF0.regs\[5\]\[11\] _0633_ _0638_ RF0.regs\[30\]\[11\] _0641_ VGND VGND VPWR
+ VPWR _1564_ sky130_fd_sc_hd__a221o_1
XTAP_TAPCELL_ROW_5_215 VGND VPWR sky130_fd_sc_hd__tapvpwrvgnd_1
XFILLER_0_0_293 VGND VGND VPWR VPWR sky130_fd_sc_hd__decap_8
X_3338_ RF0.regs\[5\]\[15\] _0633_ _0637_ RF0.regs\[30\]\[15\] _0640_ VGND VGND VPWR
+ VPWR _1496_ sky130_fd_sc_hd__a221o_1
X_3269_ RF0.regs\[0\]\[22\] _0604_ _1426_ VGND VGND VPWR VPWR _1427_ sky130_fd_sc_hd__o21bai_1
XTAP_TAPCELL_ROW_56_648 VGND VPWR sky130_fd_sc_hd__tapvpwrvgnd_1
XPHY_EDGE_ROW_71_Right_71 VGND VGND VPWR VPWR sky130_fd_sc_hd__decap_3
XFILLER_0_48_241 VGND VGND VPWR VPWR sky130_fd_sc_hd__decap_8
XFILLER_0_36_425 VGND VGND VPWR VPWR sky130_fd_sc_hd__fill_1
XFILLER_0_63_222 VGND VGND VPWR VPWR sky130_fd_sc_hd__fill_2
XFILLER_0_36_458 VGND VGND VPWR VPWR sky130_fd_sc_hd__fill_1
XPHY_EDGE_ROW_80_Right_80 VGND VGND VPWR VPWR sky130_fd_sc_hd__decap_3
XTAP_TAPCELL_ROW_19_339 VGND VPWR sky130_fd_sc_hd__tapvpwrvgnd_1
XFILLER_0_52_27 VGND VGND VPWR VPWR sky130_fd_sc_hd__fill_1
XFILLER_0_27_425 VGND VGND VPWR VPWR sky130_fd_sc_hd__decap_4
XFILLER_0_14_119 VPWR VGND VPWR VGND sky130_ef_sc_hd__decap_12
X_2640_ _0800_ VGND VGND VPWR VPWR _0801_ sky130_fd_sc_hd__inv_2
XTAP_TAPCELL_ROW_10_261 VGND VPWR sky130_fd_sc_hd__tapvpwrvgnd_1
X_2571_ RF0.regs\[15\]\[9\] _0662_ _0667_ RF0.regs\[5\]\[9\] VGND VGND VPWR VPWR _0732_
+ sky130_fd_sc_hd__a22o_1
X_4310_ _2246_ VGND VGND VPWR VPWR _2247_ sky130_fd_sc_hd__buf_2
XFILLER_0_77_57 VPWR VGND VPWR VGND sky130_ef_sc_hd__decap_12
X_4241_ _2201_ VGND VGND VPWR VPWR _0259_ sky130_fd_sc_hd__clkbuf_1
X_4172_ _2015_ RF0.regs\[25\]\[3\] _2156_ VGND VGND VPWR VPWR _2165_ sky130_fd_sc_hd__mux2_1
X_3123_ _1058_ _1282_ VGND VGND VPWR VPWR _1283_ sky130_fd_sc_hd__nand2_1
X_3054_ _1205_ _1207_ _1213_ VGND VGND VPWR VPWR _1214_ sky130_fd_sc_hd__and3_1
XTAP_TAPCELL_ROW_53_629 VGND VPWR sky130_fd_sc_hd__tapvpwrvgnd_1
X_3956_ _2005_ RF0.regs\[10\]\[8\] _2046_ VGND VGND VPWR VPWR _2050_ sky130_fd_sc_hd__mux2_1
XTAP_TAPCELL_ROW_61_695 VGND VPWR sky130_fd_sc_hd__tapvpwrvgnd_1
X_2907_ _1044_ VGND VGND VPWR VPWR _1068_ sky130_fd_sc_hd__clkbuf_4
X_3887_ _2010_ VGND VGND VPWR VPWR _0422_ sky130_fd_sc_hd__clkbuf_1
XFILLER_0_33_406 VGND VGND VPWR VPWR sky130_fd_sc_hd__fill_1
X_2838_ _0762_ _0992_ _0997_ VGND VGND VPWR VPWR _0999_ sky130_fd_sc_hd__o21ai_1
X_2769_ _0747_ _0929_ VGND VGND VPWR VPWR _0930_ sky130_fd_sc_hd__nand2b_4
XFILLER_0_60_269 VGND VGND VPWR VPWR sky130_fd_sc_hd__decap_4
X_4508_ _2276_ VGND VGND VPWR VPWR _2277_ sky130_fd_sc_hd__buf_4
X_4439_ _2265_ VGND VGND VPWR VPWR _0110_ sky130_fd_sc_hd__inv_2
XTAP_TAPCELL_ROW_69_762 VGND VPWR sky130_fd_sc_hd__tapvpwrvgnd_1
XTAP_TAPCELL_ROW_16_309 VGND VPWR sky130_fd_sc_hd__tapvpwrvgnd_1
XFILLER_0_36_200 VGND VGND VPWR VPWR sky130_fd_sc_hd__fill_1
XFILLER_0_36_277 VGND VGND VPWR VPWR sky130_fd_sc_hd__fill_1
XFILLER_0_47_27 VPWR VGND VPWR VGND sky130_ef_sc_hd__decap_12
XFILLER_0_2_29 VGND VGND VPWR VPWR sky130_fd_sc_hd__fill_2
XFILLER_0_63_15 VPWR VGND VPWR VGND sky130_ef_sc_hd__decap_12
X_3810_ _1422_ _1950_ VGND VGND VPWR VPWR _1951_ sky130_fd_sc_hd__xnor2_2
X_4790_ clknet_leaf_6_clk _0440_ _0184_ VGND VGND VPWR VPWR RF0.regs\[5\]\[24\] sky130_fd_sc_hd__dfrtp_1
X_3741_ _1672_ _1292_ VGND VGND VPWR VPWR _1882_ sky130_fd_sc_hd__and2_1
XFILLER_0_6_127 VGND VGND VPWR VPWR sky130_fd_sc_hd__fill_1
XFILLER_0_27_288 VGND VGND VPWR VPWR sky130_fd_sc_hd__decap_3
X_3672_ _1040_ _1820_ _1822_ _1002_ VGND VGND VPWR VPWR _1823_ sky130_fd_sc_hd__a211o_1
XFILLER_0_42_247 VGND VGND VPWR VPWR sky130_fd_sc_hd__decap_4
X_2623_ RF0.regs\[10\]\[25\] _0617_ _0675_ RF0.regs\[25\]\[25\] VGND VGND VPWR VPWR
+ _0784_ sky130_fd_sc_hd__a22o_1
X_2554_ IM0.addr\[0\] _0650_ _0656_ _0714_ VGND VGND VPWR VPWR _0715_ sky130_fd_sc_hd__a22o_1
XFILLER_0_23_461 VGND VGND VPWR VPWR sky130_fd_sc_hd__decap_3
XFILLER_0_10_111 VPWR VGND VPWR VGND sky130_ef_sc_hd__decap_12
XFILLER_0_50_280 VGND VGND VPWR VPWR sky130_fd_sc_hd__decap_6
X_2485_ RF0.regs\[0\]\[31\] _0605_ _0645_ VGND VGND VPWR VPWR _0646_ sky130_fd_sc_hd__o21ai_1
XFILLER_0_10_177 VPWR VGND VPWR VGND sky130_ef_sc_hd__decap_12
X_4224_ _1993_ net140 _2192_ VGND VGND VPWR VPWR _2193_ sky130_fd_sc_hd__mux2_1
X_4155_ _2133_ VGND VGND VPWR VPWR _2156_ sky130_fd_sc_hd__clkbuf_4
X_3106_ _1261_ _1265_ _1037_ VGND VGND VPWR VPWR _1266_ sky130_fd_sc_hd__mux2_1
X_4086_ _2119_ VGND VGND VPWR VPWR _0332_ sky130_fd_sc_hd__clkbuf_1
X_3037_ RF0.regs\[10\]\[28\] _0631_ _0619_ RF0.regs\[25\]\[28\] VGND VGND VPWR VPWR
+ _1197_ sky130_fd_sc_hd__a22o_1
XFILLER_0_65_306 VGND VGND VPWR VPWR sky130_fd_sc_hd__decap_8
XFILLER_0_77_199 VPWR VGND VPWR VGND sky130_ef_sc_hd__decap_12
XFILLER_0_58_380 VGND VGND VPWR VPWR sky130_fd_sc_hd__decap_8
XFILLER_0_73_361 VGND VGND VPWR VPWR sky130_fd_sc_hd__decap_4
X_3939_ _1975_ RF0.regs\[10\]\[16\] _2035_ VGND VGND VPWR VPWR _2041_ sky130_fd_sc_hd__mux2_1
XFILLER_0_18_299 VGND VGND VPWR VPWR sky130_fd_sc_hd__decap_8
XFILLER_0_18_288 VGND VGND VPWR VPWR sky130_fd_sc_hd__decap_4
XTAP_TAPCELL_ROW_21_356 VGND VPWR sky130_fd_sc_hd__tapvpwrvgnd_1
XFILLER_0_33_225 VPWR VGND VPWR VGND sky130_ef_sc_hd__decap_12
XTAP_TAPCELL_ROW_29_423 VGND VPWR sky130_fd_sc_hd__tapvpwrvgnd_1
XFILLER_0_56_317 VGND VGND VPWR VPWR sky130_fd_sc_hd__decap_3
XFILLER_0_68_188 VGND VGND VPWR VPWR sky130_fd_sc_hd__decap_8
XFILLER_0_49_391 VGND VGND VPWR VPWR sky130_fd_sc_hd__fill_1
XFILLER_0_58_15 VPWR VGND VPWR VGND sky130_ef_sc_hd__decap_12
XTAP_TAPCELL_ROW_63_713 VGND VPWR sky130_fd_sc_hd__tapvpwrvgnd_1
XFILLER_0_23_73 VGND VGND VPWR VPWR sky130_fd_sc_hd__decap_6
X_4842_ clknet_leaf_0_clk _0492_ _0236_ VGND VGND VPWR VPWR IM0.addr\[12\] sky130_fd_sc_hd__dfrtp_1
X_4773_ clknet_leaf_22_clk _0423_ _0167_ VGND VGND VPWR VPWR RF0.regs\[5\]\[7\] sky130_fd_sc_hd__dfrtp_1
XFILLER_0_62_309 VPWR VGND VPWR VGND sky130_ef_sc_hd__decap_12
XFILLER_0_15_225 VGND VGND VPWR VPWR sky130_fd_sc_hd__decap_4
X_3724_ _1533_ VGND VGND VPWR VPWR _1865_ sky130_fd_sc_hd__inv_2
X_3655_ _1001_ _1805_ VGND VGND VPWR VPWR _1806_ sky130_fd_sc_hd__nor2_1
X_2606_ _0659_ _0680_ _0754_ _0626_ VGND VGND VPWR VPWR _0767_ sky130_fd_sc_hd__a31o_1
XFILLER_0_11_442 VGND VGND VPWR VPWR sky130_fd_sc_hd__decap_6
X_3586_ _1151_ _1737_ VGND VGND VPWR VPWR _1738_ sky130_fd_sc_hd__nand2_1
X_2537_ _0657_ _0697_ VGND VGND VPWR VPWR _0698_ sky130_fd_sc_hd__nand2_1
X_2468_ _0628_ VGND VGND VPWR VPWR _0629_ sky130_fd_sc_hd__clkbuf_4
XFILLER_0_54_3 VPWR VGND VPWR VGND sky130_ef_sc_hd__decap_12
X_4207_ _1965_ net150 _2181_ VGND VGND VPWR VPWR _2184_ sky130_fd_sc_hd__mux2_1
X_2399_ _0574_ VGND VGND VPWR VPWR _0462_ sky130_fd_sc_hd__clkbuf_1
X_4138_ _2147_ VGND VGND VPWR VPWR _0308_ sky130_fd_sc_hd__clkbuf_1
X_4069_ net123 _1959_ _2109_ VGND VGND VPWR VPWR _2111_ sky130_fd_sc_hd__mux2_1
XFILLER_0_64_80 VGND VGND VPWR VPWR sky130_fd_sc_hd__fill_1
XFILLER_0_78_475 VGND VGND VPWR VPWR sky130_fd_sc_hd__fill_1
XFILLER_0_61_320 VPWR VGND VPWR VGND sky130_ef_sc_hd__decap_12
XFILLER_0_28_29 VGND VGND VPWR VPWR sky130_fd_sc_hd__decap_6
XTAP_TAPCELL_ROW_77_827 VGND VPWR sky130_fd_sc_hd__tapvpwrvgnd_1
XFILLER_0_60_27 VGND VGND VPWR VPWR sky130_fd_sc_hd__fill_1
XFILLER_0_44_309 VPWR VGND VPWR VGND sky130_ef_sc_hd__decap_12
XFILLER_0_12_228 VGND VGND VPWR VPWR sky130_fd_sc_hd__fill_1
XFILLER_0_12_239 VGND VGND VPWR VPWR sky130_fd_sc_hd__decap_8
X_3440_ _1595_ _1596_ VGND VGND VPWR VPWR _1597_ sky130_fd_sc_hd__and2_1
XFILLER_0_69_69 VGND VGND VPWR VPWR sky130_fd_sc_hd__decap_3
X_3371_ _0910_ _0918_ VGND VGND VPWR VPWR _1528_ sky130_fd_sc_hd__and2b_1
X_2322_ net86 _0528_ VGND VGND VPWR VPWR _0539_ sky130_fd_sc_hd__nor2_1
XFILLER_0_20_272 VGND VGND VPWR VPWR sky130_fd_sc_hd__decap_8
XTAP_TAPCELL_ROW_48_584 VGND VPWR sky130_fd_sc_hd__tapvpwrvgnd_1
XFILLER_0_75_445 VGND VGND VPWR VPWR sky130_fd_sc_hd__decap_3
XFILLER_0_47_125 VPWR VGND VPWR VGND sky130_ef_sc_hd__decap_12
X_4825_ clknet_leaf_14_clk _0475_ _0219_ VGND VGND VPWR VPWR RF0.regs\[0\]\[27\] sky130_fd_sc_hd__dfrtp_1
XFILLER_0_47_169 VPWR VGND VPWR VGND sky130_ef_sc_hd__decap_12
XTAP_TAPCELL_ROW_31_440 VGND VPWR sky130_fd_sc_hd__tapvpwrvgnd_1
X_4756_ clknet_leaf_11_clk _0406_ _0150_ VGND VGND VPWR VPWR RF0.regs\[10\]\[22\]
+ sky130_fd_sc_hd__dfrtp_1
X_4687_ clknet_leaf_5_clk _0337_ _0081_ VGND VGND VPWR VPWR RF0.regs\[20\]\[17\] sky130_fd_sc_hd__dfrtp_1
X_3707_ _1851_ VGND VGND VPWR VPWR _0443_ sky130_fd_sc_hd__clkbuf_1
XFILLER_0_3_461 VPWR VGND VPWR VGND sky130_ef_sc_hd__decap_12
X_3638_ _1551_ _1713_ _1750_ _1788_ VGND VGND VPWR VPWR _1789_ sky130_fd_sc_hd__o211ai_2
X_3569_ _1154_ _1331_ _1203_ VGND VGND VPWR VPWR _1722_ sky130_fd_sc_hd__a21o_1
XTAP_TAPCELL_ROW_74_808 VGND VPWR sky130_fd_sc_hd__tapvpwrvgnd_1
Xclone1 net35 VGND VGND VPWR VPWR net69 sky130_fd_sc_hd__buf_2
XTAP_TAPCELL_ROW_3_198 VGND VPWR sky130_fd_sc_hd__tapvpwrvgnd_1
XFILLER_0_53_139 VGND VGND VPWR VPWR sky130_fd_sc_hd__decap_8
XFILLER_0_34_331 VGND VGND VPWR VPWR sky130_fd_sc_hd__fill_1
XFILLER_0_61_194 VGND VGND VPWR VPWR sky130_fd_sc_hd__fill_2
XFILLER_0_55_27 VPWR VGND VPWR VGND sky130_ef_sc_hd__decap_12
XFILLER_0_69_261 VGND VGND VPWR VPWR sky130_fd_sc_hd__decap_3
XFILLER_0_71_15 VPWR VGND VPWR VGND sky130_ef_sc_hd__decap_12
X_2940_ _0766_ _0989_ _0991_ VGND VGND VPWR VPWR _1100_ sky130_fd_sc_hd__and3_1
X_2871_ _1029_ _1031_ _1009_ VGND VGND VPWR VPWR _1032_ sky130_fd_sc_hd__mux2_1
XFILLER_0_29_147 VGND VGND VPWR VPWR sky130_fd_sc_hd__fill_2
XFILLER_0_29_158 VGND VGND VPWR VPWR sky130_fd_sc_hd__fill_1
X_4610_ clknet_leaf_24_clk _0260_ _0004_ VGND VGND VPWR VPWR RF0.regs\[30\]\[4\] sky130_fd_sc_hd__dfrtp_1
X_4541_ _2281_ VGND VGND VPWR VPWR _0196_ sky130_fd_sc_hd__inv_2
XFILLER_0_4_236 VPWR VGND VPWR VGND sky130_ef_sc_hd__decap_12
XFILLER_0_80_481 VGND VGND VPWR VPWR sky130_fd_sc_hd__fill_1
X_4472_ _2271_ VGND VGND VPWR VPWR _0137_ sky130_fd_sc_hd__inv_2
XFILLER_0_40_323 VGND VGND VPWR VPWR sky130_fd_sc_hd__fill_1
X_3423_ _1557_ _1579_ VGND VGND VPWR VPWR _1580_ sky130_fd_sc_hd__nor2_1
X_3354_ RF0.regs\[5\]\[13\] _0634_ _0638_ RF0.regs\[30\]\[13\] _0641_ VGND VGND VPWR
+ VPWR _1511_ sky130_fd_sc_hd__a221o_1
X_2305_ IM0.addr\[25\] IM0.addr\[24\] _0529_ VGND VGND VPWR VPWR _0530_ sky130_fd_sc_hd__and3_1
XFILLER_0_29_94 VGND VGND VPWR VPWR sky130_fd_sc_hd__fill_2
X_3285_ _0968_ _0973_ _1413_ VGND VGND VPWR VPWR _1443_ sky130_fd_sc_hd__and3_1
XFILLER_0_17_3 VGND VGND VPWR VPWR sky130_fd_sc_hd__decap_6
XTAP_TAPCELL_ROW_0_168 VGND VPWR sky130_fd_sc_hd__tapvpwrvgnd_1
XTAP_TAPCELL_ROW_0_179 VGND VPWR sky130_fd_sc_hd__tapvpwrvgnd_1
X_4808_ clknet_leaf_21_clk _0458_ _0202_ VGND VGND VPWR VPWR RF0.regs\[0\]\[10\] sky130_fd_sc_hd__dfrtp_1
X_4739_ clknet_leaf_19_clk _0389_ _0133_ VGND VGND VPWR VPWR RF0.regs\[10\]\[5\] sky130_fd_sc_hd__dfrtp_2
XFILLER_0_71_481 VGND VGND VPWR VPWR sky130_fd_sc_hd__fill_1
XTAP_TAPCELL_ROW_8_246 VGND VPWR sky130_fd_sc_hd__tapvpwrvgnd_1
XTAP_TAPCELL_ROW_59_679 VGND VPWR sky130_fd_sc_hd__tapvpwrvgnd_1
XFILLER_0_58_209 VGND VGND VPWR VPWR sky130_fd_sc_hd__decap_3
XTAP_TAPCELL_ROW_42_535 VGND VPWR sky130_fd_sc_hd__tapvpwrvgnd_1
XFILLER_0_26_139 VGND VGND VPWR VPWR sky130_fd_sc_hd__fill_1
XFILLER_0_81_289 VGND VGND VPWR VPWR sky130_fd_sc_hd__decap_8
XFILLER_0_62_470 VGND VGND VPWR VPWR sky130_fd_sc_hd__decap_6
XFILLER_0_62_481 VGND VGND VPWR VPWR sky130_fd_sc_hd__fill_1
XFILLER_0_66_15 VPWR VGND VPWR VGND sky130_ef_sc_hd__decap_12
X_3070_ _1002_ _1150_ _1229_ VGND VGND VPWR VPWR _1230_ sky130_fd_sc_hd__and3_1
X_3972_ RF0.regs\[10\]\[0\] VGND VGND VPWR VPWR _2058_ sky130_fd_sc_hd__clkbuf_1
XFILLER_0_57_231 VGND VGND VPWR VPWR sky130_fd_sc_hd__decap_4
XFILLER_0_17_106 VGND VGND VPWR VPWR sky130_fd_sc_hd__decap_6
X_2923_ _1083_ VGND VGND VPWR VPWR _1084_ sky130_fd_sc_hd__clkbuf_4
XFILLER_0_17_139 VPWR VGND VPWR VGND sky130_ef_sc_hd__decap_12
X_2854_ _0823_ _1013_ _1014_ VGND VGND VPWR VPWR _1015_ sky130_fd_sc_hd__mux2_1
XFILLER_0_31_51 VGND VGND VPWR VPWR sky130_fd_sc_hd__decap_4
XFILLER_0_72_289 VGND VGND VPWR VPWR sky130_fd_sc_hd__decap_8
X_2785_ _0944_ _0945_ VGND VGND VPWR VPWR _0946_ sky130_fd_sc_hd__xnor2_2
X_4524_ _2278_ VGND VGND VPWR VPWR _0182_ sky130_fd_sc_hd__inv_2
XFILLER_0_40_131 VGND VGND VPWR VPWR sky130_fd_sc_hd__fill_2
X_4455_ _2267_ VGND VGND VPWR VPWR _2268_ sky130_fd_sc_hd__clkbuf_2
X_4386_ _2258_ VGND VGND VPWR VPWR _2259_ sky130_fd_sc_hd__buf_4
X_3406_ RF0.regs\[10\]\[11\] _0630_ _0618_ RF0.regs\[25\]\[11\] VGND VGND VPWR VPWR
+ _1563_ sky130_fd_sc_hd__a22o_1
XTAP_TAPCELL_ROW_5_216 VGND VPWR sky130_fd_sc_hd__tapvpwrvgnd_1
X_3337_ _1487_ _1494_ VGND VGND VPWR VPWR _1495_ sky130_fd_sc_hd__nor2_1
X_3268_ _1423_ _1425_ VGND VGND VPWR VPWR _1426_ sky130_fd_sc_hd__nor2_1
X_3199_ _1355_ _1357_ VGND VGND VPWR VPWR _1358_ sky130_fd_sc_hd__or2_1
XTAP_TAPCELL_ROW_56_649 VGND VPWR sky130_fd_sc_hd__tapvpwrvgnd_1
XFILLER_0_72_80 VGND VGND VPWR VPWR sky130_fd_sc_hd__decap_4
XFILLER_0_48_253 VGND VGND VPWR VPWR sky130_fd_sc_hd__decap_4
XFILLER_0_36_448 VGND VGND VPWR VPWR sky130_fd_sc_hd__fill_1
XFILLER_0_48_297 VGND VGND VPWR VPWR sky130_fd_sc_hd__fill_1
XFILLER_0_16_150 VGND VGND VPWR VPWR sky130_fd_sc_hd__decap_3
XFILLER_0_8_394 VGND VGND VPWR VPWR sky130_fd_sc_hd__decap_3
XFILLER_0_6_3 VPWR VGND VPWR VGND sky130_ef_sc_hd__decap_12
XFILLER_0_36_29 VGND VGND VPWR VPWR sky130_fd_sc_hd__fill_1
XFILLER_0_6_309 VPWR VGND VPWR VGND sky130_ef_sc_hd__decap_12
XFILLER_0_42_429 VGND VGND VPWR VPWR sky130_fd_sc_hd__decap_8
XTAP_TAPCELL_ROW_10_262 VGND VPWR sky130_fd_sc_hd__tapvpwrvgnd_1
XFILLER_0_22_120 VGND VGND VPWR VPWR sky130_fd_sc_hd__fill_2
X_2570_ RF0.regs\[15\]\[10\] _0662_ _0667_ RF0.regs\[5\]\[10\] VGND VGND VPWR VPWR
+ _0731_ sky130_fd_sc_hd__a22o_1
XFILLER_0_77_69 VPWR VGND VPWR VGND sky130_ef_sc_hd__decap_12
X_4240_ _2015_ RF0.regs\[30\]\[3\] _2192_ VGND VGND VPWR VPWR _2201_ sky130_fd_sc_hd__mux2_1
X_4171_ _2164_ VGND VGND VPWR VPWR _0292_ sky130_fd_sc_hd__clkbuf_1
X_3122_ _1280_ _1281_ _1075_ VGND VGND VPWR VPWR _1282_ sky130_fd_sc_hd__mux2_1
X_3053_ _1136_ _1212_ VGND VGND VPWR VPWR _1213_ sky130_fd_sc_hd__nand2_1
XFILLER_0_77_315 VGND VGND VPWR VPWR sky130_fd_sc_hd__decap_3
XFILLER_0_77_359 VGND VGND VPWR VPWR sky130_fd_sc_hd__decap_4
XFILLER_0_18_415 VGND VGND VPWR VPWR sky130_fd_sc_hd__decap_4
X_3955_ _2049_ VGND VGND VPWR VPWR _0393_ sky130_fd_sc_hd__clkbuf_1
XFILLER_0_9_169 VPWR VGND VPWR VGND sky130_ef_sc_hd__decap_12
XFILLER_0_42_94 VPWR VGND VPWR VGND sky130_ef_sc_hd__decap_12
XTAP_TAPCELL_ROW_61_696 VGND VPWR sky130_fd_sc_hd__tapvpwrvgnd_1
X_2906_ _0784_ _0789_ _1044_ VGND VGND VPWR VPWR _1067_ sky130_fd_sc_hd__mux2_1
X_3886_ _2009_ RF0.regs\[5\]\[6\] _1994_ VGND VGND VPWR VPWR _2010_ sky130_fd_sc_hd__mux2_1
XFILLER_0_60_204 VGND VGND VPWR VPWR sky130_fd_sc_hd__fill_1
X_2837_ _0762_ _0992_ _0997_ VGND VGND VPWR VPWR _0998_ sky130_fd_sc_hd__or3_1
XFILLER_0_60_215 VGND VGND VPWR VPWR sky130_fd_sc_hd__fill_2
XFILLER_0_60_237 VGND VGND VPWR VPWR sky130_fd_sc_hd__decap_6
X_2768_ _0698_ _0700_ _0745_ _0928_ VGND VGND VPWR VPWR _0929_ sky130_fd_sc_hd__a31o_1
X_2699_ RF0.regs\[10\]\[4\] _0614_ _0670_ RF0.regs\[25\]\[4\] VGND VGND VPWR VPWR
+ _0860_ sky130_fd_sc_hd__a22oi_2
X_4507_ reset VGND VGND VPWR VPWR _2276_ sky130_fd_sc_hd__buf_1
X_4438_ _2265_ VGND VGND VPWR VPWR _0109_ sky130_fd_sc_hd__inv_2
X_4369_ _2253_ VGND VGND VPWR VPWR _2256_ sky130_fd_sc_hd__buf_4
XTAP_TAPCELL_ROW_69_763 VGND VPWR sky130_fd_sc_hd__tapvpwrvgnd_1
XFILLER_0_68_304 VGND VGND VPWR VPWR sky130_fd_sc_hd__fill_1
XTAP_TAPCELL_ROW_24_376 VGND VPWR sky130_fd_sc_hd__tapvpwrvgnd_1
XFILLER_0_36_234 VPWR VGND VPWR VGND sky130_ef_sc_hd__decap_12
XFILLER_0_24_418 VGND VGND VPWR VPWR sky130_fd_sc_hd__fill_2
XFILLER_0_17_481 VGND VGND VPWR VPWR sky130_fd_sc_hd__fill_1
XFILLER_0_51_248 VGND VGND VPWR VPWR sky130_fd_sc_hd__decap_8
XFILLER_0_51_259 VGND VGND VPWR VPWR sky130_fd_sc_hd__fill_1
XFILLER_0_47_39 VGND VGND VPWR VPWR sky130_fd_sc_hd__decap_8
XFILLER_0_63_27 VPWR VGND VPWR VGND sky130_ef_sc_hd__decap_12
XFILLER_0_59_359 VGND VGND VPWR VPWR sky130_fd_sc_hd__decap_6
XFILLER_0_12_20 VGND VGND VPWR VPWR sky130_fd_sc_hd__fill_1
X_3740_ _1096_ _1592_ _1607_ _1880_ VGND VGND VPWR VPWR _1881_ sky130_fd_sc_hd__o31a_1
XFILLER_0_27_223 VGND VGND VPWR VPWR sky130_fd_sc_hd__fill_1
XFILLER_0_6_139 VGND VGND VPWR VPWR sky130_fd_sc_hd__fill_1
XFILLER_0_12_97 VGND VGND VPWR VPWR sky130_fd_sc_hd__fill_1
X_3671_ _1040_ _1821_ VGND VGND VPWR VPWR _1822_ sky130_fd_sc_hd__nor2_1
XFILLER_0_42_259 VGND VGND VPWR VPWR sky130_fd_sc_hd__fill_1
X_2622_ _0752_ _0782_ VGND VGND VPWR VPWR _0783_ sky130_fd_sc_hd__nand2_1
X_2553_ RF0.regs\[15\]\[2\] _0661_ _0666_ RF0.regs\[5\]\[2\] VGND VGND VPWR VPWR _0714_
+ sky130_fd_sc_hd__a22o_1
XFILLER_0_10_123 VPWR VGND VPWR VGND sky130_ef_sc_hd__decap_12
X_2484_ _0620_ _0644_ VGND VGND VPWR VPWR _0645_ sky130_fd_sc_hd__or2_1
XFILLER_0_10_189 VGND VGND VPWR VPWR sky130_fd_sc_hd__fill_1
X_4223_ _2169_ VGND VGND VPWR VPWR _2192_ sky130_fd_sc_hd__clkbuf_4
X_4154_ _2155_ VGND VGND VPWR VPWR _0300_ sky130_fd_sc_hd__clkbuf_1
X_4085_ RF0.regs\[20\]\[12\] _1990_ _2109_ VGND VGND VPWR VPWR _2119_ sky130_fd_sc_hd__mux2_1
XFILLER_0_37_61 VGND VGND VPWR VPWR sky130_fd_sc_hd__fill_1
X_3105_ _1264_ VGND VGND VPWR VPWR _1265_ sky130_fd_sc_hd__inv_2
X_3036_ _1098_ _0986_ _1195_ VGND VGND VPWR VPWR _1196_ sky130_fd_sc_hd__nor3_1
XTAP_TAPCELL_ROW_66_733 VGND VPWR sky130_fd_sc_hd__tapvpwrvgnd_1
XFILLER_0_77_167 VGND VGND VPWR VPWR sky130_fd_sc_hd__fill_1
XFILLER_0_65_318 VGND VGND VPWR VPWR sky130_fd_sc_hd__decap_8
XFILLER_0_18_234 VGND VGND VPWR VPWR sky130_fd_sc_hd__decap_8
X_3938_ _2040_ VGND VGND VPWR VPWR _0401_ sky130_fd_sc_hd__clkbuf_1
XTAP_TAPCELL_ROW_21_357 VGND VPWR sky130_fd_sc_hd__tapvpwrvgnd_1
X_3869_ _1707_ _1996_ VGND VGND VPWR VPWR _1997_ sky130_fd_sc_hd__xor2_2
XFILLER_0_33_237 VPWR VGND VPWR VGND sky130_ef_sc_hd__decap_12
XTAP_TAPCELL_ROW_29_424 VGND VPWR sky130_fd_sc_hd__tapvpwrvgnd_1
XTAP_TAPCELL_ROW_37_490 VGND VPWR sky130_fd_sc_hd__tapvpwrvgnd_1
XFILLER_0_56_307 VGND VGND VPWR VPWR sky130_fd_sc_hd__fill_1
XFILLER_0_64_395 VGND VGND VPWR VPWR sky130_fd_sc_hd__decap_4
XFILLER_0_24_259 VGND VGND VPWR VPWR sky130_fd_sc_hd__fill_1
XFILLER_0_20_421 VGND VGND VPWR VPWR sky130_fd_sc_hd__fill_1
XFILLER_0_32_292 VGND VGND VPWR VPWR sky130_fd_sc_hd__decap_6
XFILLER_0_58_27 VGND VGND VPWR VPWR sky130_fd_sc_hd__fill_1
XFILLER_0_74_15 VPWR VGND VPWR VGND sky130_ef_sc_hd__decap_12
XFILLER_0_59_145 VGND VGND VPWR VPWR sky130_fd_sc_hd__decap_3
XTAP_TAPCELL_ROW_63_714 VGND VPWR sky130_fd_sc_hd__tapvpwrvgnd_1
X_4841_ clknet_leaf_0_clk _0491_ _0235_ VGND VGND VPWR VPWR IM0.addr\[11\] sky130_fd_sc_hd__dfrtp_1
X_4772_ clknet_leaf_25_clk _0422_ _0166_ VGND VGND VPWR VPWR RF0.regs\[5\]\[6\] sky130_fd_sc_hd__dfrtp_1
XTAP_TAPCELL_ROW_71_780 VGND VPWR sky130_fd_sc_hd__tapvpwrvgnd_1
XFILLER_0_15_204 VGND VGND VPWR VPWR sky130_fd_sc_hd__decap_3
X_3723_ _1725_ _1730_ VGND VGND VPWR VPWR _1864_ sky130_fd_sc_hd__and2b_1
X_3654_ _1320_ _1318_ _1224_ _1227_ _1064_ _1135_ VGND VGND VPWR VPWR _1805_ sky130_fd_sc_hd__mux4_1
X_2605_ _0764_ _0765_ VGND VGND VPWR VPWR _0766_ sky130_fd_sc_hd__nand2_1
XFILLER_0_70_365 VGND VGND VPWR VPWR sky130_fd_sc_hd__fill_1
X_3585_ _1433_ _1395_ VGND VGND VPWR VPWR _1737_ sky130_fd_sc_hd__or2_1
XFILLER_0_23_270 VGND VGND VPWR VPWR sky130_fd_sc_hd__decap_6
X_2536_ RF0.regs\[15\]\[18\] _0663_ _0669_ RF0.regs\[5\]\[18\] VGND VGND VPWR VPWR
+ _0697_ sky130_fd_sc_hd__a22o_1
X_2467_ _0514_ _0607_ VGND VGND VPWR VPWR _0628_ sky130_fd_sc_hd__and2b_2
XFILLER_0_47_3 VPWR VGND VPWR VGND sky130_ef_sc_hd__decap_12
X_4206_ _2183_ VGND VGND VPWR VPWR _0276_ sky130_fd_sc_hd__clkbuf_1
X_2398_ net92 VGND VGND VPWR VPWR _0574_ sky130_fd_sc_hd__clkbuf_1
X_4137_ _1959_ RF0.regs\[25\]\[20\] _2145_ VGND VGND VPWR VPWR _2147_ sky130_fd_sc_hd__mux2_1
XFILLER_0_78_421 VPWR VGND VPWR VGND sky130_ef_sc_hd__decap_12
X_4068_ _2110_ VGND VGND VPWR VPWR _0341_ sky130_fd_sc_hd__clkbuf_1
X_3019_ _1176_ _1178_ _1011_ VGND VGND VPWR VPWR _1179_ sky130_fd_sc_hd__mux2_1
XFILLER_0_65_148 VGND VGND VPWR VPWR sky130_fd_sc_hd__fill_2
XFILLER_0_80_91 VGND VGND VPWR VPWR sky130_fd_sc_hd__fill_1
XFILLER_0_65_159 VGND VGND VPWR VPWR sky130_fd_sc_hd__fill_1
XFILLER_0_6_481 VGND VGND VPWR VPWR sky130_fd_sc_hd__fill_1
XFILLER_0_61_332 VGND VGND VPWR VPWR sky130_fd_sc_hd__decap_4
XTAP_TAPCELL_ROW_77_828 VGND VPWR sky130_fd_sc_hd__tapvpwrvgnd_1
XFILLER_0_44_29 VPWR VGND VPWR VGND sky130_ef_sc_hd__decap_12
XFILLER_0_69_421 VPWR VGND VPWR VGND sky130_ef_sc_hd__decap_12
XFILLER_0_71_129 VGND VGND VPWR VPWR sky130_fd_sc_hd__fill_1
XFILLER_0_8_29 VGND VGND VPWR VPWR sky130_fd_sc_hd__fill_1
XFILLER_0_52_321 VPWR VGND VPWR VGND sky130_ef_sc_hd__decap_12
XFILLER_0_69_15 VPWR VGND VPWR VGND sky130_ef_sc_hd__decap_12
X_3370_ _1518_ _1526_ _1038_ VGND VGND VPWR VPWR _1527_ sky130_fd_sc_hd__mux2_1
X_2321_ net58 _0529_ VGND VGND VPWR VPWR _0504_ sky130_fd_sc_hd__xor2_1
XFILLER_0_20_262 VGND VGND VPWR VPWR sky130_fd_sc_hd__fill_1
XFILLER_0_20_295 VGND VGND VPWR VPWR sky130_fd_sc_hd__fill_1
XFILLER_0_18_85 VPWR VGND VPWR VGND sky130_ef_sc_hd__decap_12
XTAP_TAPCELL_ROW_48_585 VGND VPWR sky130_fd_sc_hd__tapvpwrvgnd_1
XFILLER_0_75_413 VPWR VGND VPWR VGND sky130_ef_sc_hd__decap_12
XFILLER_0_47_137 VGND VGND VPWR VPWR sky130_fd_sc_hd__decap_4
X_4824_ clknet_leaf_14_clk _0474_ _0218_ VGND VGND VPWR VPWR RF0.regs\[0\]\[26\] sky130_fd_sc_hd__dfrtp_1
XTAP_TAPCELL_ROW_31_441 VGND VPWR sky130_fd_sc_hd__tapvpwrvgnd_1
X_4755_ clknet_leaf_9_clk _0405_ _0149_ VGND VGND VPWR VPWR RF0.regs\[10\]\[21\] sky130_fd_sc_hd__dfrtp_2
XFILLER_0_43_321 VGND VGND VPWR VPWR sky130_fd_sc_hd__fill_1
XFILLER_0_55_192 VGND VGND VPWR VPWR sky130_fd_sc_hd__decap_6
X_3706_ _1850_ RF0.regs\[5\]\[27\] _1835_ VGND VGND VPWR VPWR _1851_ sky130_fd_sc_hd__mux2_1
X_4686_ clknet_leaf_5_clk _0336_ _0080_ VGND VGND VPWR VPWR RF0.regs\[20\]\[16\] sky130_fd_sc_hd__dfrtp_1
X_3637_ _1766_ _1787_ VGND VGND VPWR VPWR _1788_ sky130_fd_sc_hd__nor2_1
XFILLER_0_3_473 VGND VGND VPWR VPWR sky130_fd_sc_hd__decap_8
X_3568_ _1718_ _1719_ _0946_ VGND VGND VPWR VPWR _1721_ sky130_fd_sc_hd__a21o_1
X_2519_ RF0.regs\[15\]\[28\] _0664_ _0676_ RF0.regs\[5\]\[28\] VGND VGND VPWR VPWR
+ _0680_ sky130_fd_sc_hd__a22o_1
X_3499_ RF0.regs\[20\]\[2\] _0623_ _0828_ RF0.regs\[25\]\[2\] _1653_ VGND VGND VPWR
+ VPWR _1654_ sky130_fd_sc_hd__a221o_1
XTAP_TAPCELL_ROW_74_809 VGND VPWR sky130_fd_sc_hd__tapvpwrvgnd_1
XTAP_TAPCELL_ROW_3_199 VGND VPWR sky130_fd_sc_hd__tapvpwrvgnd_1
XFILLER_0_81_405 VPWR VGND VPWR VGND sky130_ef_sc_hd__decap_12
XFILLER_0_19_362 VGND VGND VPWR VPWR sky130_fd_sc_hd__fill_2
XPHY_EDGE_ROW_49_Left_131 VGND VGND VPWR VPWR sky130_fd_sc_hd__decap_3
XFILLER_0_81_449 VPWR VGND VPWR VGND sky130_ef_sc_hd__decap_12
XFILLER_0_46_181 VPWR VGND VPWR VGND sky130_ef_sc_hd__decap_12
XFILLER_0_34_365 VGND VGND VPWR VPWR sky130_fd_sc_hd__fill_2
XPHY_EDGE_ROW_58_Left_140 VGND VGND VPWR VPWR sky130_fd_sc_hd__decap_3
XFILLER_0_55_39 VPWR VGND VPWR VGND sky130_ef_sc_hd__decap_12
XFILLER_0_69_240 VGND VGND VPWR VPWR sky130_fd_sc_hd__decap_6
XFILLER_0_71_27 VPWR VGND VPWR VGND sky130_ef_sc_hd__decap_12
XTAP_TAPCELL_ROW_45_555 VGND VPWR sky130_fd_sc_hd__tapvpwrvgnd_1
XFILLER_0_69_273 VGND VGND VPWR VPWR sky130_fd_sc_hd__fill_1
XFILLER_0_72_405 VPWR VGND VPWR VGND sky130_ef_sc_hd__decap_12
X_2870_ _0880_ _1030_ _0722_ VGND VGND VPWR VPWR _1031_ sky130_fd_sc_hd__mux2_1
XFILLER_0_37_181 VPWR VGND VPWR VGND sky130_ef_sc_hd__decap_12
X_4540_ _2281_ VGND VGND VPWR VPWR _0195_ sky130_fd_sc_hd__inv_2
XFILLER_0_4_248 VGND VGND VPWR VPWR sky130_fd_sc_hd__decap_4
Xclkbuf_leaf_10_clk clknet_1_1__leaf_clk VGND VGND VPWR VPWR clknet_leaf_10_clk sky130_fd_sc_hd__clkbuf_8
X_4471_ _2271_ VGND VGND VPWR VPWR _0136_ sky130_fd_sc_hd__inv_2
XFILLER_0_0_421 VPWR VGND VPWR VGND sky130_ef_sc_hd__decap_12
X_3422_ _0847_ _0890_ _0841_ VGND VGND VPWR VPWR _1579_ sky130_fd_sc_hd__o21a_1
X_3353_ RF0.regs\[15\]\[13\] _0610_ _0618_ RF0.regs\[25\]\[13\] VGND VGND VPWR VPWR
+ _1510_ sky130_fd_sc_hd__a22o_1
X_2304_ IM0.addr\[23\] _0528_ VGND VGND VPWR VPWR _0529_ sky130_fd_sc_hd__and2_1
X_3284_ _1039_ _1440_ _1441_ _1084_ VGND VGND VPWR VPWR _1442_ sky130_fd_sc_hd__o211a_1
XTAP_TAPCELL_ROW_0_169 VGND VPWR sky130_fd_sc_hd__tapvpwrvgnd_1
XFILLER_0_75_221 VGND VGND VPWR VPWR sky130_fd_sc_hd__decap_3
XFILLER_0_0_41 VPWR VGND VPWR VGND sky130_ef_sc_hd__decap_12
XFILLER_0_48_424 VGND VGND VPWR VPWR sky130_fd_sc_hd__decap_6
XFILLER_0_63_405 VGND VGND VPWR VPWR sky130_fd_sc_hd__fill_2
XPHY_EDGE_ROW_3_Right_3 VGND VGND VPWR VPWR sky130_fd_sc_hd__decap_3
X_4807_ clknet_leaf_21_clk _0457_ _0201_ VGND VGND VPWR VPWR RF0.regs\[0\]\[9\] sky130_fd_sc_hd__dfrtp_1
X_2999_ _0915_ _0810_ _1007_ VGND VGND VPWR VPWR _1159_ sky130_fd_sc_hd__mux2_1
XFILLER_0_63_449 VPWR VGND VPWR VGND sky130_ef_sc_hd__decap_12
XFILLER_0_16_365 VGND VGND VPWR VPWR sky130_fd_sc_hd__decap_8
X_4738_ clknet_leaf_19_clk _0388_ _0132_ VGND VGND VPWR VPWR RF0.regs\[10\]\[4\] sky130_fd_sc_hd__dfrtp_2
XFILLER_0_43_151 VPWR VGND VPWR VGND sky130_ef_sc_hd__decap_12
X_4669_ clknet_leaf_12_clk _0319_ _0063_ VGND VGND VPWR VPWR RF0.regs\[25\]\[31\]
+ sky130_fd_sc_hd__dfrtp_2
XFILLER_0_9_83 VGND VGND VPWR VPWR sky130_fd_sc_hd__fill_1
XFILLER_0_3_281 VGND VGND VPWR VPWR sky130_fd_sc_hd__fill_2
XFILLER_0_31_379 VGND VGND VPWR VPWR sky130_fd_sc_hd__decap_3
XTAP_TAPCELL_ROW_8_247 VGND VPWR sky130_fd_sc_hd__tapvpwrvgnd_1
Xclkbuf_1_1__f_clk clknet_0_clk VGND VGND VPWR VPWR clknet_1_1__leaf_clk sky130_fd_sc_hd__clkbuf_16
XTAP_TAPCELL_ROW_42_536 VGND VPWR sky130_fd_sc_hd__tapvpwrvgnd_1
XFILLER_0_34_184 VGND VGND VPWR VPWR sky130_fd_sc_hd__decap_6
XFILLER_0_66_27 VGND VGND VPWR VPWR sky130_fd_sc_hd__fill_1
X_3971_ _2057_ VGND VGND VPWR VPWR _0385_ sky130_fd_sc_hd__clkbuf_1
X_2922_ _0707_ _0708_ _0710_ VGND VGND VPWR VPWR _1083_ sky130_fd_sc_hd__a21o_2
XFILLER_0_57_276 VGND VGND VPWR VPWR sky130_fd_sc_hd__decap_4
XFILLER_0_72_224 VGND VGND VPWR VPWR sky130_fd_sc_hd__decap_8
X_2853_ _1004_ VGND VGND VPWR VPWR _1014_ sky130_fd_sc_hd__clkbuf_4
XFILLER_0_45_449 VGND VGND VPWR VPWR sky130_fd_sc_hd__fill_2
X_2784_ RF0.regs\[10\]\[17\] _0616_ _0931_ RF0.regs\[25\]\[17\] VGND VGND VPWR VPWR
+ _0945_ sky130_fd_sc_hd__a22oi_4
XFILLER_0_60_419 VGND VGND VPWR VPWR sky130_fd_sc_hd__fill_1
X_4523_ _2278_ VGND VGND VPWR VPWR _0181_ sky130_fd_sc_hd__inv_2
XFILLER_0_80_290 VGND VGND VPWR VPWR sky130_fd_sc_hd__decap_3
X_4454_ _2246_ VGND VGND VPWR VPWR _2267_ sky130_fd_sc_hd__clkbuf_1
X_3405_ _1555_ _1561_ VGND VGND VPWR VPWR _1562_ sky130_fd_sc_hd__nor2_1
X_4385_ _2246_ VGND VGND VPWR VPWR _2258_ sky130_fd_sc_hd__clkbuf_2
XTAP_TAPCELL_ROW_5_217 VGND VPWR sky130_fd_sc_hd__tapvpwrvgnd_1
X_3336_ _1097_ _1491_ _1493_ _1151_ _1124_ VGND VGND VPWR VPWR _1494_ sky130_fd_sc_hd__o32a_1
X_3267_ RF0.regs\[20\]\[22\] _0626_ _0611_ RF0.regs\[15\]\[22\] _1424_ VGND VGND VPWR
+ VPWR _1425_ sky130_fd_sc_hd__a221o_1
X_3198_ RF0.regs\[20\]\[24\] _0626_ _0631_ RF0.regs\[10\]\[24\] _1356_ VGND VGND VPWR
+ VPWR _1357_ sky130_fd_sc_hd__a221o_1
XFILLER_0_48_221 VGND VGND VPWR VPWR sky130_fd_sc_hd__decap_4
XFILLER_0_48_232 VGND VGND VPWR VPWR sky130_fd_sc_hd__decap_3
XFILLER_0_63_202 VGND VGND VPWR VPWR sky130_fd_sc_hd__decap_8
XFILLER_0_63_279 VGND VGND VPWR VPWR sky130_fd_sc_hd__fill_1
XFILLER_0_16_173 VGND VGND VPWR VPWR sky130_fd_sc_hd__decap_8
XFILLER_0_16_162 VGND VGND VPWR VPWR sky130_fd_sc_hd__decap_4
XFILLER_0_44_471 VGND VGND VPWR VPWR sky130_fd_sc_hd__decap_4
XFILLER_0_16_195 VGND VGND VPWR VPWR sky130_fd_sc_hd__fill_1
XFILLER_0_52_29 VPWR VGND VPWR VGND sky130_ef_sc_hd__decap_12
XFILLER_0_27_449 VGND VGND VPWR VPWR sky130_fd_sc_hd__fill_1
XFILLER_0_54_246 VGND VGND VPWR VPWR sky130_fd_sc_hd__decap_6
XFILLER_0_42_419 VGND VGND VPWR VPWR sky130_fd_sc_hd__fill_1
XFILLER_0_22_110 VGND VGND VPWR VPWR sky130_fd_sc_hd__fill_2
XTAP_TAPCELL_ROW_10_263 VGND VPWR sky130_fd_sc_hd__tapvpwrvgnd_1
XFILLER_0_77_15 VPWR VGND VPWR VGND sky130_ef_sc_hd__decap_12
XFILLER_0_10_316 VGND VGND VPWR VPWR sky130_fd_sc_hd__fill_1
XFILLER_0_10_305 VGND VGND VPWR VPWR sky130_fd_sc_hd__decap_3
X_4170_ _2013_ RF0.regs\[25\]\[4\] _2156_ VGND VGND VPWR VPWR _2164_ sky130_fd_sc_hd__mux2_1
X_3121_ _1054_ _1041_ _1080_ VGND VGND VPWR VPWR _1281_ sky130_fd_sc_hd__mux2_1
X_3052_ _1208_ _1209_ _1210_ _1211_ _1066_ _1049_ VGND VGND VPWR VPWR _1212_ sky130_fd_sc_hd__mux4_1
XTAP_TAPCELL_ROW_18_330 VGND VPWR sky130_fd_sc_hd__tapvpwrvgnd_1
XFILLER_0_26_85 VGND VGND VPWR VPWR sky130_fd_sc_hd__decap_4
XFILLER_0_18_405 VGND VGND VPWR VPWR sky130_fd_sc_hd__decap_6
X_3954_ _2001_ RF0.regs\[10\]\[9\] _2046_ VGND VGND VPWR VPWR _2049_ sky130_fd_sc_hd__mux2_1
X_3885_ _1611_ _1691_ VGND VGND VPWR VPWR _2009_ sky130_fd_sc_hd__xnor2_4
XFILLER_0_18_438 VPWR VGND VPWR VGND sky130_ef_sc_hd__decap_12
XFILLER_0_45_213 VGND VGND VPWR VPWR sky130_fd_sc_hd__decap_3
X_2905_ _1065_ VGND VGND VPWR VPWR _1066_ sky130_fd_sc_hd__clkbuf_4
X_2836_ _0995_ _0996_ VGND VGND VPWR VPWR _0997_ sky130_fd_sc_hd__xnor2_1
XFILLER_0_45_257 VPWR VGND VPWR VGND sky130_ef_sc_hd__decap_12
XTAP_TAPCELL_ROW_61_697 VGND VPWR sky130_fd_sc_hd__tapvpwrvgnd_1
X_2767_ _0623_ _0696_ VGND VGND VPWR VPWR _0928_ sky130_fd_sc_hd__nor2_1
XFILLER_0_77_3 VPWR VGND VPWR VGND sky130_ef_sc_hd__decap_12
X_4506_ _2275_ VGND VGND VPWR VPWR _0167_ sky130_fd_sc_hd__inv_2
X_2698_ _0771_ _0724_ _0858_ VGND VGND VPWR VPWR _0859_ sky130_fd_sc_hd__and3_1
XFILLER_0_13_176 VGND VGND VPWR VPWR sky130_fd_sc_hd__fill_2
X_4437_ _2265_ VGND VGND VPWR VPWR _0108_ sky130_fd_sc_hd__inv_2
X_4368_ _2255_ VGND VGND VPWR VPWR _0049_ sky130_fd_sc_hd__inv_2
X_3319_ _1154_ _1164_ _1202_ VGND VGND VPWR VPWR _1477_ sky130_fd_sc_hd__a21o_1
X_4299_ _1059_ _1050_ _2237_ _1935_ VGND VGND VPWR VPWR _2238_ sky130_fd_sc_hd__a211o_1
XTAP_TAPCELL_ROW_69_764 VGND VPWR sky130_fd_sc_hd__tapvpwrvgnd_1
XTAP_TAPCELL_ROW_52_620 VGND VPWR sky130_fd_sc_hd__tapvpwrvgnd_1
XTAP_TAPCELL_ROW_24_377 VGND VPWR sky130_fd_sc_hd__tapvpwrvgnd_1
XFILLER_0_36_246 VGND VGND VPWR VPWR sky130_fd_sc_hd__decap_3
XFILLER_0_32_474 VGND VGND VPWR VPWR sky130_fd_sc_hd__fill_2
XFILLER_0_63_39 VPWR VGND VPWR VGND sky130_ef_sc_hd__decap_12
XTAP_TAPCELL_ROW_15_300 VGND VPWR sky130_fd_sc_hd__tapvpwrvgnd_1
XFILLER_0_67_393 VGND VGND VPWR VPWR sky130_fd_sc_hd__decap_8
XFILLER_0_12_43 VPWR VGND VPWR VGND sky130_ef_sc_hd__decap_12
XFILLER_0_15_419 VGND VGND VPWR VPWR sky130_fd_sc_hd__decap_3
XFILLER_0_27_279 VGND VGND VPWR VPWR sky130_fd_sc_hd__fill_1
X_3670_ _1392_ _1387_ _1058_ VGND VGND VPWR VPWR _1821_ sky130_fd_sc_hd__mux2_1
X_2621_ _0686_ _0751_ _0771_ VGND VGND VPWR VPWR _0782_ sky130_fd_sc_hd__o21a_1
X_2552_ _0656_ _0712_ _0607_ VGND VGND VPWR VPWR _0713_ sky130_fd_sc_hd__a21o_2
XFILLER_0_10_135 VGND VGND VPWR VPWR sky130_fd_sc_hd__decap_4
X_2483_ RF0.regs\[20\]\[31\] _0627_ _0631_ RF0.regs\[10\]\[31\] _0643_ VGND VGND VPWR
+ VPWR _0644_ sky130_fd_sc_hd__a221o_1
X_4222_ _2191_ VGND VGND VPWR VPWR _0268_ sky130_fd_sc_hd__clkbuf_1
X_4153_ _1990_ RF0.regs\[25\]\[12\] _2145_ VGND VGND VPWR VPWR _2155_ sky130_fd_sc_hd__mux2_1
XFILLER_0_37_51 VGND VGND VPWR VPWR sky130_fd_sc_hd__decap_4
XFILLER_0_37_73 VPWR VGND VPWR VGND sky130_ef_sc_hd__decap_12
X_3104_ _1262_ _1263_ _1062_ VGND VGND VPWR VPWR _1264_ sky130_fd_sc_hd__mux2_1
X_4084_ _2118_ VGND VGND VPWR VPWR _0333_ sky130_fd_sc_hd__clkbuf_1
X_3035_ _0775_ _0983_ _0985_ VGND VGND VPWR VPWR _1195_ sky130_fd_sc_hd__and3_1
XTAP_TAPCELL_ROW_66_734 VGND VPWR sky130_fd_sc_hd__tapvpwrvgnd_1
XFILLER_0_77_113 VGND VGND VPWR VPWR sky130_fd_sc_hd__decap_3
XFILLER_0_53_50 VGND VGND VPWR VPWR sky130_fd_sc_hd__decap_6
X_3937_ _1972_ RF0.regs\[10\]\[17\] _2035_ VGND VGND VPWR VPWR _2040_ sky130_fd_sc_hd__mux2_1
XTAP_TAPCELL_ROW_21_358 VGND VPWR sky130_fd_sc_hd__tapvpwrvgnd_1
X_3868_ _1703_ _1705_ VGND VGND VPWR VPWR _1996_ sky130_fd_sc_hd__and2b_1
XFILLER_0_33_249 VGND VGND VPWR VPWR sky130_fd_sc_hd__fill_2
X_3799_ _1468_ VGND VGND VPWR VPWR _1940_ sky130_fd_sc_hd__inv_2
X_2819_ _0781_ _0785_ _0979_ VGND VGND VPWR VPWR _0980_ sky130_fd_sc_hd__and3_1
XPHY_EDGE_ROW_21_Left_103 VGND VGND VPWR VPWR sky130_fd_sc_hd__decap_3
XTAP_TAPCELL_ROW_29_425 VGND VPWR sky130_fd_sc_hd__tapvpwrvgnd_1
XTAP_TAPCELL_ROW_37_491 VGND VPWR sky130_fd_sc_hd__tapvpwrvgnd_1
XPHY_EDGE_ROW_30_Left_112 VGND VGND VPWR VPWR sky130_fd_sc_hd__decap_3
XFILLER_0_64_352 VGND VGND VPWR VPWR sky130_fd_sc_hd__fill_1
XFILLER_0_64_363 VGND VGND VPWR VPWR sky130_fd_sc_hd__fill_1
XFILLER_0_64_385 VGND VGND VPWR VPWR sky130_fd_sc_hd__fill_1
XFILLER_0_32_271 VGND VGND VPWR VPWR sky130_fd_sc_hd__decap_8
XFILLER_0_20_477 VGND VGND VPWR VPWR sky130_fd_sc_hd__decap_4
XFILLER_0_74_27 VGND VGND VPWR VPWR sky130_fd_sc_hd__fill_1
XFILLER_0_59_102 VGND VGND VPWR VPWR sky130_fd_sc_hd__fill_2
XTAP_TAPCELL_ROW_63_715 VGND VPWR sky130_fd_sc_hd__tapvpwrvgnd_1
X_4840_ clknet_leaf_0_clk _0490_ _0234_ VGND VGND VPWR VPWR IM0.addr\[10\] sky130_fd_sc_hd__dfrtp_1
XFILLER_0_23_53 VGND VGND VPWR VPWR sky130_fd_sc_hd__decap_3
XFILLER_0_7_449 VPWR VGND VPWR VGND sky130_ef_sc_hd__decap_12
X_4771_ clknet_leaf_24_clk _0421_ _0165_ VGND VGND VPWR VPWR RF0.regs\[5\]\[5\] sky130_fd_sc_hd__dfrtp_1
XTAP_TAPCELL_ROW_71_781 VGND VPWR sky130_fd_sc_hd__tapvpwrvgnd_1
X_3722_ _1861_ _1862_ VGND VGND VPWR VPWR _1863_ sky130_fd_sc_hd__and2_1
X_3653_ _1221_ _1300_ _1204_ VGND VGND VPWR VPWR _1804_ sky130_fd_sc_hd__a21oi_1
X_2604_ RF0.regs\[10\]\[29\] _0619_ _0676_ RF0.regs\[25\]\[29\] VGND VGND VPWR VPWR
+ _0765_ sky130_fd_sc_hd__a22o_1
XFILLER_0_30_208 VGND VGND VPWR VPWR sky130_fd_sc_hd__decap_3
X_3584_ _0920_ _0927_ _0942_ VGND VGND VPWR VPWR _1736_ sky130_fd_sc_hd__nand3_1
X_2535_ _0657_ _0695_ VGND VGND VPWR VPWR _0696_ sky130_fd_sc_hd__and2_1
X_2466_ _0626_ VGND VGND VPWR VPWR _0627_ sky130_fd_sc_hd__buf_2
XFILLER_0_48_83 VGND VGND VPWR VPWR sky130_fd_sc_hd__fill_1
X_4205_ _1959_ net148 _2181_ VGND VGND VPWR VPWR _2183_ sky130_fd_sc_hd__mux2_1
X_2397_ _0573_ VGND VGND VPWR VPWR _0463_ sky130_fd_sc_hd__clkbuf_1
X_4136_ _2146_ VGND VGND VPWR VPWR _0309_ sky130_fd_sc_hd__clkbuf_1
XFILLER_0_78_400 VPWR VGND VPWR VGND sky130_ef_sc_hd__decap_12
X_4067_ net121 _1956_ _2109_ VGND VGND VPWR VPWR _2110_ sky130_fd_sc_hd__mux2_1
XFILLER_0_78_433 VPWR VGND VPWR VGND sky130_ef_sc_hd__decap_12
X_3018_ _1177_ _0971_ _1052_ VGND VGND VPWR VPWR _1178_ sky130_fd_sc_hd__mux2_1
XFILLER_0_78_477 VGND VGND VPWR VPWR sky130_fd_sc_hd__decap_4
XTAP_TAPCELL_ROW_34_461 VGND VPWR sky130_fd_sc_hd__tapvpwrvgnd_1
XFILLER_0_61_344 VGND VGND VPWR VPWR sky130_fd_sc_hd__decap_4
XTAP_TAPCELL_ROW_77_829 VGND VPWR sky130_fd_sc_hd__tapvpwrvgnd_1
XFILLER_0_69_433 VPWR VGND VPWR VGND sky130_ef_sc_hd__decap_12
XFILLER_0_60_29 VPWR VGND VPWR VGND sky130_ef_sc_hd__decap_12
XFILLER_0_4_419 VGND VGND VPWR VPWR sky130_fd_sc_hd__fill_1
XFILLER_0_52_333 VGND VGND VPWR VPWR sky130_fd_sc_hd__fill_1
XFILLER_0_64_182 VGND VGND VPWR VPWR sky130_fd_sc_hd__fill_1
XFILLER_0_69_27 VPWR VGND VPWR VGND sky130_ef_sc_hd__decap_12
X_2320_ _0530_ net57 VGND VGND VPWR VPWR _0505_ sky130_fd_sc_hd__nor2_1
XFILLER_0_18_97 VPWR VGND VPWR VGND sky130_ef_sc_hd__decap_12
XTAP_TAPCELL_ROW_48_586 VGND VPWR sky130_fd_sc_hd__tapvpwrvgnd_1
XFILLER_0_75_425 VPWR VGND VPWR VGND sky130_ef_sc_hd__decap_12
XFILLER_0_34_96 VGND VGND VPWR VPWR sky130_fd_sc_hd__fill_1
X_4823_ clknet_leaf_14_clk _0473_ _0217_ VGND VGND VPWR VPWR RF0.regs\[0\]\[25\] sky130_fd_sc_hd__dfrtp_1
XFILLER_0_28_352 VGND VGND VPWR VPWR sky130_fd_sc_hd__decap_4
XFILLER_0_28_363 VGND VGND VPWR VPWR sky130_fd_sc_hd__fill_1
XTAP_TAPCELL_ROW_31_442 VGND VPWR sky130_fd_sc_hd__tapvpwrvgnd_1
X_4754_ clknet_leaf_10_clk _0404_ _0148_ VGND VGND VPWR VPWR RF0.regs\[10\]\[20\]
+ sky130_fd_sc_hd__dfrtp_4
XFILLER_0_62_119 VGND VGND VPWR VPWR sky130_fd_sc_hd__fill_1
X_3705_ _1381_ _1849_ VGND VGND VPWR VPWR _1850_ sky130_fd_sc_hd__xnor2_4
XFILLER_0_43_344 VGND VGND VPWR VPWR sky130_fd_sc_hd__decap_8
X_4685_ clknet_leaf_1_clk _0335_ _0079_ VGND VGND VPWR VPWR RF0.regs\[20\]\[15\] sky130_fd_sc_hd__dfrtp_1
X_3636_ _1771_ _1777_ _1786_ VGND VGND VPWR VPWR _1787_ sky130_fd_sc_hd__a21o_1
X_3567_ _1718_ _0946_ _1719_ VGND VGND VPWR VPWR _1720_ sky130_fd_sc_hd__nand3_1
X_2518_ _0659_ _0678_ VGND VGND VPWR VPWR _0679_ sky130_fd_sc_hd__and2_1
XFILLER_0_59_93 VGND VGND VPWR VPWR sky130_fd_sc_hd__fill_1
X_3498_ RF0.regs\[15\]\[2\] _0608_ _0628_ RF0.regs\[10\]\[2\] VGND VGND VPWR VPWR
+ _1653_ sky130_fd_sc_hd__a22o_1
X_2449_ _0609_ VGND VGND VPWR VPWR _0610_ sky130_fd_sc_hd__clkbuf_4
X_4119_ _2137_ VGND VGND VPWR VPWR _0317_ sky130_fd_sc_hd__clkbuf_1
XFILLER_0_78_241 VGND VGND VPWR VPWR sky130_fd_sc_hd__fill_2
XFILLER_0_38_138 VGND VGND VPWR VPWR sky130_fd_sc_hd__fill_2
XFILLER_0_81_417 VGND VGND VPWR VPWR sky130_fd_sc_hd__decap_3
XFILLER_0_34_322 VGND VGND VPWR VPWR sky130_fd_sc_hd__fill_1
XFILLER_0_46_193 VGND VGND VPWR VPWR sky130_fd_sc_hd__decap_3
XTAP_TAPCELL_ROW_45_556 VGND VPWR sky130_fd_sc_hd__tapvpwrvgnd_1
XFILLER_0_71_39 VPWR VGND VPWR VGND sky130_ef_sc_hd__decap_12
XFILLER_0_57_447 VGND VGND VPWR VPWR sky130_fd_sc_hd__fill_1
XFILLER_0_72_417 VGND VGND VPWR VPWR sky130_fd_sc_hd__decap_3
XFILLER_0_37_193 VGND VGND VPWR VPWR sky130_fd_sc_hd__fill_1
XFILLER_0_52_141 VGND VGND VPWR VPWR sky130_fd_sc_hd__fill_1
X_4470_ _2269_ VGND VGND VPWR VPWR _2271_ sky130_fd_sc_hd__buf_4
X_3421_ RF0.regs\[0\]\[8\] _0603_ _1577_ VGND VGND VPWR VPWR _1578_ sky130_fd_sc_hd__o21a_1
XFILLER_0_0_433 VPWR VGND VPWR VGND sky130_ef_sc_hd__decap_12
X_3352_ _1506_ _1508_ VGND VGND VPWR VPWR _1509_ sky130_fd_sc_hd__nor2_1
XFILLER_0_0_477 VGND VGND VPWR VPWR sky130_fd_sc_hd__decap_4
X_2303_ IM0.addr\[22\] IM0.addr\[21\] _0527_ VGND VGND VPWR VPWR _0528_ sky130_fd_sc_hd__and3_1
X_3283_ _1134_ _1143_ VGND VGND VPWR VPWR _1441_ sky130_fd_sc_hd__or2_1
XFILLER_0_75_244 VGND VGND VPWR VPWR sky130_fd_sc_hd__fill_1
XFILLER_0_0_53 VGND VGND VPWR VPWR sky130_fd_sc_hd__decap_3
XFILLER_0_48_447 VGND VGND VPWR VPWR sky130_fd_sc_hd__decap_3
XFILLER_0_75_277 VGND VGND VPWR VPWR sky130_fd_sc_hd__decap_3
X_4806_ clknet_leaf_20_clk _0456_ _0200_ VGND VGND VPWR VPWR RF0.regs\[0\]\[8\] sky130_fd_sc_hd__dfrtp_1
X_2998_ _0831_ _0834_ _1052_ VGND VGND VPWR VPWR _1158_ sky130_fd_sc_hd__mux2_1
XFILLER_0_16_355 VGND VGND VPWR VPWR sky130_fd_sc_hd__fill_2
X_4737_ clknet_leaf_19_clk _0387_ _0131_ VGND VGND VPWR VPWR RF0.regs\[10\]\[3\] sky130_fd_sc_hd__dfrtp_4
XFILLER_0_71_461 VPWR VGND VPWR VGND sky130_ef_sc_hd__decap_12
X_4668_ clknet_leaf_12_clk _0318_ _0062_ VGND VGND VPWR VPWR RF0.regs\[25\]\[30\]
+ sky130_fd_sc_hd__dfrtp_1
XFILLER_0_43_163 VGND VGND VPWR VPWR sky130_fd_sc_hd__decap_4
X_3619_ _1767_ _1769_ VGND VGND VPWR VPWR _1770_ sky130_fd_sc_hd__nor2_1
X_4599_ _2286_ VGND VGND VPWR VPWR _0249_ sky130_fd_sc_hd__inv_2
XTAP_TAPCELL_ROW_8_248 VGND VPWR sky130_fd_sc_hd__tapvpwrvgnd_1
XFILLER_0_39_447 VGND VGND VPWR VPWR sky130_fd_sc_hd__fill_1
XTAP_TAPCELL_ROW_42_537 VGND VPWR sky130_fd_sc_hd__tapvpwrvgnd_1
XFILLER_0_81_225 VPWR VGND VPWR VGND sky130_ef_sc_hd__decap_12
XFILLER_0_22_336 VGND VGND VPWR VPWR sky130_fd_sc_hd__fill_2
XFILLER_0_22_347 VPWR VGND VPWR VGND sky130_ef_sc_hd__decap_12
XFILLER_0_30_380 VGND VGND VPWR VPWR sky130_fd_sc_hd__decap_8
XPHY_EDGE_ROW_13_Right_13 VGND VGND VPWR VPWR sky130_fd_sc_hd__decap_3
XTAP_TAPCELL_ROW_58_670 VGND VPWR sky130_fd_sc_hd__tapvpwrvgnd_1
X_3970_ _2020_ RF0.regs\[10\]\[1\] _2023_ VGND VGND VPWR VPWR _2057_ sky130_fd_sc_hd__mux2_1
XFILLER_0_15_65 VPWR VGND VPWR VGND sky130_ef_sc_hd__decap_12
X_2921_ net41 _0996_ _1079_ _1081_ VGND VGND VPWR VPWR _1082_ sky130_fd_sc_hd__o211a_1
XFILLER_0_57_255 VGND VGND VPWR VPWR sky130_fd_sc_hd__decap_4
XFILLER_0_57_266 VGND VGND VPWR VPWR sky130_fd_sc_hd__decap_3
X_2852_ _0838_ VGND VGND VPWR VPWR _1013_ sky130_fd_sc_hd__inv_2
XTAP_TAPCELL_ROW_13_283 VGND VPWR sky130_fd_sc_hd__tapvpwrvgnd_1
XPHY_EDGE_ROW_22_Right_22 VGND VGND VPWR VPWR sky130_fd_sc_hd__decap_3
XFILLER_0_31_86 VGND VGND VPWR VPWR sky130_fd_sc_hd__decap_4
X_2783_ _0710_ _0943_ _0759_ VGND VGND VPWR VPWR _0944_ sky130_fd_sc_hd__o21ai_4
X_4522_ _2278_ VGND VGND VPWR VPWR _0180_ sky130_fd_sc_hd__inv_2
X_4453_ _2266_ VGND VGND VPWR VPWR _0123_ sky130_fd_sc_hd__inv_2
X_3404_ _1096_ _1559_ _1560_ _1000_ _1365_ VGND VGND VPWR VPWR _1561_ sky130_fd_sc_hd__o32a_1
X_4384_ _2257_ VGND VGND VPWR VPWR _0063_ sky130_fd_sc_hd__inv_2
XTAP_TAPCELL_ROW_5_218 VGND VPWR sky130_fd_sc_hd__tapvpwrvgnd_1
X_3335_ _0905_ _1492_ VGND VGND VPWR VPWR _1493_ sky130_fd_sc_hd__and2_1
XPHY_EDGE_ROW_31_Right_31 VGND VGND VPWR VPWR sky130_fd_sc_hd__decap_3
X_3266_ RF0.regs\[5\]\[22\] _0634_ _0639_ RF0.regs\[30\]\[22\] _0642_ VGND VGND VPWR
+ VPWR _1424_ sky130_fd_sc_hd__a221o_1
XFILLER_0_22_3 VGND VGND VPWR VPWR sky130_fd_sc_hd__decap_8
X_3197_ RF0.regs\[5\]\[24\] _0635_ _0639_ RF0.regs\[30\]\[24\] _0642_ VGND VGND VPWR
+ VPWR _1356_ sky130_fd_sc_hd__a221o_1
XPHY_EDGE_ROW_77_Left_159 VGND VGND VPWR VPWR sky130_fd_sc_hd__decap_3
XPHY_EDGE_ROW_40_Right_40 VGND VGND VPWR VPWR sky130_fd_sc_hd__decap_3
XFILLER_0_63_214 VGND VGND VPWR VPWR sky130_fd_sc_hd__decap_8
XFILLER_0_63_236 VPWR VGND VPWR VGND sky130_ef_sc_hd__decap_12
XFILLER_0_16_130 VGND VGND VPWR VPWR sky130_fd_sc_hd__fill_1
XFILLER_0_44_461 VGND VGND VPWR VPWR sky130_fd_sc_hd__fill_1
XFILLER_0_31_155 VGND VGND VPWR VPWR sky130_fd_sc_hd__fill_1
XTAP_TAPCELL_ROW_55_640 VGND VPWR sky130_fd_sc_hd__tapvpwrvgnd_1
XFILLER_0_79_391 VGND VGND VPWR VPWR sky130_fd_sc_hd__fill_1
XFILLER_0_54_203 VGND VGND VPWR VPWR sky130_fd_sc_hd__fill_1
XFILLER_0_54_236 VGND VGND VPWR VPWR sky130_fd_sc_hd__decap_4
XTAP_TAPCELL_ROW_10_264 VGND VPWR sky130_fd_sc_hd__tapvpwrvgnd_1
XFILLER_0_77_27 VPWR VGND VPWR VGND sky130_ef_sc_hd__decap_12
XFILLER_0_22_166 VGND VGND VPWR VPWR sky130_fd_sc_hd__decap_3
X_3120_ _1141_ _0960_ _1044_ VGND VGND VPWR VPWR _1280_ sky130_fd_sc_hd__mux2_1
X_3051_ _0960_ _1041_ _1068_ VGND VGND VPWR VPWR _1211_ sky130_fd_sc_hd__mux2_1
XTAP_TAPCELL_ROW_18_331 VGND VPWR sky130_fd_sc_hd__tapvpwrvgnd_1
XFILLER_0_26_97 VGND VGND VPWR VPWR sky130_fd_sc_hd__decap_4
X_3953_ _2048_ VGND VGND VPWR VPWR _0394_ sky130_fd_sc_hd__clkbuf_1
X_3884_ _2008_ VGND VGND VPWR VPWR _0423_ sky130_fd_sc_hd__clkbuf_1
XFILLER_0_42_74 VGND VGND VPWR VPWR sky130_fd_sc_hd__decap_3
XFILLER_0_42_85 VGND VGND VPWR VPWR sky130_fd_sc_hd__fill_1
X_2904_ _1064_ VGND VGND VPWR VPWR _1065_ sky130_fd_sc_hd__clkbuf_4
X_2835_ RF0.regs\[10\]\[31\] _0619_ _0676_ RF0.regs\[25\]\[31\] VGND VGND VPWR VPWR
+ _0996_ sky130_fd_sc_hd__a22oi_4
XFILLER_0_45_269 VGND VGND VPWR VPWR sky130_fd_sc_hd__decap_4
XTAP_TAPCELL_ROW_61_698 VGND VPWR sky130_fd_sc_hd__tapvpwrvgnd_1
X_2766_ _0921_ _0923_ _0926_ _0906_ VGND VGND VPWR VPWR _0927_ sky130_fd_sc_hd__o2bb2a_1
X_2697_ _0711_ _0857_ VGND VGND VPWR VPWR _0858_ sky130_fd_sc_hd__nand2_1
X_4505_ _2275_ VGND VGND VPWR VPWR _0166_ sky130_fd_sc_hd__inv_2
X_4436_ _2265_ VGND VGND VPWR VPWR _0107_ sky130_fd_sc_hd__inv_2
X_4367_ _2255_ VGND VGND VPWR VPWR _0048_ sky130_fd_sc_hd__inv_2
XFILLER_0_6_85 VGND VGND VPWR VPWR sky130_fd_sc_hd__decap_4
X_3318_ _1161_ _1180_ _1037_ VGND VGND VPWR VPWR _1476_ sky130_fd_sc_hd__mux2_1
X_4298_ _1059_ _1070_ VGND VGND VPWR VPWR _2237_ sky130_fd_sc_hd__nor2_1
X_3249_ RF0.regs\[15\]\[23\] _0609_ _0629_ RF0.regs\[10\]\[23\] VGND VGND VPWR VPWR
+ _1407_ sky130_fd_sc_hd__a22o_1
XTAP_TAPCELL_ROW_69_765 VGND VPWR sky130_fd_sc_hd__tapvpwrvgnd_1
XTAP_TAPCELL_ROW_52_621 VGND VPWR sky130_fd_sc_hd__tapvpwrvgnd_1
XTAP_TAPCELL_ROW_24_378 VGND VPWR sky130_fd_sc_hd__tapvpwrvgnd_1
XFILLER_0_8_160 VGND VGND VPWR VPWR sky130_fd_sc_hd__decap_3
XFILLER_0_17_461 VPWR VGND VPWR VGND sky130_ef_sc_hd__decap_12
XTAP_TAPCELL_ROW_15_301 VGND VPWR sky130_fd_sc_hd__tapvpwrvgnd_1
XFILLER_0_12_11 VGND VGND VPWR VPWR sky130_fd_sc_hd__fill_1
XFILLER_0_12_55 VGND VGND VPWR VPWR sky130_fd_sc_hd__decap_8
X_2620_ _0779_ _0780_ VGND VGND VPWR VPWR _0781_ sky130_fd_sc_hd__nor2_1
XFILLER_0_2_303 VGND VGND VPWR VPWR sky130_fd_sc_hd__fill_1
X_2551_ RF0.regs\[15\]\[3\] _0661_ _0666_ RF0.regs\[5\]\[3\] VGND VGND VPWR VPWR _0712_
+ sky130_fd_sc_hd__a22o_1
X_2482_ RF0.regs\[5\]\[31\] _0635_ _0639_ RF0.regs\[30\]\[31\] _0642_ VGND VGND VPWR
+ VPWR _0643_ sky130_fd_sc_hd__a221o_1
XFILLER_0_50_272 VGND VGND VPWR VPWR sky130_fd_sc_hd__decap_4
X_4221_ _1990_ RF0.regs\[30\]\[12\] _2181_ VGND VGND VPWR VPWR _2191_ sky130_fd_sc_hd__mux2_1
X_4152_ _2154_ VGND VGND VPWR VPWR _0301_ sky130_fd_sc_hd__clkbuf_1
X_3103_ _1225_ _1223_ _1073_ VGND VGND VPWR VPWR _1263_ sky130_fd_sc_hd__mux2_1
XFILLER_0_37_85 VPWR VGND VPWR VGND sky130_ef_sc_hd__decap_12
X_4083_ RF0.regs\[20\]\[13\] _1988_ _2109_ VGND VGND VPWR VPWR _2118_ sky130_fd_sc_hd__mux2_1
X_3034_ _1152_ _1166_ _1193_ _1002_ VGND VGND VPWR VPWR _1194_ sky130_fd_sc_hd__o2bb2a_1
XTAP_TAPCELL_ROW_66_735 VGND VPWR sky130_fd_sc_hd__tapvpwrvgnd_1
XFILLER_0_77_136 VGND VGND VPWR VPWR sky130_fd_sc_hd__decap_4
X_3936_ _2039_ VGND VGND VPWR VPWR _0402_ sky130_fd_sc_hd__clkbuf_1
X_3867_ _1995_ VGND VGND VPWR VPWR _0427_ sky130_fd_sc_hd__clkbuf_1
X_3798_ _1099_ _1456_ _1457_ _1938_ VGND VGND VPWR VPWR _1939_ sky130_fd_sc_hd__o31a_1
X_2818_ _0792_ _0803_ _0976_ _0978_ VGND VGND VPWR VPWR _0979_ sky130_fd_sc_hd__a31o_1
XFILLER_0_14_475 VGND VGND VPWR VPWR sky130_fd_sc_hd__fill_1
X_2749_ _0908_ _0909_ VGND VGND VPWR VPWR _0910_ sky130_fd_sc_hd__and2_1
X_4419_ _2262_ VGND VGND VPWR VPWR _0093_ sky130_fd_sc_hd__inv_2
XFILLER_0_1_391 VGND VGND VPWR VPWR sky130_fd_sc_hd__fill_1
XTAP_TAPCELL_ROW_29_426 VGND VPWR sky130_fd_sc_hd__tapvpwrvgnd_1
XFILLER_0_68_136 VGND VGND VPWR VPWR sky130_fd_sc_hd__fill_1
XTAP_TAPCELL_ROW_37_492 VGND VPWR sky130_fd_sc_hd__tapvpwrvgnd_1
XFILLER_0_56_309 VGND VGND VPWR VPWR sky130_fd_sc_hd__decap_8
XFILLER_0_58_29 VPWR VGND VPWR VGND sky130_ef_sc_hd__decap_12
XFILLER_0_23_43 VGND VGND VPWR VPWR sky130_fd_sc_hd__decap_3
X_4770_ clknet_leaf_24_clk _0420_ _0164_ VGND VGND VPWR VPWR RF0.regs\[5\]\[4\] sky130_fd_sc_hd__dfrtp_1
XTAP_TAPCELL_ROW_71_782 VGND VPWR sky130_fd_sc_hd__tapvpwrvgnd_1
XFILLER_0_23_98 VGND VGND VPWR VPWR sky130_fd_sc_hd__fill_1
X_3721_ _1481_ VGND VGND VPWR VPWR _1862_ sky130_fd_sc_hd__inv_2
X_3652_ _1422_ _1450_ _1482_ _1802_ VGND VGND VPWR VPWR _1803_ sky130_fd_sc_hd__or4_4
X_2603_ _0756_ _0763_ VGND VGND VPWR VPWR _0764_ sky130_fd_sc_hd__nand2_1
X_3583_ RF0.regs\[0\]\[16\] _0604_ _1734_ VGND VGND VPWR VPWR _1735_ sky130_fd_sc_hd__o21a_1
X_2534_ RF0.regs\[15\]\[19\] _0663_ _0669_ RF0.regs\[5\]\[19\] VGND VGND VPWR VPWR
+ _0695_ sky130_fd_sc_hd__a22o_1
XFILLER_0_23_294 VGND VGND VPWR VPWR sky130_fd_sc_hd__decap_8
X_2465_ _0625_ VGND VGND VPWR VPWR _0626_ sky130_fd_sc_hd__clkbuf_4
X_2396_ net96 VGND VGND VPWR VPWR _0573_ sky130_fd_sc_hd__clkbuf_1
X_4204_ _2182_ VGND VGND VPWR VPWR _0277_ sky130_fd_sc_hd__clkbuf_1
X_4135_ _1956_ RF0.regs\[25\]\[21\] _2145_ VGND VGND VPWR VPWR _2146_ sky130_fd_sc_hd__mux2_1
XFILLER_0_78_412 VGND VGND VPWR VPWR sky130_fd_sc_hd__decap_8
X_4066_ _2097_ VGND VGND VPWR VPWR _2109_ sky130_fd_sc_hd__clkbuf_4
XFILLER_0_78_445 VPWR VGND VPWR VGND sky130_ef_sc_hd__decap_12
X_3017_ RF0.regs\[10\]\[19\] _0969_ _0931_ RF0.regs\[25\]\[19\] VGND VGND VPWR VPWR
+ _1177_ sky130_fd_sc_hd__a22o_1
XTAP_TAPCELL_ROW_34_462 VGND VPWR sky130_fd_sc_hd__tapvpwrvgnd_1
XFILLER_0_58_191 VGND VGND VPWR VPWR sky130_fd_sc_hd__fill_1
X_3919_ _2030_ VGND VGND VPWR VPWR _0410_ sky130_fd_sc_hd__clkbuf_1
XFILLER_0_73_194 VGND VGND VPWR VPWR sky130_fd_sc_hd__decap_8
XFILLER_0_61_389 VGND VGND VPWR VPWR sky130_fd_sc_hd__decap_3
XFILLER_0_69_445 VGND VGND VPWR VPWR sky130_fd_sc_hd__decap_3
XPHY_EDGE_ROW_69_Right_69 VGND VGND VPWR VPWR sky130_fd_sc_hd__decap_3
XFILLER_0_37_331 VGND VGND VPWR VPWR sky130_fd_sc_hd__decap_4
XFILLER_0_56_139 VGND VGND VPWR VPWR sky130_fd_sc_hd__fill_1
XFILLER_0_37_386 VGND VGND VPWR VPWR sky130_fd_sc_hd__decap_6
XFILLER_0_69_39 VPWR VGND VPWR VGND sky130_ef_sc_hd__decap_12
XPHY_EDGE_ROW_78_Right_78 VGND VGND VPWR VPWR sky130_fd_sc_hd__decap_3
XTAP_TAPCELL_ROW_48_587 VGND VPWR sky130_fd_sc_hd__tapvpwrvgnd_1
XFILLER_0_34_53 VGND VGND VPWR VPWR sky130_fd_sc_hd__fill_2
XFILLER_0_75_437 VGND VGND VPWR VPWR sky130_fd_sc_hd__decap_8
X_4822_ clknet_1_1__leaf_clk _0472_ _0216_ VGND VGND VPWR VPWR RF0.regs\[0\]\[24\]
+ sky130_fd_sc_hd__dfrtp_1
XFILLER_0_7_236 VGND VGND VPWR VPWR sky130_fd_sc_hd__decap_3
XTAP_TAPCELL_ROW_31_443 VGND VPWR sky130_fd_sc_hd__tapvpwrvgnd_1
XFILLER_0_50_41 VGND VGND VPWR VPWR sky130_fd_sc_hd__decap_8
X_4753_ clknet_leaf_10_clk _0403_ _0147_ VGND VGND VPWR VPWR RF0.regs\[10\]\[19\]
+ sky130_fd_sc_hd__dfrtp_4
X_3704_ _1376_ _1848_ VGND VGND VPWR VPWR _1849_ sky130_fd_sc_hd__nand2_2
XFILLER_0_50_85 VGND VGND VPWR VPWR sky130_fd_sc_hd__decap_6
XFILLER_0_3_420 VPWR VGND VPWR VGND sky130_ef_sc_hd__decap_12
X_4684_ clknet_leaf_1_clk _0334_ _0078_ VGND VGND VPWR VPWR RF0.regs\[20\]\[14\] sky130_fd_sc_hd__dfrtp_1
XFILLER_0_43_378 VPWR VGND VPWR VGND sky130_ef_sc_hd__decap_12
X_3635_ _1770_ _1785_ VGND VGND VPWR VPWR _1786_ sky130_fd_sc_hd__nor2_1
X_3566_ _0920_ _0927_ _0942_ VGND VGND VPWR VPWR _1719_ sky130_fd_sc_hd__a21o_1
X_2517_ RF0.regs\[15\]\[29\] _0664_ _0676_ RF0.regs\[5\]\[29\] VGND VGND VPWR VPWR
+ _0678_ sky130_fd_sc_hd__a22o_1
X_3497_ RF0.regs\[5\]\[2\] _0632_ _0636_ RF0.regs\[30\]\[2\] _0606_ VGND VGND VPWR
+ VPWR _1652_ sky130_fd_sc_hd__a221o_1
X_2448_ _0608_ VGND VGND VPWR VPWR _0609_ sky130_fd_sc_hd__clkbuf_4
XFILLER_0_52_3 VPWR VGND VPWR VGND sky130_ef_sc_hd__decap_12
XTAP_TAPCELL_ROW_39_510 VGND VPWR sky130_fd_sc_hd__tapvpwrvgnd_1
X_2379_ _0564_ VGND VGND VPWR VPWR _0472_ sky130_fd_sc_hd__clkbuf_1
X_4118_ _1842_ RF0.regs\[25\]\[29\] _2134_ VGND VGND VPWR VPWR _2137_ sky130_fd_sc_hd__mux2_1
X_4049_ _2100_ VGND VGND VPWR VPWR _0350_ sky130_fd_sc_hd__clkbuf_1
Xclone4 net40 VGND VGND VPWR VPWR net39 sky130_fd_sc_hd__buf_2
XFILLER_0_78_253 VGND VGND VPWR VPWR sky130_fd_sc_hd__fill_1
XFILLER_0_38_106 VPWR VGND VPWR VGND sky130_ef_sc_hd__decap_12
XFILLER_0_19_375 VGND VGND VPWR VPWR sky130_fd_sc_hd__fill_1
XFILLER_0_53_109 VGND VGND VPWR VPWR sky130_fd_sc_hd__decap_3
XFILLER_0_74_481 VGND VGND VPWR VPWR sky130_fd_sc_hd__fill_1
XTAP_TAPCELL_ROW_73_800 VGND VPWR sky130_fd_sc_hd__tapvpwrvgnd_1
XTAP_TAPCELL_ROW_2_190 VGND VPWR sky130_fd_sc_hd__tapvpwrvgnd_1
XTAP_TAPCELL_ROW_45_557 VGND VPWR sky130_fd_sc_hd__tapvpwrvgnd_1
XFILLER_0_69_297 VGND VGND VPWR VPWR sky130_fd_sc_hd__decap_4
XFILLER_0_4_206 VGND VGND VPWR VPWR sky130_fd_sc_hd__decap_6
XFILLER_0_65_481 VGND VGND VPWR VPWR sky130_fd_sc_hd__fill_1
XFILLER_0_52_153 VGND VGND VPWR VPWR sky130_fd_sc_hd__fill_2
XFILLER_0_20_77 VGND VGND VPWR VPWR sky130_fd_sc_hd__fill_1
X_3420_ _1574_ _1576_ VGND VGND VPWR VPWR _1577_ sky130_fd_sc_hd__or2_1
XFILLER_0_52_197 VGND VGND VPWR VPWR sky130_fd_sc_hd__fill_2
XFILLER_0_0_445 VGND VGND VPWR VPWR sky130_fd_sc_hd__decap_3
X_3351_ _1507_ _1499_ net7 VGND VGND VPWR VPWR _1508_ sky130_fd_sc_hd__mux2_4
X_2302_ IM0.addr\[20\] _0526_ VGND VGND VPWR VPWR _0527_ sky130_fd_sc_hd__and2_1
X_3282_ _1435_ _1437_ _1438_ _1439_ _1075_ _1064_ VGND VGND VPWR VPWR _1440_ sky130_fd_sc_hd__mux4_1
XFILLER_0_75_212 VGND VGND VPWR VPWR sky130_fd_sc_hd__decap_3
XFILLER_0_48_459 VGND VGND VPWR VPWR sky130_fd_sc_hd__decap_4
XFILLER_0_61_51 VGND VGND VPWR VPWR sky130_fd_sc_hd__decap_4
X_4805_ clknet_leaf_17_clk _0455_ _0199_ VGND VGND VPWR VPWR RF0.regs\[0\]\[7\] sky130_fd_sc_hd__dfrtp_1
XFILLER_0_0_98 VPWR VGND VPWR VGND sky130_ef_sc_hd__decap_12
XFILLER_0_28_150 VGND VGND VPWR VPWR sky130_fd_sc_hd__decap_6
XFILLER_0_61_95 VGND VGND VPWR VPWR sky130_fd_sc_hd__fill_2
XFILLER_0_16_323 VPWR VGND VPWR VGND sky130_ef_sc_hd__decap_12
X_2997_ _1110_ _1156_ _1010_ VGND VGND VPWR VPWR _1157_ sky130_fd_sc_hd__mux2_1
XFILLER_0_28_172 VGND VGND VPWR VPWR sky130_fd_sc_hd__fill_1
XFILLER_0_56_481 VGND VGND VPWR VPWR sky130_fd_sc_hd__fill_1
X_4736_ clknet_leaf_19_clk _0386_ _0130_ VGND VGND VPWR VPWR RF0.regs\[10\]\[2\] sky130_fd_sc_hd__dfrtp_4
X_4667_ clknet_leaf_12_clk _0317_ _0061_ VGND VGND VPWR VPWR RF0.regs\[25\]\[29\]
+ sky130_fd_sc_hd__dfrtp_1
XFILLER_0_16_378 VGND VGND VPWR VPWR sky130_fd_sc_hd__decap_4
XFILLER_0_71_473 VGND VGND VPWR VPWR sky130_fd_sc_hd__decap_8
XFILLER_0_3_272 VGND VGND VPWR VPWR sky130_fd_sc_hd__decap_8
XFILLER_0_31_337 VPWR VGND VPWR VGND sky130_ef_sc_hd__decap_12
X_3618_ RF0.regs\[20\]\[18\] _0626_ _0630_ RF0.regs\[10\]\[18\] _1768_ VGND VGND VPWR
+ VPWR _1769_ sky130_fd_sc_hd__a221o_1
X_4598_ _2286_ VGND VGND VPWR VPWR _0248_ sky130_fd_sc_hd__inv_2
X_3549_ _1584_ _1693_ _1702_ _1583_ VGND VGND VPWR VPWR _1703_ sky130_fd_sc_hd__o211a_1
XFILLER_0_66_212 VGND VGND VPWR VPWR sky130_fd_sc_hd__fill_2
XFILLER_0_54_429 VGND VGND VPWR VPWR sky130_fd_sc_hd__decap_4
XFILLER_0_81_237 VPWR VGND VPWR VGND sky130_ef_sc_hd__decap_12
XFILLER_0_47_481 VGND VGND VPWR VPWR sky130_fd_sc_hd__fill_1
XFILLER_0_66_29 VPWR VGND VPWR VGND sky130_ef_sc_hd__decap_12
XTAP_TAPCELL_ROW_58_671 VGND VPWR sky130_fd_sc_hd__tapvpwrvgnd_1
XFILLER_0_15_55 VGND VGND VPWR VPWR sky130_fd_sc_hd__fill_1
XFILLER_0_15_77 VGND VGND VPWR VPWR sky130_fd_sc_hd__fill_1
XFILLER_0_57_223 VGND VGND VPWR VPWR sky130_fd_sc_hd__fill_1
X_2920_ _1076_ _1080_ _0761_ _1066_ VGND VGND VPWR VPWR _1081_ sky130_fd_sc_hd__o31a_1
XFILLER_0_45_418 VPWR VGND VPWR VGND sky130_ef_sc_hd__decap_12
XFILLER_0_38_481 VGND VGND VPWR VPWR sky130_fd_sc_hd__fill_1
X_2851_ _1005_ _1008_ _1011_ VGND VGND VPWR VPWR _1012_ sky130_fd_sc_hd__mux2_1
XFILLER_0_57_289 VGND VGND VPWR VPWR sky130_fd_sc_hd__decap_3
XTAP_TAPCELL_ROW_13_284 VGND VPWR sky130_fd_sc_hd__tapvpwrvgnd_1
X_2782_ _0699_ _0700_ _0745_ VGND VGND VPWR VPWR _0943_ sky130_fd_sc_hd__mux2_2
X_4521_ _2278_ VGND VGND VPWR VPWR _0179_ sky130_fd_sc_hd__inv_2
X_4452_ _2266_ VGND VGND VPWR VPWR _0122_ sky130_fd_sc_hd__inv_2
X_3403_ net42 _1557_ _0819_ _0833_ VGND VGND VPWR VPWR _1560_ sky130_fd_sc_hd__a211oi_1
X_4383_ _2257_ VGND VGND VPWR VPWR _0062_ sky130_fd_sc_hd__inv_2
XFILLER_0_0_253 VPWR VGND VPWR VGND sky130_ef_sc_hd__decap_12
XTAP_TAPCELL_ROW_5_219 VGND VPWR sky130_fd_sc_hd__tapvpwrvgnd_1
X_3334_ _1488_ _0916_ _1489_ _0910_ VGND VGND VPWR VPWR _1492_ sky130_fd_sc_hd__a31o_1
X_3265_ RF0.regs\[10\]\[22\] _0631_ _0619_ RF0.regs\[25\]\[22\] VGND VGND VPWR VPWR
+ _1423_ sky130_fd_sc_hd__a22o_1
X_3196_ RF0.regs\[15\]\[24\] _0611_ _0619_ RF0.regs\[25\]\[24\] VGND VGND VPWR VPWR
+ _1355_ sky130_fd_sc_hd__a22o_1
XFILLER_0_15_3 VGND VGND VPWR VPWR sky130_fd_sc_hd__fill_1
XFILLER_0_36_407 VPWR VGND VPWR VGND sky130_ef_sc_hd__decap_12
XFILLER_0_48_289 VGND VGND VPWR VPWR sky130_fd_sc_hd__decap_8
XFILLER_0_8_386 VGND VGND VPWR VPWR sky130_fd_sc_hd__decap_8
XFILLER_0_63_248 VGND VGND VPWR VPWR sky130_fd_sc_hd__decap_4
X_4719_ clknet_leaf_4_clk _0369_ _0113_ VGND VGND VPWR VPWR RF0.regs\[15\]\[17\] sky130_fd_sc_hd__dfrtp_1
XFILLER_0_16_197 VGND VGND VPWR VPWR sky130_fd_sc_hd__decap_8
XPHY_EDGE_ROW_12_Left_94 VGND VGND VPWR VPWR sky130_fd_sc_hd__decap_3
XFILLER_0_71_281 VGND VGND VPWR VPWR sky130_fd_sc_hd__fill_1
XFILLER_0_31_167 VGND VGND VPWR VPWR sky130_fd_sc_hd__fill_1
XTAP_TAPCELL_ROW_55_641 VGND VPWR sky130_fd_sc_hd__tapvpwrvgnd_1
XTAP_TAPCELL_ROW_10_265 VGND VPWR sky130_fd_sc_hd__tapvpwrvgnd_1
XFILLER_0_50_421 VGND VGND VPWR VPWR sky130_fd_sc_hd__decap_6
XFILLER_0_77_39 VPWR VGND VPWR VGND sky130_ef_sc_hd__decap_12
X_3050_ _1051_ _0945_ _1080_ VGND VGND VPWR VPWR _1210_ sky130_fd_sc_hd__mux2_1
XFILLER_0_26_32 VGND VGND VPWR VPWR sky130_fd_sc_hd__fill_1
XFILLER_0_77_307 VGND VGND VPWR VPWR sky130_fd_sc_hd__decap_8
XTAP_TAPCELL_ROW_18_332 VGND VPWR sky130_fd_sc_hd__tapvpwrvgnd_1
X_3952_ _1997_ RF0.regs\[10\]\[10\] _2046_ VGND VGND VPWR VPWR _2048_ sky130_fd_sc_hd__mux2_1
X_3883_ _2007_ RF0.regs\[5\]\[7\] _1994_ VGND VGND VPWR VPWR _2008_ sky130_fd_sc_hd__mux2_1
X_2903_ _1063_ VGND VGND VPWR VPWR _1064_ sky130_fd_sc_hd__clkbuf_4
X_2834_ _0659_ _0994_ _0627_ VGND VGND VPWR VPWR _0995_ sky130_fd_sc_hd__a21o_1
X_4504_ _2275_ VGND VGND VPWR VPWR _0165_ sky130_fd_sc_hd__inv_2
X_2765_ _0910_ _0925_ _0918_ VGND VGND VPWR VPWR _0926_ sky130_fd_sc_hd__o21a_1
XFILLER_0_41_443 VGND VGND VPWR VPWR sky130_fd_sc_hd__decap_4
XFILLER_0_53_270 VGND VGND VPWR VPWR sky130_fd_sc_hd__fill_1
XFILLER_0_53_281 VGND VGND VPWR VPWR sky130_fd_sc_hd__decap_4
X_2696_ _0713_ _0715_ _0723_ VGND VGND VPWR VPWR _0857_ sky130_fd_sc_hd__or3_1
X_4435_ _2265_ VGND VGND VPWR VPWR _0106_ sky130_fd_sc_hd__inv_2
X_4366_ _2255_ VGND VGND VPWR VPWR _0047_ sky130_fd_sc_hd__inv_2
X_3317_ _0948_ _0957_ _0967_ VGND VGND VPWR VPWR _1475_ sky130_fd_sc_hd__nand3_1
X_4297_ _1343_ VGND VGND VPWR VPWR net18 sky130_fd_sc_hd__inv_2
X_3248_ RF0.regs\[5\]\[23\] _0634_ _0638_ RF0.regs\[30\]\[23\] _0641_ VGND VGND VPWR
+ VPWR _1406_ sky130_fd_sc_hd__a221o_1
XTAP_TAPCELL_ROW_69_766 VGND VPWR sky130_fd_sc_hd__tapvpwrvgnd_1
X_3179_ _1048_ _1067_ VGND VGND VPWR VPWR _1338_ sky130_fd_sc_hd__nand2_1
XFILLER_0_68_329 VGND VGND VPWR VPWR sky130_fd_sc_hd__fill_2
XFILLER_0_76_351 VGND VGND VPWR VPWR sky130_fd_sc_hd__decap_8
XTAP_TAPCELL_ROW_52_622 VGND VPWR sky130_fd_sc_hd__tapvpwrvgnd_1
XTAP_TAPCELL_ROW_24_379 VGND VPWR sky130_fd_sc_hd__tapvpwrvgnd_1
XFILLER_0_17_473 VGND VGND VPWR VPWR sky130_fd_sc_hd__decap_8
XFILLER_0_8_183 VGND VGND VPWR VPWR sky130_fd_sc_hd__decap_3
XFILLER_0_51_207 VPWR VGND VPWR VGND sky130_ef_sc_hd__decap_12
XFILLER_0_4_3 VPWR VGND VPWR VGND sky130_ef_sc_hd__decap_12
XTAP_TAPCELL_ROW_15_302 VGND VPWR sky130_fd_sc_hd__tapvpwrvgnd_1
XFILLER_0_27_259 VPWR VGND VPWR VGND sky130_ef_sc_hd__decap_12
XFILLER_0_23_432 VPWR VGND VPWR VGND sky130_ef_sc_hd__decap_12
X_2550_ _0707_ _0708_ _0710_ VGND VGND VPWR VPWR _0711_ sky130_fd_sc_hd__a21oi_4
XFILLER_0_2_359 VGND VGND VPWR VPWR sky130_fd_sc_hd__fill_2
X_2481_ _0641_ VGND VGND VPWR VPWR _0642_ sky130_fd_sc_hd__buf_2
X_4220_ _2190_ VGND VGND VPWR VPWR _0269_ sky130_fd_sc_hd__clkbuf_1
X_4151_ _1988_ RF0.regs\[25\]\[13\] _2145_ VGND VGND VPWR VPWR _2154_ sky130_fd_sc_hd__mux2_1
X_3102_ _1218_ _1222_ _1010_ VGND VGND VPWR VPWR _1262_ sky130_fd_sc_hd__mux2_1
X_4082_ _2117_ VGND VGND VPWR VPWR _0334_ sky130_fd_sc_hd__clkbuf_1
XFILLER_0_37_97 VGND VGND VPWR VPWR sky130_fd_sc_hd__decap_4
X_3033_ _1180_ _1192_ _1040_ VGND VGND VPWR VPWR _1193_ sky130_fd_sc_hd__mux2_1
XTAP_TAPCELL_ROW_66_736 VGND VPWR sky130_fd_sc_hd__tapvpwrvgnd_1
X_3935_ _1968_ RF0.regs\[10\]\[18\] _2035_ VGND VGND VPWR VPWR _2039_ sky130_fd_sc_hd__mux2_1
XFILLER_0_73_365 VGND VGND VPWR VPWR sky130_fd_sc_hd__fill_1
X_3866_ _1993_ RF0.regs\[5\]\[11\] _1994_ VGND VGND VPWR VPWR _1995_ sky130_fd_sc_hd__mux2_1
XFILLER_0_14_421 VPWR VGND VPWR VGND sky130_ef_sc_hd__decap_12
XFILLER_0_5_142 VGND VGND VPWR VPWR sky130_fd_sc_hd__fill_1
X_3797_ _1085_ _1936_ _1937_ _1152_ _1623_ VGND VGND VPWR VPWR _1938_ sky130_fd_sc_hd__a32o_1
X_2817_ _0791_ _0977_ VGND VGND VPWR VPWR _0978_ sky130_fd_sc_hd__or2_1
XFILLER_0_5_186 VGND VGND VPWR VPWR sky130_fd_sc_hd__fill_2
X_2748_ RF0.regs\[10\]\[13\] _0615_ _0672_ RF0.regs\[25\]\[13\] VGND VGND VPWR VPWR
+ _0909_ sky130_fd_sc_hd__a22oi_4
XFILLER_0_41_273 VGND VGND VPWR VPWR sky130_fd_sc_hd__decap_6
X_4418_ _2262_ VGND VGND VPWR VPWR _0092_ sky130_fd_sc_hd__inv_2
X_2679_ _0827_ _0838_ VGND VGND VPWR VPWR _0840_ sky130_fd_sc_hd__and2_1
X_4349_ _2253_ VGND VGND VPWR VPWR _2254_ sky130_fd_sc_hd__clkbuf_4
XTAP_TAPCELL_ROW_37_493 VGND VPWR sky130_fd_sc_hd__tapvpwrvgnd_1
XFILLER_0_49_373 VPWR VGND VPWR VGND sky130_ef_sc_hd__decap_12
XFILLER_0_9_481 VGND VGND VPWR VPWR sky130_fd_sc_hd__fill_1
XFILLER_0_24_218 VGND VGND VPWR VPWR sky130_fd_sc_hd__decap_3
XFILLER_0_64_365 VGND VGND VPWR VPWR sky130_fd_sc_hd__fill_2
XFILLER_0_17_281 VGND VGND VPWR VPWR sky130_fd_sc_hd__decap_8
XFILLER_0_74_29 VPWR VGND VPWR VGND sky130_ef_sc_hd__decap_12
XFILLER_0_59_137 VGND VGND VPWR VPWR sky130_fd_sc_hd__fill_1
X_3720_ _1468_ _1469_ VGND VGND VPWR VPWR _1861_ sky130_fd_sc_hd__nor2_1
XTAP_TAPCELL_ROW_71_783 VGND VPWR sky130_fd_sc_hd__tapvpwrvgnd_1
X_3651_ _1795_ _1787_ _1766_ _1800_ _1801_ VGND VGND VPWR VPWR _1802_ sky130_fd_sc_hd__o311a_4
X_2602_ _0679_ _0755_ _0627_ VGND VGND VPWR VPWR _0763_ sky130_fd_sc_hd__a21oi_1
X_3582_ _1731_ _1733_ VGND VGND VPWR VPWR _1734_ sky130_fd_sc_hd__or2_1
XFILLER_0_2_123 VGND VGND VPWR VPWR sky130_fd_sc_hd__fill_1
X_2533_ _0658_ _0693_ VGND VGND VPWR VPWR _0694_ sky130_fd_sc_hd__nand2_1
XFILLER_0_48_41 VPWR VGND VPWR VGND sky130_ef_sc_hd__decap_12
X_2464_ _0624_ VGND VGND VPWR VPWR _0625_ sky130_fd_sc_hd__clkbuf_4
X_2395_ _0572_ VGND VGND VPWR VPWR _0464_ sky130_fd_sc_hd__clkbuf_1
XFILLER_0_48_85 VPWR VGND VPWR VGND sky130_ef_sc_hd__decap_12
X_4203_ _1956_ net157 _2181_ VGND VGND VPWR VPWR _2182_ sky130_fd_sc_hd__mux2_1
XTAP_TAPCELL_ROW_79_850 VGND VPWR sky130_fd_sc_hd__tapvpwrvgnd_1
X_4134_ _2133_ VGND VGND VPWR VPWR _2145_ sky130_fd_sc_hd__clkbuf_4
XFILLER_0_64_73 VGND VGND VPWR VPWR sky130_fd_sc_hd__fill_1
X_4065_ _2108_ VGND VGND VPWR VPWR _0342_ sky130_fd_sc_hd__clkbuf_1
Xwire33 _0897_ VGND VGND VPWR VPWR net33 sky130_fd_sc_hd__clkbuf_2
X_3016_ _1174_ _1175_ _1007_ VGND VGND VPWR VPWR _1176_ sky130_fd_sc_hd__mux2_1
XFILLER_0_78_457 VPWR VGND VPWR VGND sky130_ef_sc_hd__decap_12
XFILLER_0_80_83 VGND VGND VPWR VPWR sky130_fd_sc_hd__fill_1
XTAP_TAPCELL_ROW_34_463 VGND VPWR sky130_fd_sc_hd__tapvpwrvgnd_1
X_3918_ _1853_ RF0.regs\[10\]\[26\] _2024_ VGND VGND VPWR VPWR _2030_ sky130_fd_sc_hd__mux2_1
X_3849_ _1981_ RF0.regs\[5\]\[15\] _1957_ VGND VGND VPWR VPWR _1982_ sky130_fd_sc_hd__mux2_1
XFILLER_0_61_357 VPWR VGND VPWR VGND sky130_ef_sc_hd__decap_12
XFILLER_0_56_129 VGND VGND VPWR VPWR sky130_fd_sc_hd__decap_3
Xclkbuf_leaf_22_clk clknet_1_0__leaf_clk VGND VGND VPWR VPWR clknet_leaf_22_clk sky130_fd_sc_hd__clkbuf_8
XFILLER_0_37_354 VGND VGND VPWR VPWR sky130_fd_sc_hd__fill_2
XPHY_EDGE_ROW_0_Left_82 VGND VGND VPWR VPWR sky130_fd_sc_hd__decap_3
XTAP_TAPCELL_ROW_76_820 VGND VPWR sky130_fd_sc_hd__tapvpwrvgnd_1
XTAP_TAPCELL_ROW_48_588 VGND VPWR sky130_fd_sc_hd__tapvpwrvgnd_1
X_4821_ clknet_leaf_13_clk _0471_ _0215_ VGND VGND VPWR VPWR RF0.regs\[0\]\[23\] sky130_fd_sc_hd__dfrtp_1
XFILLER_0_75_449 VPWR VGND VPWR VGND sky130_ef_sc_hd__decap_12
Xclkbuf_leaf_13_clk clknet_1_1__leaf_clk VGND VGND VPWR VPWR clknet_leaf_13_clk sky130_fd_sc_hd__clkbuf_8
XFILLER_0_28_365 VGND VGND VPWR VPWR sky130_fd_sc_hd__decap_3
X_4752_ clknet_leaf_10_clk _0402_ _0146_ VGND VGND VPWR VPWR RF0.regs\[10\]\[18\]
+ sky130_fd_sc_hd__dfrtp_2
X_4683_ clknet_leaf_5_clk _0333_ _0077_ VGND VGND VPWR VPWR RF0.regs\[20\]\[13\] sky130_fd_sc_hd__dfrtp_1
X_3703_ _1360_ _1847_ _1304_ VGND VGND VPWR VPWR _1848_ sky130_fd_sc_hd__o21ai_1
XFILLER_0_43_357 VGND VGND VPWR VPWR sky130_fd_sc_hd__fill_1
X_3634_ _1097_ _1759_ _1772_ _1784_ VGND VGND VPWR VPWR _1785_ sky130_fd_sc_hd__o31a_1
XFILLER_0_3_432 VPWR VGND VPWR VGND sky130_ef_sc_hd__decap_12
X_3565_ _0949_ VGND VGND VPWR VPWR _1718_ sky130_fd_sc_hd__inv_2
XFILLER_0_59_51 VGND VGND VPWR VPWR sky130_fd_sc_hd__decap_4
X_2516_ RF0.regs\[15\]\[30\] _0664_ _0676_ RF0.regs\[5\]\[30\] VGND VGND VPWR VPWR
+ _0677_ sky130_fd_sc_hd__a22o_1
XFILLER_0_11_243 VGND VGND VPWR VPWR sky130_fd_sc_hd__fill_1
X_3496_ _1645_ _1646_ net26 VGND VGND VPWR VPWR _1651_ sky130_fd_sc_hd__mux2_1
X_2447_ _0514_ _0607_ VGND VGND VPWR VPWR _0608_ sky130_fd_sc_hd__and2_1
XFILLER_0_45_3 VPWR VGND VPWR VGND sky130_ef_sc_hd__decap_12
X_2378_ net117 VGND VGND VPWR VPWR _0564_ sky130_fd_sc_hd__clkbuf_1
X_4117_ _2136_ VGND VGND VPWR VPWR _0318_ sky130_fd_sc_hd__clkbuf_1
XTAP_TAPCELL_ROW_39_511 VGND VPWR sky130_fd_sc_hd__tapvpwrvgnd_1
X_4048_ net139 _1838_ _2098_ VGND VGND VPWR VPWR _2100_ sky130_fd_sc_hd__mux2_2
XFILLER_0_38_118 VPWR VGND VPWR VGND sky130_ef_sc_hd__decap_12
XFILLER_0_66_405 VGND VGND VPWR VPWR sky130_fd_sc_hd__fill_1
XFILLER_0_34_346 VGND VGND VPWR VPWR sky130_fd_sc_hd__decap_6
XPHY_EDGE_ROW_18_Left_100 VGND VGND VPWR VPWR sky130_fd_sc_hd__decap_3
XTAP_TAPCELL_ROW_2_191 VGND VPWR sky130_fd_sc_hd__tapvpwrvgnd_1
XTAP_TAPCELL_ROW_45_558 VGND VPWR sky130_fd_sc_hd__tapvpwrvgnd_1
XFILLER_0_25_335 VGND VGND VPWR VPWR sky130_fd_sc_hd__fill_1
XFILLER_0_52_176 VGND VGND VPWR VPWR sky130_fd_sc_hd__fill_2
XFILLER_0_52_187 VGND VGND VPWR VPWR sky130_fd_sc_hd__fill_2
X_3350_ _1500_ VGND VGND VPWR VPWR _1507_ sky130_fd_sc_hd__inv_2
X_2301_ IM0.addr\[19\] IM0.addr\[18\] _0525_ VGND VGND VPWR VPWR _0526_ sky130_fd_sc_hd__and3_1
X_3281_ _0913_ _1016_ _1014_ VGND VGND VPWR VPWR _1439_ sky130_fd_sc_hd__mux2_1
Xclkbuf_leaf_2_clk clknet_1_0__leaf_clk VGND VGND VPWR VPWR clknet_leaf_2_clk sky130_fd_sc_hd__clkbuf_8
XFILLER_0_48_438 VGND VGND VPWR VPWR sky130_fd_sc_hd__decap_6
XFILLER_0_0_88 VGND VGND VPWR VPWR sky130_fd_sc_hd__decap_4
X_4804_ clknet_leaf_17_clk _0454_ _0198_ VGND VGND VPWR VPWR RF0.regs\[0\]\[6\] sky130_fd_sc_hd__dfrtp_1
X_4735_ clknet_leaf_23_clk _0385_ _0129_ VGND VGND VPWR VPWR RF0.regs\[10\]\[1\] sky130_fd_sc_hd__dfrtp_2
X_2996_ _0829_ _1155_ _1004_ VGND VGND VPWR VPWR _1156_ sky130_fd_sc_hd__mux2_1
XFILLER_0_16_335 VPWR VGND VPWR VGND sky130_ef_sc_hd__decap_12
XFILLER_0_71_441 VGND VGND VPWR VPWR sky130_fd_sc_hd__decap_6
X_4666_ clknet_leaf_12_clk _0316_ _0060_ VGND VGND VPWR VPWR RF0.regs\[25\]\[28\]
+ sky130_fd_sc_hd__dfrtp_2
X_4597_ _2286_ VGND VGND VPWR VPWR _0247_ sky130_fd_sc_hd__inv_2
XFILLER_0_3_240 VGND VGND VPWR VPWR sky130_fd_sc_hd__fill_2
XFILLER_0_3_262 VGND VGND VPWR VPWR sky130_fd_sc_hd__fill_1
XFILLER_0_31_349 VPWR VGND VPWR VGND sky130_ef_sc_hd__decap_12
X_3617_ RF0.regs\[5\]\[18\] _0634_ _0638_ RF0.regs\[30\]\[18\] _0641_ VGND VGND VPWR
+ VPWR _1768_ sky130_fd_sc_hd__a221o_1
X_3548_ _1701_ VGND VGND VPWR VPWR _1702_ sky130_fd_sc_hd__inv_2
X_3479_ _1428_ _1429_ _1009_ VGND VGND VPWR VPWR _1635_ sky130_fd_sc_hd__mux2_1
XFILLER_0_39_449 VGND VGND VPWR VPWR sky130_fd_sc_hd__decap_8
XFILLER_0_81_249 VGND VGND VPWR VPWR sky130_fd_sc_hd__decap_3
XTAP_TAPCELL_ROW_58_672 VGND VPWR sky130_fd_sc_hd__tapvpwrvgnd_1
X_2850_ _1010_ VGND VGND VPWR VPWR _1011_ sky130_fd_sc_hd__clkbuf_4
XFILLER_0_31_55 VGND VGND VPWR VPWR sky130_fd_sc_hd__fill_1
X_2781_ _0940_ _0941_ VGND VGND VPWR VPWR _0942_ sky130_fd_sc_hd__xnor2_1
XTAP_TAPCELL_ROW_13_285 VGND VPWR sky130_fd_sc_hd__tapvpwrvgnd_1
X_4520_ _2278_ VGND VGND VPWR VPWR _0178_ sky130_fd_sc_hd__inv_2
X_4451_ _2266_ VGND VGND VPWR VPWR _0121_ sky130_fd_sc_hd__inv_2
XFILLER_0_0_221 VGND VGND VPWR VPWR sky130_fd_sc_hd__decap_3
X_3402_ _1556_ _0840_ _1557_ _0819_ _1558_ VGND VGND VPWR VPWR _1559_ sky130_fd_sc_hd__o311a_1
X_4382_ _2257_ VGND VGND VPWR VPWR _0061_ sky130_fd_sc_hd__inv_2
XFILLER_0_21_371 VGND VGND VPWR VPWR sky130_fd_sc_hd__fill_1
XFILLER_0_0_265 VPWR VGND VPWR VGND sky130_ef_sc_hd__decap_12
X_3333_ _1490_ VGND VGND VPWR VPWR _1491_ sky130_fd_sc_hd__inv_2
XPHY_EDGE_ROW_7_Right_7 VGND VGND VPWR VPWR sky130_fd_sc_hd__decap_3
XFILLER_0_56_41 VGND VGND VPWR VPWR sky130_fd_sc_hd__decap_3
X_3264_ _1409_ _1411_ _1421_ VGND VGND VPWR VPWR _1422_ sky130_fd_sc_hd__mux2_4
XFILLER_0_56_85 VGND VGND VPWR VPWR sky130_fd_sc_hd__fill_2
X_3195_ _1309_ _1353_ _0653_ VGND VGND VPWR VPWR _1354_ sky130_fd_sc_hd__and3b_1
XFILLER_0_72_73 VGND VGND VPWR VPWR sky130_fd_sc_hd__decap_3
XFILLER_0_36_419 VGND VGND VPWR VPWR sky130_fd_sc_hd__fill_1
X_2979_ _0937_ _0945_ _1014_ VGND VGND VPWR VPWR _1139_ sky130_fd_sc_hd__mux2_1
X_4718_ clknet_leaf_4_clk _0368_ _0112_ VGND VGND VPWR VPWR RF0.regs\[15\]\[16\] sky130_fd_sc_hd__dfrtp_1
X_4649_ clknet_leaf_21_clk _0299_ _0043_ VGND VGND VPWR VPWR RF0.regs\[25\]\[11\]
+ sky130_fd_sc_hd__dfrtp_2
XFILLER_0_31_179 VGND VGND VPWR VPWR sky130_fd_sc_hd__decap_3
XFILLER_0_12_393 VGND VGND VPWR VPWR sky130_fd_sc_hd__fill_2
XTAP_TAPCELL_ROW_55_642 VGND VPWR sky130_fd_sc_hd__tapvpwrvgnd_1
XFILLER_0_79_393 VPWR VGND VPWR VGND sky130_ef_sc_hd__decap_12
XFILLER_0_62_293 VGND VGND VPWR VPWR sky130_fd_sc_hd__decap_3
XFILLER_0_50_444 VGND VGND VPWR VPWR sky130_fd_sc_hd__fill_2
XFILLER_0_50_477 VGND VGND VPWR VPWR sky130_fd_sc_hd__decap_4
XFILLER_0_26_66 VGND VGND VPWR VPWR sky130_fd_sc_hd__fill_2
XTAP_TAPCELL_ROW_18_333 VGND VPWR sky130_fd_sc_hd__tapvpwrvgnd_1
X_3951_ _2047_ VGND VGND VPWR VPWR _0395_ sky130_fd_sc_hd__clkbuf_1
X_2902_ _1062_ VGND VGND VPWR VPWR _1063_ sky130_fd_sc_hd__clkbuf_4
XFILLER_0_18_419 VGND VGND VPWR VPWR sky130_fd_sc_hd__fill_1
X_3882_ _1602_ _1692_ VGND VGND VPWR VPWR _2007_ sky130_fd_sc_hd__xor2_2
XFILLER_0_42_54 VPWR VGND VPWR VGND sky130_ef_sc_hd__decap_12
X_2833_ _0757_ _0993_ VGND VGND VPWR VPWR _0994_ sky130_fd_sc_hd__xor2_1
XFILLER_0_26_474 VGND VGND VPWR VPWR sky130_fd_sc_hd__fill_2
X_2764_ _0924_ VGND VGND VPWR VPWR _0925_ sky130_fd_sc_hd__inv_2
X_4503_ _2275_ VGND VGND VPWR VPWR _0164_ sky130_fd_sc_hd__inv_2
XFILLER_0_41_422 VGND VGND VPWR VPWR sky130_fd_sc_hd__decap_6
X_2695_ _0854_ _0855_ VGND VGND VPWR VPWR _0856_ sky130_fd_sc_hd__and2_1
XFILLER_0_6_21 VGND VGND VPWR VPWR sky130_fd_sc_hd__fill_1
X_4434_ _2265_ VGND VGND VPWR VPWR _0105_ sky130_fd_sc_hd__inv_2
X_4365_ _2255_ VGND VGND VPWR VPWR _0046_ sky130_fd_sc_hd__inv_2
X_3316_ RF0.regs\[0\]\[20\] _0603_ _1473_ VGND VGND VPWR VPWR _1474_ sky130_fd_sc_hd__o21a_1
XFILLER_0_67_51 VGND VGND VPWR VPWR sky130_fd_sc_hd__decap_4
X_4296_ _0654_ _1415_ _1416_ _2236_ VGND VGND VPWR VPWR net16 sky130_fd_sc_hd__a31o_1
X_3247_ _1344_ _1382_ _1404_ VGND VGND VPWR VPWR _1405_ sky130_fd_sc_hd__or3_1
X_3178_ _1043_ _1055_ _1074_ VGND VGND VPWR VPWR _1337_ sky130_fd_sc_hd__mux2_1
XFILLER_0_76_374 VGND VGND VPWR VPWR sky130_fd_sc_hd__decap_3
XFILLER_0_8_173 VGND VGND VPWR VPWR sky130_fd_sc_hd__fill_2
XFILLER_0_51_219 VGND VGND VPWR VPWR sky130_fd_sc_hd__decap_4
XFILLER_0_44_282 VGND VGND VPWR VPWR sky130_fd_sc_hd__fill_1
XFILLER_0_32_477 VGND VGND VPWR VPWR sky130_fd_sc_hd__fill_1
XTAP_TAPCELL_ROW_15_303 VGND VPWR sky130_fd_sc_hd__tapvpwrvgnd_1
XFILLER_0_67_352 VGND VGND VPWR VPWR sky130_fd_sc_hd__fill_1
XFILLER_0_27_205 VGND VGND VPWR VPWR sky130_fd_sc_hd__decap_4
XFILLER_0_23_411 VGND VGND VPWR VPWR sky130_fd_sc_hd__decap_4
XFILLER_0_23_444 VGND VGND VPWR VPWR sky130_fd_sc_hd__decap_4
XFILLER_0_50_230 VGND VGND VPWR VPWR sky130_fd_sc_hd__fill_1
X_2480_ _0640_ VGND VGND VPWR VPWR _0641_ sky130_fd_sc_hd__buf_2
X_4150_ _2153_ VGND VGND VPWR VPWR _0302_ sky130_fd_sc_hd__clkbuf_1
X_3101_ _1063_ _1260_ VGND VGND VPWR VPWR _1261_ sky130_fd_sc_hd__nand2_1
X_4081_ net162 _1984_ _2109_ VGND VGND VPWR VPWR _2117_ sky130_fd_sc_hd__mux2_1
X_3032_ _1059_ _1186_ _1191_ VGND VGND VPWR VPWR _1192_ sky130_fd_sc_hd__a21o_1
XTAP_TAPCELL_ROW_66_737 VGND VPWR sky130_fd_sc_hd__tapvpwrvgnd_1
XFILLER_0_73_300 VGND VGND VPWR VPWR sky130_fd_sc_hd__decap_8
X_3934_ _2038_ VGND VGND VPWR VPWR _0403_ sky130_fd_sc_hd__clkbuf_1
X_3865_ _1834_ VGND VGND VPWR VPWR _1994_ sky130_fd_sc_hd__clkbuf_4
XFILLER_0_73_388 VGND VGND VPWR VPWR sky130_fd_sc_hd__decap_4
XFILLER_0_5_110 VGND VGND VPWR VPWR sky130_fd_sc_hd__fill_2
X_2816_ _0783_ _0784_ VGND VGND VPWR VPWR _0977_ sky130_fd_sc_hd__and2_1
XFILLER_0_14_400 VGND VGND VPWR VPWR sky130_fd_sc_hd__decap_3
X_3796_ _1136_ _1212_ VGND VGND VPWR VPWR _1937_ sky130_fd_sc_hd__or2_1
XFILLER_0_14_433 VPWR VGND VPWR VGND sky130_ef_sc_hd__decap_12
X_2747_ _0902_ _0907_ VGND VGND VPWR VPWR _0908_ sky130_fd_sc_hd__nor2_1
XFILLER_0_41_241 VPWR VGND VPWR VGND sky130_ef_sc_hd__decap_12
XFILLER_0_75_3 VPWR VGND VPWR VGND sky130_ef_sc_hd__decap_12
XFILLER_0_14_477 VGND VGND VPWR VPWR sky130_fd_sc_hd__decap_4
X_2678_ _0827_ _0838_ VGND VGND VPWR VPWR _0839_ sky130_fd_sc_hd__nor2_1
XFILLER_0_78_83 VGND VGND VPWR VPWR sky130_fd_sc_hd__fill_1
X_4417_ _2258_ VGND VGND VPWR VPWR _2262_ sky130_fd_sc_hd__clkbuf_2
XFILLER_0_1_393 VPWR VGND VPWR VGND sky130_ef_sc_hd__decap_12
X_4348_ _2246_ VGND VGND VPWR VPWR _2253_ sky130_fd_sc_hd__clkbuf_2
X_4279_ _1205_ _1648_ _2223_ VGND VGND VPWR VPWR _2224_ sky130_fd_sc_hd__o21ai_1
XFILLER_0_68_105 VGND VGND VPWR VPWR sky130_fd_sc_hd__decap_3
XTAP_TAPCELL_ROW_37_494 VGND VPWR sky130_fd_sc_hd__tapvpwrvgnd_1
XFILLER_0_49_385 VGND VGND VPWR VPWR sky130_fd_sc_hd__decap_6
XFILLER_0_64_377 VGND VGND VPWR VPWR sky130_fd_sc_hd__decap_8
XTAP_TAPCELL_ROW_20_350 VGND VPWR sky130_fd_sc_hd__tapvpwrvgnd_1
X_3650_ _1754_ _1765_ VGND VGND VPWR VPWR _1801_ sky130_fd_sc_hd__or2_1
XFILLER_0_70_325 VGND VGND VPWR VPWR sky130_fd_sc_hd__decap_4
X_2601_ _0760_ _0761_ VGND VGND VPWR VPWR _0762_ sky130_fd_sc_hd__nor2_1
X_3581_ RF0.regs\[20\]\[16\] _0626_ _1091_ RF0.regs\[25\]\[16\] _1732_ VGND VGND VPWR
+ VPWR _1733_ sky130_fd_sc_hd__a221o_1
Xrebuffer1 _0745_ VGND VGND VPWR VPWR net36 sky130_fd_sc_hd__dlymetal6s2s_1
XFILLER_0_70_369 VGND VGND VPWR VPWR sky130_fd_sc_hd__fill_1
X_2532_ RF0.regs\[15\]\[20\] _0663_ _0672_ RF0.regs\[5\]\[20\] VGND VGND VPWR VPWR
+ _0693_ sky130_fd_sc_hd__a22o_1
X_2463_ _0623_ VGND VGND VPWR VPWR _0624_ sky130_fd_sc_hd__clkbuf_4
X_4202_ _2169_ VGND VGND VPWR VPWR _2181_ sky130_fd_sc_hd__clkbuf_4
X_2394_ net101 VGND VGND VPWR VPWR _0572_ sky130_fd_sc_hd__clkbuf_1
XFILLER_0_48_53 VPWR VGND VPWR VGND sky130_ef_sc_hd__decap_12
XTAP_TAPCELL_ROW_79_851 VGND VPWR sky130_fd_sc_hd__tapvpwrvgnd_1
X_4133_ _2144_ VGND VGND VPWR VPWR _0310_ sky130_fd_sc_hd__clkbuf_1
XFILLER_0_3_55 VGND VGND VPWR VPWR sky130_fd_sc_hd__fill_1
X_4064_ net131 _1953_ _2098_ VGND VGND VPWR VPWR _2108_ sky130_fd_sc_hd__mux2_1
XFILLER_0_3_66 VGND VGND VPWR VPWR sky130_fd_sc_hd__fill_1
X_3015_ RF0.regs\[10\]\[17\] _0969_ _0931_ RF0.regs\[25\]\[17\] VGND VGND VPWR VPWR
+ _1175_ sky130_fd_sc_hd__a22o_1
XFILLER_0_64_41 VPWR VGND VPWR VGND sky130_ef_sc_hd__decap_12
XFILLER_0_78_469 VGND VGND VPWR VPWR sky130_fd_sc_hd__decap_6
XFILLER_0_65_108 VGND VGND VPWR VPWR sky130_fd_sc_hd__fill_1
XTAP_TAPCELL_ROW_34_464 VGND VPWR sky130_fd_sc_hd__tapvpwrvgnd_1
X_3917_ _2029_ VGND VGND VPWR VPWR _0411_ sky130_fd_sc_hd__clkbuf_1
X_3848_ _1508_ _1980_ VGND VGND VPWR VPWR _1981_ sky130_fd_sc_hd__xnor2_2
X_3779_ _1208_ _1210_ _1049_ VGND VGND VPWR VPWR _1920_ sky130_fd_sc_hd__mux2_1
XFILLER_0_61_369 VPWR VGND VPWR VGND sky130_ef_sc_hd__decap_12
XFILLER_0_56_108 VGND VGND VPWR VPWR sky130_fd_sc_hd__decap_6
XFILLER_0_64_141 VPWR VGND VPWR VGND sky130_ef_sc_hd__decap_12
XTAP_TAPCELL_ROW_76_821 VGND VPWR sky130_fd_sc_hd__tapvpwrvgnd_1
XFILLER_0_18_78 VGND VGND VPWR VPWR sky130_fd_sc_hd__decap_6
XFILLER_0_34_88 VGND VGND VPWR VPWR sky130_fd_sc_hd__decap_8
XFILLER_0_47_108 VGND VGND VPWR VPWR sky130_fd_sc_hd__decap_4
X_4820_ clknet_leaf_13_clk _0470_ _0214_ VGND VGND VPWR VPWR RF0.regs\[0\]\[22\] sky130_fd_sc_hd__dfrtp_1
XFILLER_0_28_344 VGND VGND VPWR VPWR sky130_fd_sc_hd__decap_4
X_4751_ clknet_leaf_3_clk _0401_ _0145_ VGND VGND VPWR VPWR RF0.regs\[10\]\[17\] sky130_fd_sc_hd__dfrtp_2
XFILLER_0_28_377 VPWR VGND VPWR VGND sky130_ef_sc_hd__decap_12
X_4682_ clknet_leaf_1_clk _0332_ _0076_ VGND VGND VPWR VPWR RF0.regs\[20\]\[12\] sky130_fd_sc_hd__dfrtp_1
XFILLER_0_55_163 VGND VGND VPWR VPWR sky130_fd_sc_hd__decap_4
X_3702_ _1405_ _1813_ VGND VGND VPWR VPWR _1847_ sky130_fd_sc_hd__nor2_1
X_3633_ _1084_ _1781_ _1783_ _1151_ _1663_ VGND VGND VPWR VPWR _1784_ sky130_fd_sc_hd__a32o_1
XFILLER_0_3_444 VGND VGND VPWR VPWR sky130_fd_sc_hd__decap_4
X_3564_ _1714_ _1716_ VGND VGND VPWR VPWR _1717_ sky130_fd_sc_hd__or2_1
XFILLER_0_51_391 VGND VGND VPWR VPWR sky130_fd_sc_hd__fill_1
X_3495_ _1083_ _1648_ _1650_ _0650_ VGND VGND VPWR VPWR net26 sky130_fd_sc_hd__a22o_1
X_2515_ _0675_ VGND VGND VPWR VPWR _0676_ sky130_fd_sc_hd__buf_4
X_2446_ IM0.addr\[2\] _0513_ _0606_ VGND VGND VPWR VPWR _0607_ sky130_fd_sc_hd__nor3_2
X_4116_ _1838_ RF0.regs\[25\]\[30\] _2134_ VGND VGND VPWR VPWR _2136_ sky130_fd_sc_hd__mux2_2
XFILLER_0_75_51 VGND VGND VPWR VPWR sky130_fd_sc_hd__decap_4
XFILLER_0_38_3 VPWR VGND VPWR VGND sky130_ef_sc_hd__decap_12
X_2377_ _0563_ VGND VGND VPWR VPWR _0473_ sky130_fd_sc_hd__clkbuf_1
X_4047_ _2099_ VGND VGND VPWR VPWR _0351_ sky130_fd_sc_hd__clkbuf_1
XFILLER_0_19_322 VPWR VGND VPWR VGND sky130_ef_sc_hd__decap_12
XFILLER_0_46_141 VGND VGND VPWR VPWR sky130_fd_sc_hd__fill_2
XFILLER_0_34_303 VGND VGND VPWR VPWR sky130_fd_sc_hd__fill_1
XFILLER_0_46_163 VGND VGND VPWR VPWR sky130_fd_sc_hd__decap_6
XFILLER_0_61_100 VGND VGND VPWR VPWR sky130_fd_sc_hd__fill_2
XFILLER_0_61_111 VGND VGND VPWR VPWR sky130_fd_sc_hd__fill_1
XFILLER_0_6_271 VGND VGND VPWR VPWR sky130_fd_sc_hd__fill_1
XFILLER_0_61_133 VGND VGND VPWR VPWR sky130_fd_sc_hd__fill_2
XFILLER_0_61_144 VGND VGND VPWR VPWR sky130_fd_sc_hd__fill_1
XTAP_TAPCELL_ROW_2_192 VGND VPWR sky130_fd_sc_hd__tapvpwrvgnd_1
XFILLER_0_29_108 VGND VGND VPWR VPWR sky130_fd_sc_hd__decap_4
XTAP_TAPCELL_ROW_45_559 VGND VPWR sky130_fd_sc_hd__tapvpwrvgnd_1
XFILLER_0_57_406 VGND VGND VPWR VPWR sky130_fd_sc_hd__fill_1
XFILLER_0_57_439 VGND VGND VPWR VPWR sky130_fd_sc_hd__decap_8
XFILLER_0_65_461 VPWR VGND VPWR VGND sky130_ef_sc_hd__decap_12
XFILLER_0_80_475 VGND VGND VPWR VPWR sky130_fd_sc_hd__fill_1
XFILLER_0_20_68 VGND VGND VPWR VPWR sky130_fd_sc_hd__fill_2
XFILLER_0_40_306 VGND VGND VPWR VPWR sky130_fd_sc_hd__fill_2
XFILLER_0_33_391 VGND VGND VPWR VPWR sky130_fd_sc_hd__fill_1
X_2300_ IM0.addr\[17\] _0524_ VGND VGND VPWR VPWR _0525_ sky130_fd_sc_hd__and2_1
X_3280_ _1006_ _0909_ _1014_ VGND VGND VPWR VPWR _1438_ sky130_fd_sc_hd__mux2_1
XFILLER_0_75_225 VGND VGND VPWR VPWR sky130_fd_sc_hd__fill_1
XFILLER_0_75_269 VGND VGND VPWR VPWR sky130_fd_sc_hd__decap_8
X_4803_ clknet_leaf_17_clk _0453_ _0197_ VGND VGND VPWR VPWR RF0.regs\[0\]\[5\] sky130_fd_sc_hd__dfrtp_1
X_4734_ clknet_leaf_18_clk _0384_ _0128_ VGND VGND VPWR VPWR RF0.regs\[10\]\[0\] sky130_fd_sc_hd__dfrtp_2
X_2995_ RF0.regs\[10\]\[7\] _0828_ _0672_ RF0.regs\[25\]\[7\] VGND VGND VPWR VPWR
+ _1155_ sky130_fd_sc_hd__a22o_1
XFILLER_0_43_100 VGND VGND VPWR VPWR sky130_fd_sc_hd__decap_8
XFILLER_0_16_347 VGND VGND VPWR VPWR sky130_fd_sc_hd__decap_8
XFILLER_0_43_111 VGND VGND VPWR VPWR sky130_fd_sc_hd__fill_1
XFILLER_0_43_122 VGND VGND VPWR VPWR sky130_fd_sc_hd__fill_1
X_4665_ clknet_leaf_12_clk _0315_ _0059_ VGND VGND VPWR VPWR RF0.regs\[25\]\[27\]
+ sky130_fd_sc_hd__dfrtp_1
X_4596_ _2286_ VGND VGND VPWR VPWR _0246_ sky130_fd_sc_hd__inv_2
XFILLER_0_24_391 VGND VGND VPWR VPWR sky130_fd_sc_hd__fill_1
XFILLER_0_43_188 VPWR VGND VPWR VGND sky130_ef_sc_hd__decap_12
X_3616_ RF0.regs\[15\]\[18\] _0610_ _0618_ RF0.regs\[25\]\[18\] VGND VGND VPWR VPWR
+ _1767_ sky130_fd_sc_hd__a22o_1
X_3547_ _1697_ _1700_ VGND VGND VPWR VPWR _1701_ sky130_fd_sc_hd__and2_1
X_3478_ RF0.regs\[0\]\[4\] _0602_ _1626_ _1628_ VGND VGND VPWR VPWR _1634_ sky130_fd_sc_hd__o22a_1
X_2429_ IM0.addr\[25\] IM0.addr\[24\] IM0.addr\[23\] IM0.addr\[22\] VGND VGND VPWR
+ VPWR _0590_ sky130_fd_sc_hd__or4_4
XFILLER_0_19_141 VGND VGND VPWR VPWR sky130_fd_sc_hd__fill_2
XTAP_TAPCELL_ROW_42_529 VGND VPWR sky130_fd_sc_hd__tapvpwrvgnd_1
XTAP_TAPCELL_ROW_58_673 VGND VPWR sky130_fd_sc_hd__tapvpwrvgnd_1
XFILLER_0_25_111 VGND VGND VPWR VPWR sky130_fd_sc_hd__fill_1
X_2780_ RF0.regs\[10\]\[16\] _0615_ _0931_ RF0.regs\[25\]\[16\] VGND VGND VPWR VPWR
+ _0941_ sky130_fd_sc_hd__a22o_1
XFILLER_0_65_291 VGND VGND VPWR VPWR sky130_fd_sc_hd__fill_1
XFILLER_0_80_261 VGND VGND VPWR VPWR sky130_fd_sc_hd__fill_2
XFILLER_0_13_317 VGND VGND VPWR VPWR sky130_fd_sc_hd__fill_1
XTAP_TAPCELL_ROW_13_286 VGND VPWR sky130_fd_sc_hd__tapvpwrvgnd_1
X_4450_ _2266_ VGND VGND VPWR VPWR _0120_ sky130_fd_sc_hd__inv_2
X_4381_ _2257_ VGND VGND VPWR VPWR _0060_ sky130_fd_sc_hd__inv_2
X_3401_ _0824_ VGND VGND VPWR VPWR _1558_ sky130_fd_sc_hd__inv_2
XFILLER_0_21_350 VGND VGND VPWR VPWR sky130_fd_sc_hd__fill_1
X_3332_ _1488_ _0916_ _1489_ _0910_ _0905_ VGND VGND VPWR VPWR _1490_ sky130_fd_sc_hd__a311o_2
XFILLER_0_0_277 VGND VGND VPWR VPWR sky130_fd_sc_hd__decap_3
XPHY_EDGE_ROW_37_Left_119 VGND VGND VPWR VPWR sky130_fd_sc_hd__decap_3
X_3263_ _0653_ _1415_ _1416_ _1420_ VGND VGND VPWR VPWR _1421_ sky130_fd_sc_hd__a31oi_4
X_3194_ _0803_ _0976_ _0792_ VGND VGND VPWR VPWR _1353_ sky130_fd_sc_hd__a21o_1
XFILLER_0_72_41 VPWR VGND VPWR VGND sky130_ef_sc_hd__decap_12
XFILLER_0_72_85 VPWR VGND VPWR VGND sky130_ef_sc_hd__decap_12
XPHY_EDGE_ROW_46_Left_128 VGND VGND VPWR VPWR sky130_fd_sc_hd__decap_3
XFILLER_0_8_355 VGND VGND VPWR VPWR sky130_fd_sc_hd__decap_3
X_2978_ _0898_ _1051_ _1080_ VGND VGND VPWR VPWR _1138_ sky130_fd_sc_hd__mux2_1
XFILLER_0_16_166 VGND VGND VPWR VPWR sky130_fd_sc_hd__fill_1
X_4717_ clknet_leaf_1_clk _0367_ _0111_ VGND VGND VPWR VPWR RF0.regs\[15\]\[15\] sky130_fd_sc_hd__dfrtp_1
XFILLER_0_44_475 VGND VGND VPWR VPWR sky130_fd_sc_hd__fill_1
X_4648_ clknet_leaf_21_clk _0298_ _0042_ VGND VGND VPWR VPWR RF0.regs\[25\]\[10\]
+ sky130_fd_sc_hd__dfrtp_4
XFILLER_0_31_169 VGND VGND VPWR VPWR sky130_fd_sc_hd__fill_1
X_4579_ _2285_ VGND VGND VPWR VPWR _0230_ sky130_fd_sc_hd__inv_2
XPHY_EDGE_ROW_55_Left_137 VGND VGND VPWR VPWR sky130_fd_sc_hd__decap_3
XTAP_TAPCELL_ROW_4_210 VGND VPWR sky130_fd_sc_hd__tapvpwrvgnd_1
XTAP_TAPCELL_ROW_55_643 VGND VPWR sky130_fd_sc_hd__tapvpwrvgnd_1
XPHY_EDGE_ROW_64_Left_146 VGND VGND VPWR VPWR sky130_fd_sc_hd__decap_3
XFILLER_0_22_125 VGND VGND VPWR VPWR sky130_fd_sc_hd__fill_2
XFILLER_0_22_136 VGND VGND VPWR VPWR sky130_fd_sc_hd__decap_4
XPHY_EDGE_ROW_73_Left_155 VGND VGND VPWR VPWR sky130_fd_sc_hd__decap_3
Xhold90 RF0.regs\[20\]\[1\] VGND VGND VPWR VPWR net125 sky130_fd_sc_hd__dlygate4sd3_1
X_3950_ _1993_ RF0.regs\[10\]\[11\] _2046_ VGND VGND VPWR VPWR _2047_ sky130_fd_sc_hd__mux2_1
X_2901_ _1061_ VGND VGND VPWR VPWR _1062_ sky130_fd_sc_hd__clkbuf_4
XFILLER_0_42_33 VGND VGND VPWR VPWR sky130_fd_sc_hd__fill_1
X_3881_ _2006_ VGND VGND VPWR VPWR _0424_ sky130_fd_sc_hd__clkbuf_1
XFILLER_0_42_66 VGND VGND VPWR VPWR sky130_fd_sc_hd__decap_8
X_2832_ RF0.regs\[15\]\[31\] _0664_ _0676_ RF0.regs\[5\]\[31\] VGND VGND VPWR VPWR
+ _0993_ sky130_fd_sc_hd__a22o_1
XFILLER_0_5_303 VGND VGND VPWR VPWR sky130_fd_sc_hd__fill_1
X_2763_ _0912_ _0913_ VGND VGND VPWR VPWR _0924_ sky130_fd_sc_hd__nor2_1
X_4502_ _2275_ VGND VGND VPWR VPWR _0163_ sky130_fd_sc_hd__inv_2
X_2694_ RF0.regs\[10\]\[5\] _0614_ _0670_ RF0.regs\[25\]\[5\] VGND VGND VPWR VPWR
+ _0855_ sky130_fd_sc_hd__a22oi_2
X_4433_ _2265_ VGND VGND VPWR VPWR _0104_ sky130_fd_sc_hd__inv_2
X_4364_ _2255_ VGND VGND VPWR VPWR _0045_ sky130_fd_sc_hd__inv_2
X_3315_ _1470_ _1472_ VGND VGND VPWR VPWR _1473_ sky130_fd_sc_hd__or2_1
X_4295_ _1002_ _2234_ _2235_ _1205_ _1601_ VGND VGND VPWR VPWR _2236_ sky130_fd_sc_hd__o32a_1
X_3246_ _1383_ net17 _1359_ VGND VGND VPWR VPWR _1404_ sky130_fd_sc_hd__o21ai_4
XFILLER_0_67_85 VGND VGND VPWR VPWR sky130_fd_sc_hd__fill_1
XFILLER_0_20_3 VPWR VGND VPWR VGND sky130_ef_sc_hd__decap_12
X_3177_ _1334_ _1335_ _1020_ VGND VGND VPWR VPWR _1336_ sky130_fd_sc_hd__mux2_1
Xrebuffer11 _1467_ VGND VGND VPWR VPWR net46 sky130_fd_sc_hd__clkbuf_1
XFILLER_0_8_152 VGND VGND VPWR VPWR sky130_fd_sc_hd__decap_8
XFILLER_0_17_442 VGND VGND VPWR VPWR sky130_fd_sc_hd__decap_6
XTAP_TAPCELL_ROW_60_690 VGND VPWR sky130_fd_sc_hd__tapvpwrvgnd_1
XTAP_TAPCELL_ROW_15_304 VGND VPWR sky130_fd_sc_hd__tapvpwrvgnd_1
XFILLER_0_27_217 VGND VGND VPWR VPWR sky130_fd_sc_hd__decap_6
XFILLER_0_12_69 VPWR VGND VPWR VGND sky130_ef_sc_hd__decap_12
XTAP_TAPCELL_ROW_23_370 VGND VPWR sky130_fd_sc_hd__tapvpwrvgnd_1
XFILLER_0_10_139 VGND VGND VPWR VPWR sky130_fd_sc_hd__fill_1
Xoutput1 net1 VGND VGND VPWR VPWR Result[0] sky130_fd_sc_hd__buf_2
XFILLER_0_50_286 VGND VGND VPWR VPWR sky130_fd_sc_hd__fill_1
X_3100_ _1216_ _1217_ _1047_ VGND VGND VPWR VPWR _1260_ sky130_fd_sc_hd__mux2_1
X_4080_ _2116_ VGND VGND VPWR VPWR _0335_ sky130_fd_sc_hd__clkbuf_1
XFILLER_0_37_55 VGND VGND VPWR VPWR sky130_fd_sc_hd__fill_1
X_3031_ _1066_ _1188_ _1190_ VGND VGND VPWR VPWR _1191_ sky130_fd_sc_hd__and3_1
XTAP_TAPCELL_ROW_66_738 VGND VPWR sky130_fd_sc_hd__tapvpwrvgnd_1
XFILLER_0_53_87 VGND VGND VPWR VPWR sky130_fd_sc_hd__fill_2
XFILLER_0_58_342 VGND VGND VPWR VPWR sky130_fd_sc_hd__decap_4
X_3933_ _1965_ RF0.regs\[10\]\[19\] _2035_ VGND VGND VPWR VPWR _2038_ sky130_fd_sc_hd__mux2_1
XFILLER_0_73_334 VGND VGND VPWR VPWR sky130_fd_sc_hd__fill_2
XFILLER_0_73_323 VGND VGND VPWR VPWR sky130_fd_sc_hd__fill_1
XFILLER_0_73_312 VGND VGND VPWR VPWR sky130_fd_sc_hd__decap_3
X_3864_ _1704_ _1992_ VGND VGND VPWR VPWR _1993_ sky130_fd_sc_hd__xnor2_2
XFILLER_0_58_397 VGND VGND VPWR VPWR sky130_fd_sc_hd__decap_8
XFILLER_0_33_209 VGND VGND VPWR VPWR sky130_fd_sc_hd__decap_4
X_2815_ _0968_ _0973_ _0975_ VGND VGND VPWR VPWR _0976_ sky130_fd_sc_hd__nand3_2
XFILLER_0_5_155 VGND VGND VPWR VPWR sky130_fd_sc_hd__fill_1
XFILLER_0_5_133 VGND VGND VPWR VPWR sky130_fd_sc_hd__fill_1
X_3795_ _1935_ _1526_ VGND VGND VPWR VPWR _1936_ sky130_fd_sc_hd__nand2_1
XFILLER_0_14_445 VPWR VGND VPWR VGND sky130_ef_sc_hd__decap_12
X_2746_ _0623_ _0743_ _0734_ VGND VGND VPWR VPWR _0907_ sky130_fd_sc_hd__o21a_1
X_2677_ RF0.regs\[10\]\[8\] _0614_ _0670_ RF0.regs\[25\]\[8\] VGND VGND VPWR VPWR
+ _0838_ sky130_fd_sc_hd__a22o_2
XFILLER_0_41_253 VGND VGND VPWR VPWR sky130_fd_sc_hd__decap_8
XFILLER_0_41_264 VGND VGND VPWR VPWR sky130_fd_sc_hd__fill_2
XFILLER_0_68_3 VPWR VGND VPWR VGND sky130_ef_sc_hd__decap_12
X_4416_ _2261_ VGND VGND VPWR VPWR _0091_ sky130_fd_sc_hd__inv_2
X_4347_ _2252_ VGND VGND VPWR VPWR _0031_ sky130_fd_sc_hd__inv_2
X_4278_ _1935_ _2216_ _2222_ _1002_ VGND VGND VPWR VPWR _2223_ sky130_fd_sc_hd__a211o_1
X_3229_ _1386_ _1387_ _1063_ VGND VGND VPWR VPWR _1388_ sky130_fd_sc_hd__mux2_1
XFILLER_0_68_128 VGND VGND VPWR VPWR sky130_fd_sc_hd__decap_8
XFILLER_0_76_161 VGND VGND VPWR VPWR sky130_fd_sc_hd__decap_4
XFILLER_0_9_461 VPWR VGND VPWR VGND sky130_ef_sc_hd__decap_12
XFILLER_0_32_253 VGND VGND VPWR VPWR sky130_fd_sc_hd__fill_1
XTAP_TAPCELL_ROW_63_708 VGND VPWR sky130_fd_sc_hd__tapvpwrvgnd_1
XFILLER_0_23_35 VGND VGND VPWR VPWR sky130_fd_sc_hd__fill_1
XFILLER_0_70_315 VGND VGND VPWR VPWR sky130_fd_sc_hd__fill_2
Xrebuffer2 _1831_ VGND VGND VPWR VPWR net37 sky130_fd_sc_hd__buf_6
X_2600_ RF0.regs\[10\]\[30\] _0619_ _0676_ RF0.regs\[25\]\[30\] VGND VGND VPWR VPWR
+ _0761_ sky130_fd_sc_hd__a22oi_4
X_3580_ RF0.regs\[15\]\[16\] _0610_ _0630_ RF0.regs\[10\]\[16\] VGND VGND VPWR VPWR
+ _1732_ sky130_fd_sc_hd__a22o_1
X_2531_ _0658_ _0691_ VGND VGND VPWR VPWR _0692_ sky130_fd_sc_hd__nand2_1
X_2462_ _0622_ VGND VGND VPWR VPWR _0623_ sky130_fd_sc_hd__buf_2
X_4201_ _2180_ VGND VGND VPWR VPWR _0278_ sky130_fd_sc_hd__clkbuf_1
X_2393_ _0571_ VGND VGND VPWR VPWR _0465_ sky130_fd_sc_hd__clkbuf_1
XFILLER_0_48_65 VPWR VGND VPWR VGND sky130_ef_sc_hd__decap_12
X_4132_ _1953_ RF0.regs\[25\]\[22\] _2134_ VGND VGND VPWR VPWR _2144_ sky130_fd_sc_hd__mux2_1
X_4063_ _2107_ VGND VGND VPWR VPWR _0343_ sky130_fd_sc_hd__clkbuf_1
X_3014_ RF0.regs\[10\]\[18\] _0969_ _0673_ RF0.regs\[25\]\[18\] VGND VGND VPWR VPWR
+ _1174_ sky130_fd_sc_hd__a22o_1
XFILLER_0_64_53 VPWR VGND VPWR VGND sky130_ef_sc_hd__decap_12
Xwire35 _0593_ VGND VGND VPWR VPWR net35 sky130_fd_sc_hd__clkbuf_2
XFILLER_0_80_41 VPWR VGND VPWR VGND sky130_ef_sc_hd__decap_12
XFILLER_0_58_150 VGND VGND VPWR VPWR sky130_fd_sc_hd__decap_3
XTAP_TAPCELL_ROW_34_465 VGND VPWR sky130_fd_sc_hd__tapvpwrvgnd_1
XFILLER_0_58_183 VGND VGND VPWR VPWR sky130_fd_sc_hd__decap_8
X_3916_ _1850_ RF0.regs\[10\]\[27\] _2024_ VGND VGND VPWR VPWR _2029_ sky130_fd_sc_hd__mux2_1
XFILLER_0_80_85 VGND VGND VPWR VPWR sky130_fd_sc_hd__decap_6
XFILLER_0_46_356 VGND VGND VPWR VPWR sky130_fd_sc_hd__fill_2
XFILLER_0_73_186 VGND VGND VPWR VPWR sky130_fd_sc_hd__fill_1
X_3847_ _1495_ _1979_ VGND VGND VPWR VPWR _1980_ sky130_fd_sc_hd__or2_1
XFILLER_0_6_475 VGND VGND VPWR VPWR sky130_fd_sc_hd__fill_1
X_3778_ _1749_ _1918_ VGND VGND VPWR VPWR _1919_ sky130_fd_sc_hd__and2_1
XFILLER_0_14_253 VPWR VGND VPWR VGND sky130_ef_sc_hd__decap_12
X_2729_ _0852_ _0856_ _0886_ _0888_ _0889_ VGND VGND VPWR VPWR _0890_ sky130_fd_sc_hd__o311a_1
XFILLER_0_10_481 VGND VGND VPWR VPWR sky130_fd_sc_hd__fill_1
XPHY_EDGE_ROW_29_Right_29 VGND VGND VPWR VPWR sky130_fd_sc_hd__decap_3
XFILLER_0_77_481 VGND VGND VPWR VPWR sky130_fd_sc_hd__fill_1
XFILLER_0_49_183 VGND VGND VPWR VPWR sky130_fd_sc_hd__decap_3
XFILLER_0_64_120 VPWR VGND VPWR VGND sky130_ef_sc_hd__decap_12
XFILLER_0_64_153 VGND VGND VPWR VPWR sky130_fd_sc_hd__decap_3
XPHY_EDGE_ROW_38_Right_38 VGND VGND VPWR VPWR sky130_fd_sc_hd__decap_3
XFILLER_0_64_186 VGND VGND VPWR VPWR sky130_fd_sc_hd__fill_1
XFILLER_0_20_245 VGND VGND VPWR VPWR sky130_fd_sc_hd__fill_2
XFILLER_0_20_289 VGND VGND VPWR VPWR sky130_fd_sc_hd__decap_6
XPHY_EDGE_ROW_47_Right_47 VGND VGND VPWR VPWR sky130_fd_sc_hd__decap_3
XTAP_TAPCELL_ROW_76_822 VGND VPWR sky130_fd_sc_hd__tapvpwrvgnd_1
XFILLER_0_34_78 VGND VGND VPWR VPWR sky130_fd_sc_hd__decap_3
XFILLER_0_68_481 VGND VGND VPWR VPWR sky130_fd_sc_hd__fill_1
XFILLER_0_7_206 VPWR VGND VPWR VGND sky130_ef_sc_hd__decap_12
XFILLER_0_28_334 VGND VGND VPWR VPWR sky130_fd_sc_hd__fill_2
X_4750_ clknet_leaf_3_clk _0400_ _0144_ VGND VGND VPWR VPWR RF0.regs\[10\]\[16\] sky130_fd_sc_hd__dfrtp_4
XPHY_EDGE_ROW_56_Right_56 VGND VGND VPWR VPWR sky130_fd_sc_hd__decap_3
XFILLER_0_28_389 VGND VGND VPWR VPWR sky130_fd_sc_hd__decap_4
X_4681_ clknet_leaf_2_clk _0331_ _0075_ VGND VGND VPWR VPWR RF0.regs\[20\]\[11\] sky130_fd_sc_hd__dfrtp_1
X_3701_ _1846_ VGND VGND VPWR VPWR _0444_ sky130_fd_sc_hd__clkbuf_1
X_3632_ _1034_ _1782_ VGND VGND VPWR VPWR _1783_ sky130_fd_sc_hd__or2_1
XFILLER_0_50_77 VGND VGND VPWR VPWR sky130_fd_sc_hd__fill_1
XFILLER_0_70_178 VGND VGND VPWR VPWR sky130_fd_sc_hd__decap_8
X_3563_ RF0.regs\[20\]\[17\] _0626_ _1091_ RF0.regs\[25\]\[17\] _1715_ VGND VGND VPWR
+ VPWR _1716_ sky130_fd_sc_hd__a221o_1
X_3494_ _0875_ _1649_ VGND VGND VPWR VPWR _1650_ sky130_fd_sc_hd__xnor2_1
XFILLER_0_59_75 VGND VGND VPWR VPWR sky130_fd_sc_hd__fill_1
X_2514_ _0674_ VGND VGND VPWR VPWR _0675_ sky130_fd_sc_hd__buf_2
X_2445_ net69 net39 VGND VGND VPWR VPWR _0606_ sky130_fd_sc_hd__nand2_4
XFILLER_0_11_278 VGND VGND VPWR VPWR sky130_fd_sc_hd__fill_2
XPHY_EDGE_ROW_65_Right_65 VGND VGND VPWR VPWR sky130_fd_sc_hd__decap_3
X_4115_ _2135_ VGND VGND VPWR VPWR _0319_ sky130_fd_sc_hd__clkbuf_1
X_2376_ net102 VGND VGND VPWR VPWR _0563_ sky130_fd_sc_hd__clkbuf_1
X_4046_ RF0.regs\[20\]\[31\] _1833_ _2098_ VGND VGND VPWR VPWR _2099_ sky130_fd_sc_hd__mux2_4
XPHY_EDGE_ROW_74_Right_74 VGND VGND VPWR VPWR sky130_fd_sc_hd__decap_3
XFILLER_0_19_334 VGND VGND VPWR VPWR sky130_fd_sc_hd__fill_2
XFILLER_0_19_367 VGND VGND VPWR VPWR sky130_fd_sc_hd__decap_8
XFILLER_0_19_389 VGND VGND VPWR VPWR sky130_fd_sc_hd__decap_3
XTAP_TAPCELL_ROW_2_193 VGND VPWR sky130_fd_sc_hd__tapvpwrvgnd_1
XFILLER_0_69_267 VGND VGND VPWR VPWR sky130_fd_sc_hd__decap_6
XFILLER_0_65_473 VGND VGND VPWR VPWR sky130_fd_sc_hd__decap_8
XFILLER_0_80_421 VPWR VGND VPWR VGND sky130_ef_sc_hd__decap_12
XFILLER_0_52_145 VGND VGND VPWR VPWR sky130_fd_sc_hd__decap_8
XFILLER_0_48_418 VGND VGND VPWR VPWR sky130_fd_sc_hd__fill_2
XFILLER_0_0_57 VPWR VGND VPWR VGND sky130_ef_sc_hd__decap_12
X_4802_ clknet_leaf_18_clk _0452_ _0196_ VGND VGND VPWR VPWR RF0.regs\[0\]\[4\] sky130_fd_sc_hd__dfrtp_1
X_2994_ _1153_ VGND VGND VPWR VPWR _1154_ sky130_fd_sc_hd__buf_2
X_4733_ clknet_leaf_8_clk _0383_ _0127_ VGND VGND VPWR VPWR RF0.regs\[15\]\[31\] sky130_fd_sc_hd__dfrtp_1
XFILLER_0_9_77 VGND VGND VPWR VPWR sky130_fd_sc_hd__decap_6
XFILLER_0_9_55 VGND VGND VPWR VPWR sky130_fd_sc_hd__fill_1
XFILLER_0_43_167 VGND VGND VPWR VPWR sky130_fd_sc_hd__fill_1
X_4664_ clknet_leaf_12_clk _0314_ _0058_ VGND VGND VPWR VPWR RF0.regs\[25\]\[26\]
+ sky130_fd_sc_hd__dfrtp_1
X_4595_ _2286_ VGND VGND VPWR VPWR _0245_ sky130_fd_sc_hd__inv_2
X_3615_ _1755_ _1756_ _1765_ VGND VGND VPWR VPWR _1766_ sky130_fd_sc_hd__mux2_4
X_3546_ _0651_ _1698_ _1699_ _1202_ _1316_ VGND VGND VPWR VPWR _1700_ sky130_fd_sc_hd__a32o_1
X_3477_ _0651_ _1631_ _1632_ VGND VGND VPWR VPWR _1633_ sky130_fd_sc_hd__a21oi_1
XFILLER_0_50_3 VPWR VGND VPWR VGND sky130_ef_sc_hd__decap_12
X_2428_ IM0.addr\[13\] IM0.addr\[10\] IM0.addr\[11\] IM0.addr\[12\] VGND VGND VPWR
+ VPWR _0589_ sky130_fd_sc_hd__or4_4
X_2359_ _0554_ VGND VGND VPWR VPWR _0482_ sky130_fd_sc_hd__clkbuf_1
X_4029_ _2088_ VGND VGND VPWR VPWR _0358_ sky130_fd_sc_hd__clkbuf_1
XFILLER_0_81_218 VGND VGND VPWR VPWR sky130_fd_sc_hd__decap_6
XFILLER_0_22_307 VGND VGND VPWR VPWR sky130_fd_sc_hd__fill_1
XFILLER_0_22_329 VGND VGND VPWR VPWR sky130_fd_sc_hd__fill_1
XFILLER_0_57_259 VGND VGND VPWR VPWR sky130_fd_sc_hd__fill_1
XFILLER_0_31_57 VPWR VGND VPWR VGND sky130_ef_sc_hd__decap_12
XFILLER_0_53_432 VGND VGND VPWR VPWR sky130_fd_sc_hd__fill_2
XFILLER_0_53_443 VGND VGND VPWR VPWR sky130_fd_sc_hd__decap_4
XFILLER_0_65_281 VGND VGND VPWR VPWR sky130_fd_sc_hd__decap_3
XTAP_TAPCELL_ROW_13_287 VGND VPWR sky130_fd_sc_hd__tapvpwrvgnd_1
X_4380_ _2253_ VGND VGND VPWR VPWR _2257_ sky130_fd_sc_hd__clkbuf_2
X_3400_ _0841_ _0847_ _0890_ VGND VGND VPWR VPWR _1557_ sky130_fd_sc_hd__nor3_2
X_3331_ _0837_ _0894_ _0917_ VGND VGND VPWR VPWR _1489_ sky130_fd_sc_hd__a21o_1
X_3262_ _1001_ _1417_ _1419_ VGND VGND VPWR VPWR _1420_ sky130_fd_sc_hd__o21a_1
X_3193_ _1204_ _1348_ _1351_ _1001_ VGND VGND VPWR VPWR _1352_ sky130_fd_sc_hd__o22a_1
XFILLER_0_56_76 VGND VGND VPWR VPWR sky130_fd_sc_hd__decap_8
XFILLER_0_72_53 VPWR VGND VPWR VGND sky130_ef_sc_hd__decap_12
XFILLER_0_72_97 VPWR VGND VPWR VGND sky130_ef_sc_hd__decap_12
X_2977_ _1059_ _1133_ _1136_ VGND VGND VPWR VPWR _1137_ sky130_fd_sc_hd__a21oi_1
XFILLER_0_16_134 VGND VGND VPWR VPWR sky130_fd_sc_hd__decap_3
X_4716_ clknet_leaf_1_clk _0366_ _0110_ VGND VGND VPWR VPWR RF0.regs\[15\]\[14\] sky130_fd_sc_hd__dfrtp_1
XFILLER_0_16_189 VGND VGND VPWR VPWR sky130_fd_sc_hd__decap_6
X_4647_ clknet_leaf_22_clk _0297_ _0041_ VGND VGND VPWR VPWR RF0.regs\[25\]\[9\] sky130_fd_sc_hd__dfrtp_4
XFILLER_0_12_373 VPWR VGND VPWR VGND sky130_ef_sc_hd__decap_12
X_4578_ _2280_ VGND VGND VPWR VPWR _2285_ sky130_fd_sc_hd__buf_4
X_3529_ _0713_ _1151_ _1346_ _1682_ _1095_ VGND VGND VPWR VPWR _1683_ sky130_fd_sc_hd__o32a_1
XTAP_TAPCELL_ROW_4_211 VGND VPWR sky130_fd_sc_hd__tapvpwrvgnd_1
XFILLER_0_79_340 VGND VGND VPWR VPWR sky130_fd_sc_hd__decap_6
XFILLER_0_79_373 VPWR VGND VPWR VGND sky130_ef_sc_hd__decap_12
XFILLER_0_39_204 VGND VGND VPWR VPWR sky130_fd_sc_hd__decap_6
XTAP_TAPCELL_ROW_55_644 VGND VPWR sky130_fd_sc_hd__tapvpwrvgnd_1
XFILLER_0_54_207 VGND VGND VPWR VPWR sky130_fd_sc_hd__fill_1
XFILLER_0_47_281 VGND VGND VPWR VPWR sky130_fd_sc_hd__decap_8
XFILLER_0_35_443 VGND VGND VPWR VPWR sky130_fd_sc_hd__fill_2
XFILLER_0_62_251 VGND VGND VPWR VPWR sky130_fd_sc_hd__fill_1
XTAP_TAPCELL_ROW_10_257 VGND VPWR sky130_fd_sc_hd__tapvpwrvgnd_1
XFILLER_0_35_476 VGND VGND VPWR VPWR sky130_fd_sc_hd__fill_2
Xhold80 RF0.regs\[0\]\[6\] VGND VGND VPWR VPWR net115 sky130_fd_sc_hd__dlygate4sd3_1
Xhold91 RF0.regs\[20\]\[18\] VGND VGND VPWR VPWR net126 sky130_fd_sc_hd__dlygate4sd3_1
X_2900_ _0514_ _0650_ _0658_ _0714_ VGND VGND VPWR VPWR _1061_ sky130_fd_sc_hd__a22oi_4
X_3880_ _2005_ RF0.regs\[5\]\[8\] _1994_ VGND VGND VPWR VPWR _2006_ sky130_fd_sc_hd__mux2_1
X_2831_ _0766_ _0989_ _0991_ VGND VGND VPWR VPWR _0992_ sky130_fd_sc_hd__a21oi_2
X_2762_ net33 _0898_ _0922_ VGND VGND VPWR VPWR _0923_ sky130_fd_sc_hd__o21ai_1
XFILLER_0_13_104 VGND VGND VPWR VPWR sky130_fd_sc_hd__decap_8
X_4501_ _2275_ VGND VGND VPWR VPWR _0162_ sky130_fd_sc_hd__inv_2
XFILLER_0_41_402 VPWR VGND VPWR VGND sky130_ef_sc_hd__decap_12
XFILLER_0_13_126 VGND VGND VPWR VPWR sky130_fd_sc_hd__decap_8
X_2693_ _0658_ _0842_ _0853_ _0717_ VGND VGND VPWR VPWR _0854_ sky130_fd_sc_hd__a31o_1
X_4432_ _2263_ VGND VGND VPWR VPWR _2265_ sky130_fd_sc_hd__buf_4
XFILLER_0_21_181 VGND VGND VPWR VPWR sky130_fd_sc_hd__decap_3
X_4363_ _2255_ VGND VGND VPWR VPWR _0044_ sky130_fd_sc_hd__inv_2
X_3314_ RF0.regs\[20\]\[20\] _0625_ _0610_ RF0.regs\[15\]\[20\] _1471_ VGND VGND VPWR
+ VPWR _1472_ sky130_fd_sc_hd__a221o_1
X_4294_ _1040_ _1021_ VGND VGND VPWR VPWR _2235_ sky130_fd_sc_hd__nor2_1
X_3245_ _0653_ _1384_ _1353_ _1403_ VGND VGND VPWR VPWR net17 sky130_fd_sc_hd__a31o_1
X_3176_ _1005_ _1017_ _1073_ VGND VGND VPWR VPWR _1335_ sky130_fd_sc_hd__mux2_1
Xrebuffer12 _1759_ VGND VGND VPWR VPWR net47 sky130_fd_sc_hd__dlymetal6s2s_1
XPHY_EDGE_ROW_16_Left_98 VGND VGND VPWR VPWR sky130_fd_sc_hd__decap_3
XFILLER_0_13_3 VGND VGND VPWR VPWR sky130_fd_sc_hd__decap_4
XFILLER_0_76_321 VPWR VGND VPWR VGND sky130_ef_sc_hd__decap_12
XTAP_TAPCELL_ROW_52_614 VGND VPWR sky130_fd_sc_hd__tapvpwrvgnd_1
XFILLER_0_32_402 VPWR VGND VPWR VGND sky130_ef_sc_hd__decap_12
XFILLER_0_32_435 VPWR VGND VPWR VGND sky130_ef_sc_hd__decap_12
XFILLER_0_67_310 VGND VGND VPWR VPWR sky130_fd_sc_hd__decap_4
XTAP_TAPCELL_ROW_15_305 VGND VPWR sky130_fd_sc_hd__tapvpwrvgnd_1
XFILLER_0_12_26 VGND VGND VPWR VPWR sky130_fd_sc_hd__fill_2
XTAP_TAPCELL_ROW_23_371 VGND VPWR sky130_fd_sc_hd__tapvpwrvgnd_1
XFILLER_0_2_307 VGND VGND VPWR VPWR sky130_fd_sc_hd__fill_1
XFILLER_0_50_265 VGND VGND VPWR VPWR sky130_fd_sc_hd__decap_3
XFILLER_0_50_276 VGND VGND VPWR VPWR sky130_fd_sc_hd__fill_1
Xoutput2 net2 VGND VGND VPWR VPWR Result[10] sky130_fd_sc_hd__buf_2
X_3030_ _1076_ _1189_ VGND VGND VPWR VPWR _1190_ sky130_fd_sc_hd__or2_1
XTAP_TAPCELL_ROW_66_739 VGND VPWR sky130_fd_sc_hd__tapvpwrvgnd_1
XFILLER_0_53_66 VGND VGND VPWR VPWR sky130_fd_sc_hd__fill_1
X_3932_ _2037_ VGND VGND VPWR VPWR _0404_ sky130_fd_sc_hd__clkbuf_1
X_3863_ _1707_ _1705_ _1896_ _1905_ VGND VGND VPWR VPWR _1992_ sky130_fd_sc_hd__a31o_1
X_2814_ _0801_ _0974_ _0802_ VGND VGND VPWR VPWR _0975_ sky130_fd_sc_hd__o21ai_1
X_3794_ _1136_ VGND VGND VPWR VPWR _1935_ sky130_fd_sc_hd__buf_2
XFILLER_0_14_457 VPWR VGND VPWR VGND sky130_ef_sc_hd__decap_12
XFILLER_0_5_178 VGND VGND VPWR VPWR sky130_fd_sc_hd__decap_8
XFILLER_0_5_167 VGND VGND VPWR VPWR sky130_fd_sc_hd__fill_1
X_2745_ _0899_ _0905_ VGND VGND VPWR VPWR _0906_ sky130_fd_sc_hd__or2_1
XFILLER_0_78_41 VPWR VGND VPWR VGND sky130_ef_sc_hd__decap_12
X_2676_ _0812_ _0819_ _0833_ _0836_ VGND VGND VPWR VPWR _0837_ sky130_fd_sc_hd__a31oi_2
XFILLER_0_41_298 VGND VGND VPWR VPWR sky130_fd_sc_hd__fill_2
X_4415_ _2261_ VGND VGND VPWR VPWR _0090_ sky130_fd_sc_hd__inv_2
X_4346_ _2252_ VGND VGND VPWR VPWR _0030_ sky130_fd_sc_hd__inv_2
X_4277_ _1935_ _2221_ VGND VGND VPWR VPWR _2222_ sky130_fd_sc_hd__nor2_1
X_3228_ _1286_ _1113_ _1074_ VGND VGND VPWR VPWR _1387_ sky130_fd_sc_hd__mux2_1
XTAP_TAPCELL_ROW_29_419 VGND VPWR sky130_fd_sc_hd__tapvpwrvgnd_1
X_3159_ _1254_ _1250_ _1048_ VGND VGND VPWR VPWR _1318_ sky130_fd_sc_hd__mux2_1
XFILLER_0_76_195 VGND VGND VPWR VPWR sky130_fd_sc_hd__fill_1
XFILLER_0_76_184 VGND VGND VPWR VPWR sky130_fd_sc_hd__fill_2
XFILLER_0_9_473 VGND VGND VPWR VPWR sky130_fd_sc_hd__decap_8
XFILLER_0_2_3 VPWR VGND VPWR VGND sky130_ef_sc_hd__decap_12
XTAP_TAPCELL_ROW_63_709 VGND VPWR sky130_fd_sc_hd__tapvpwrvgnd_1
XFILLER_0_59_129 VGND VGND VPWR VPWR sky130_fd_sc_hd__decap_8
Xclkbuf_leaf_25_clk clknet_1_0__leaf_clk VGND VGND VPWR VPWR clknet_leaf_25_clk sky130_fd_sc_hd__clkbuf_8
XFILLER_0_23_69 VGND VGND VPWR VPWR sky130_fd_sc_hd__fill_1
XFILLER_0_55_324 VPWR VGND VPWR VGND sky130_ef_sc_hd__decap_12
XFILLER_0_67_195 VGND VGND VPWR VPWR sky130_fd_sc_hd__decap_4
XFILLER_0_55_379 VPWR VGND VPWR VGND sky130_ef_sc_hd__decap_12
Xrebuffer3 IM0.addr\[9\] VGND VGND VPWR VPWR net38 sky130_fd_sc_hd__dlygate4sd1_1
XFILLER_0_23_221 VGND VGND VPWR VPWR sky130_fd_sc_hd__decap_3
XFILLER_0_63_390 VGND VGND VPWR VPWR sky130_fd_sc_hd__fill_2
XFILLER_0_70_338 VGND VGND VPWR VPWR sky130_fd_sc_hd__fill_1
XFILLER_0_70_349 VPWR VGND VPWR VGND sky130_ef_sc_hd__decap_12
X_2530_ RF0.regs\[15\]\[21\] _0664_ _0672_ RF0.regs\[5\]\[21\] VGND VGND VPWR VPWR
+ _0691_ sky130_fd_sc_hd__a22o_1
X_2461_ _0621_ VGND VGND VPWR VPWR _0622_ sky130_fd_sc_hd__clkbuf_2
XFILLER_0_11_449 VPWR VGND VPWR VGND sky130_ef_sc_hd__decap_12
X_4200_ _1953_ net146 _2170_ VGND VGND VPWR VPWR _2180_ sky130_fd_sc_hd__mux2_1
X_2392_ net116 VGND VGND VPWR VPWR _0571_ sky130_fd_sc_hd__clkbuf_1
XFILLER_0_48_77 VGND VGND VPWR VPWR sky130_fd_sc_hd__decap_6
X_4131_ _2143_ VGND VGND VPWR VPWR _0311_ sky130_fd_sc_hd__clkbuf_1
X_4062_ net129 _1951_ _2098_ VGND VGND VPWR VPWR _2107_ sky130_fd_sc_hd__mux2_1
X_3013_ _1169_ _1172_ _1011_ VGND VGND VPWR VPWR _1173_ sky130_fd_sc_hd__mux2_1
XFILLER_0_64_65 VGND VGND VPWR VPWR sky130_fd_sc_hd__decap_8
Xclkbuf_leaf_16_clk clknet_1_1__leaf_clk VGND VGND VPWR VPWR clknet_leaf_16_clk sky130_fd_sc_hd__clkbuf_8
XFILLER_0_80_53 VPWR VGND VPWR VGND sky130_ef_sc_hd__decap_12
X_3915_ _2028_ VGND VGND VPWR VPWR _0412_ sky130_fd_sc_hd__clkbuf_1
XTAP_TAPCELL_ROW_34_466 VGND VPWR sky130_fd_sc_hd__tapvpwrvgnd_1
XFILLER_0_46_368 VGND VGND VPWR VPWR sky130_fd_sc_hd__fill_1
XFILLER_0_58_195 VGND VGND VPWR VPWR sky130_fd_sc_hd__fill_1
XFILLER_0_6_421 VPWR VGND VPWR VGND sky130_ef_sc_hd__decap_12
X_3846_ _1546_ _1978_ _1506_ VGND VGND VPWR VPWR _1979_ sky130_fd_sc_hd__o21ba_1
XFILLER_0_80_3 VPWR VGND VPWR VGND sky130_ef_sc_hd__decap_12
X_3777_ _1509_ _1865_ _1909_ _1917_ _1503_ VGND VGND VPWR VPWR _1918_ sky130_fd_sc_hd__a32o_1
XFILLER_0_54_390 VGND VGND VPWR VPWR sky130_fd_sc_hd__decap_8
XFILLER_0_14_265 VGND VGND VPWR VPWR sky130_fd_sc_hd__decap_6
X_2728_ _0844_ _0845_ VGND VGND VPWR VPWR _0889_ sky130_fd_sc_hd__nand2_1
X_2659_ _0732_ _0730_ _0729_ VGND VGND VPWR VPWR _0820_ sky130_fd_sc_hd__or3_4
X_4329_ _2250_ VGND VGND VPWR VPWR _0015_ sky130_fd_sc_hd__inv_2
XFILLER_0_69_449 VPWR VGND VPWR VGND sky130_ef_sc_hd__decap_12
XFILLER_0_37_335 VGND VGND VPWR VPWR sky130_fd_sc_hd__fill_1
XFILLER_0_37_346 VGND VGND VPWR VPWR sky130_fd_sc_hd__decap_8
XFILLER_0_64_132 VGND VGND VPWR VPWR sky130_fd_sc_hd__decap_3
XFILLER_0_9_281 VGND VGND VPWR VPWR sky130_fd_sc_hd__decap_4
XFILLER_0_64_176 VGND VGND VPWR VPWR sky130_fd_sc_hd__decap_6
XFILLER_0_20_224 VGND VGND VPWR VPWR sky130_fd_sc_hd__fill_1
XTAP_TAPCELL_ROW_76_823 VGND VPWR sky130_fd_sc_hd__tapvpwrvgnd_1
XFILLER_0_28_302 VGND VGND VPWR VPWR sky130_fd_sc_hd__fill_1
XFILLER_0_55_110 VGND VGND VPWR VPWR sky130_fd_sc_hd__fill_2
X_3700_ _1845_ RF0.regs\[5\]\[28\] _1835_ VGND VGND VPWR VPWR _1846_ sky130_fd_sc_hd__mux2_1
XFILLER_0_7_218 VGND VGND VPWR VPWR sky130_fd_sc_hd__decap_6
X_4680_ clknet_leaf_2_clk _0330_ _0074_ VGND VGND VPWR VPWR RF0.regs\[20\]\[10\] sky130_fd_sc_hd__dfrtp_1
XTAP_TAPCELL_ROW_31_436 VGND VPWR sky130_fd_sc_hd__tapvpwrvgnd_1
XFILLER_0_43_305 VPWR VGND VPWR VGND sky130_ef_sc_hd__decap_12
X_3631_ _1138_ _1139_ _1439_ _1438_ _1047_ _1020_ VGND VGND VPWR VPWR _1782_ sky130_fd_sc_hd__mux4_1
X_3562_ RF0.regs\[15\]\[17\] _0610_ _0630_ RF0.regs\[10\]\[17\] VGND VGND VPWR VPWR
+ _1715_ sky130_fd_sc_hd__a22o_1
X_2513_ _0673_ VGND VGND VPWR VPWR _0674_ sky130_fd_sc_hd__clkbuf_4
X_3493_ _0878_ _1107_ VGND VGND VPWR VPWR _1649_ sky130_fd_sc_hd__xor2_1
X_2444_ _0604_ VGND VGND VPWR VPWR _0605_ sky130_fd_sc_hd__buf_4
Xclkbuf_leaf_5_clk clknet_1_1__leaf_clk VGND VGND VPWR VPWR clknet_leaf_5_clk sky130_fd_sc_hd__clkbuf_8
X_2375_ _0562_ VGND VGND VPWR VPWR _0474_ sky130_fd_sc_hd__clkbuf_1
X_4114_ _1833_ RF0.regs\[25\]\[31\] _2134_ VGND VGND VPWR VPWR _2135_ sky130_fd_sc_hd__mux2_4
X_4045_ _2097_ VGND VGND VPWR VPWR _2098_ sky130_fd_sc_hd__clkbuf_4
XFILLER_0_78_246 VGND VGND VPWR VPWR sky130_fd_sc_hd__decap_6
XFILLER_0_66_419 VGND VGND VPWR VPWR sky130_fd_sc_hd__fill_1
XFILLER_0_34_316 VGND VGND VPWR VPWR sky130_fd_sc_hd__decap_6
XFILLER_0_6_240 VGND VGND VPWR VPWR sky130_fd_sc_hd__decap_3
XFILLER_0_27_390 VGND VGND VPWR VPWR sky130_fd_sc_hd__fill_2
X_3829_ _1965_ RF0.regs\[5\]\[19\] _1957_ VGND VGND VPWR VPWR _1966_ sky130_fd_sc_hd__mux2_1
XTAP_TAPCELL_ROW_2_194 VGND VPWR sky130_fd_sc_hd__tapvpwrvgnd_1
XTAP_TAPCELL_ROW_81_870 VGND VPWR sky130_fd_sc_hd__tapvpwrvgnd_1
XPHY_EDGE_ROW_4_Left_86 VGND VGND VPWR VPWR sky130_fd_sc_hd__decap_3
XFILLER_0_80_400 VPWR VGND VPWR VGND sky130_ef_sc_hd__decap_12
XFILLER_0_25_316 VGND VGND VPWR VPWR sky130_fd_sc_hd__decap_6
XFILLER_0_80_433 VPWR VGND VPWR VGND sky130_ef_sc_hd__decap_12
XFILLER_0_20_15 VPWR VGND VPWR VGND sky130_ef_sc_hd__decap_12
XFILLER_0_80_477 VGND VGND VPWR VPWR sky130_fd_sc_hd__decap_4
XFILLER_0_33_371 VPWR VGND VPWR VGND sky130_ef_sc_hd__decap_12
XFILLER_0_0_405 VPWR VGND VPWR VGND sky130_ef_sc_hd__decap_12
XFILLER_0_60_190 VGND VGND VPWR VPWR sky130_fd_sc_hd__decap_6
XFILLER_0_0_449 VPWR VGND VPWR VGND sky130_ef_sc_hd__decap_12
XTAP_TAPCELL_ROW_44_550 VGND VPWR sky130_fd_sc_hd__tapvpwrvgnd_1
XFILLER_0_75_238 VGND VGND VPWR VPWR sky130_fd_sc_hd__decap_6
XFILLER_0_0_69 VPWR VGND VPWR VGND sky130_ef_sc_hd__decap_12
X_4801_ clknet_leaf_18_clk _0451_ _0195_ VGND VGND VPWR VPWR RF0.regs\[0\]\[3\] sky130_fd_sc_hd__dfrtp_1
X_2993_ _0713_ _1101_ VGND VGND VPWR VPWR _1153_ sky130_fd_sc_hd__nor2_1
XFILLER_0_28_121 VGND VGND VPWR VPWR sky130_fd_sc_hd__decap_8
XFILLER_0_28_132 VGND VGND VPWR VPWR sky130_fd_sc_hd__decap_3
XFILLER_0_61_55 VGND VGND VPWR VPWR sky130_fd_sc_hd__fill_1
X_4732_ clknet_leaf_8_clk _0382_ _0126_ VGND VGND VPWR VPWR RF0.regs\[15\]\[30\] sky130_fd_sc_hd__dfrtp_1
XFILLER_0_28_176 VGND VGND VPWR VPWR sky130_fd_sc_hd__decap_8
X_4663_ clknet_leaf_12_clk _0313_ _0057_ VGND VGND VPWR VPWR RF0.regs\[25\]\[25\]
+ sky130_fd_sc_hd__dfrtp_1
XFILLER_0_43_146 VGND VGND VPWR VPWR sky130_fd_sc_hd__fill_2
X_3614_ _1096_ _1760_ _1761_ _1762_ _1764_ VGND VGND VPWR VPWR _1765_ sky130_fd_sc_hd__o32a_4
X_4594_ _2286_ VGND VGND VPWR VPWR _0244_ sky130_fd_sc_hd__inv_2
X_3545_ net43 _0840_ _1557_ VGND VGND VPWR VPWR _1699_ sky130_fd_sc_hd__or3_1
X_3476_ _1037_ _1202_ _1164_ VGND VGND VPWR VPWR _1632_ sky130_fd_sc_hd__and3_1
X_2427_ _0588_ VGND VGND VPWR VPWR _0448_ sky130_fd_sc_hd__clkbuf_1
XFILLER_0_43_3 VPWR VGND VPWR VGND sky130_ef_sc_hd__decap_12
X_2358_ _0515_ _0553_ VGND VGND VPWR VPWR _0554_ sky130_fd_sc_hd__and2b_1
X_2289_ IM0.addr\[0\] VGND VGND VPWR VPWR _0514_ sky130_fd_sc_hd__clkbuf_4
X_4028_ _2009_ RF0.regs\[15\]\[6\] _2082_ VGND VGND VPWR VPWR _2088_ sky130_fd_sc_hd__mux2_1
XTAP_TAPCELL_ROW_50_597 VGND VPWR sky130_fd_sc_hd__tapvpwrvgnd_1
XFILLER_0_62_477 VGND VGND VPWR VPWR sky130_fd_sc_hd__decap_4
XFILLER_0_42_190 VGND VGND VPWR VPWR sky130_fd_sc_hd__fill_2
XFILLER_0_30_352 VGND VGND VPWR VPWR sky130_fd_sc_hd__fill_1
XFILLER_0_25_113 VGND VGND VPWR VPWR sky130_fd_sc_hd__decap_4
XTAP_TAPCELL_ROW_13_288 VGND VPWR sky130_fd_sc_hd__tapvpwrvgnd_1
XFILLER_0_31_69 VGND VGND VPWR VPWR sky130_fd_sc_hd__fill_2
X_3330_ _0908_ _1168_ VGND VGND VPWR VPWR _1488_ sky130_fd_sc_hd__or2b_1
X_3261_ _1418_ _1154_ _1203_ VGND VGND VPWR VPWR _1419_ sky130_fd_sc_hd__a21o_1
X_3192_ _1349_ _1350_ _1135_ VGND VGND VPWR VPWR _1351_ sky130_fd_sc_hd__mux2_1
XFILLER_0_72_65 VGND VGND VPWR VPWR sky130_fd_sc_hd__decap_8
XFILLER_0_8_313 VGND VGND VPWR VPWR sky130_fd_sc_hd__fill_1
X_2976_ _1135_ VGND VGND VPWR VPWR _1136_ sky130_fd_sc_hd__buf_2
X_4715_ clknet_leaf_2_clk _0365_ _0109_ VGND VGND VPWR VPWR RF0.regs\[15\]\[13\] sky130_fd_sc_hd__dfrtp_1
X_4646_ clknet_leaf_22_clk _0296_ _0040_ VGND VGND VPWR VPWR RF0.regs\[25\]\[8\] sky130_fd_sc_hd__dfrtp_1
XFILLER_0_44_477 VGND VGND VPWR VPWR sky130_fd_sc_hd__fill_1
XFILLER_0_71_285 VGND VGND VPWR VPWR sky130_fd_sc_hd__fill_1
X_4577_ _2284_ VGND VGND VPWR VPWR _0229_ sky130_fd_sc_hd__inv_2
XFILLER_0_24_190 VGND VGND VPWR VPWR sky130_fd_sc_hd__decap_6
XFILLER_0_12_363 VGND VGND VPWR VPWR sky130_fd_sc_hd__fill_1
X_3528_ _0867_ _1681_ VGND VGND VPWR VPWR _1682_ sky130_fd_sc_hd__nor2_1
XFILLER_0_12_385 VGND VGND VPWR VPWR sky130_fd_sc_hd__decap_8
X_3459_ RF0.regs\[15\]\[5\] _0609_ _0616_ RF0.regs\[25\]\[5\] VGND VGND VPWR VPWR
+ _1615_ sky130_fd_sc_hd__a22o_1
XTAP_TAPCELL_ROW_4_212 VGND VPWR sky130_fd_sc_hd__tapvpwrvgnd_1
XFILLER_0_79_385 VGND VGND VPWR VPWR sky130_fd_sc_hd__decap_6
XTAP_TAPCELL_ROW_55_645 VGND VPWR sky130_fd_sc_hd__tapvpwrvgnd_1
XTAP_TAPCELL_ROW_10_258 VGND VPWR sky130_fd_sc_hd__tapvpwrvgnd_1
XFILLER_0_7_390 VGND VGND VPWR VPWR sky130_fd_sc_hd__fill_2
XFILLER_0_50_403 VGND VGND VPWR VPWR sky130_fd_sc_hd__fill_1
XFILLER_0_62_285 VGND VGND VPWR VPWR sky130_fd_sc_hd__fill_1
XFILLER_0_50_436 VGND VGND VPWR VPWR sky130_fd_sc_hd__decap_8
Xhold70 RF0.regs\[0\]\[1\] VGND VGND VPWR VPWR net105 sky130_fd_sc_hd__dlygate4sd3_1
Xhold92 RF0.regs\[20\]\[4\] VGND VGND VPWR VPWR net127 sky130_fd_sc_hd__dlygate4sd3_1
Xhold81 RF0.regs\[0\]\[17\] VGND VGND VPWR VPWR net116 sky130_fd_sc_hd__dlygate4sd3_1
XTAP_TAPCELL_ROW_18_325 VGND VPWR sky130_fd_sc_hd__tapvpwrvgnd_1
XFILLER_0_26_58 VGND VGND VPWR VPWR sky130_fd_sc_hd__decap_8
X_2830_ _0762_ _0990_ VGND VGND VPWR VPWR _0991_ sky130_fd_sc_hd__or2_1
X_2761_ _0903_ _0904_ VGND VGND VPWR VPWR _0922_ sky130_fd_sc_hd__nand2_1
X_4500_ _2275_ VGND VGND VPWR VPWR _0161_ sky130_fd_sc_hd__inv_2
X_2692_ _0724_ _0725_ VGND VGND VPWR VPWR _0853_ sky130_fd_sc_hd__nand2_1
XFILLER_0_26_477 VGND VGND VPWR VPWR sky130_fd_sc_hd__fill_1
XFILLER_0_41_414 VGND VGND VPWR VPWR sky130_fd_sc_hd__decap_4
XFILLER_0_53_285 VGND VGND VPWR VPWR sky130_fd_sc_hd__fill_1
X_4431_ _2264_ VGND VGND VPWR VPWR _0103_ sky130_fd_sc_hd__inv_2
XANTENNA_1 _0838_ VGND VGND VPWR VPWR sky130_fd_sc_hd__diode_2
XFILLER_0_41_447 VGND VGND VPWR VPWR sky130_fd_sc_hd__fill_1
X_4362_ _2255_ VGND VGND VPWR VPWR _0043_ sky130_fd_sc_hd__inv_2
XFILLER_0_6_68 VPWR VGND VPWR VGND sky130_ef_sc_hd__decap_12
X_3313_ RF0.regs\[5\]\[20\] _0633_ _0637_ RF0.regs\[30\]\[20\] _0640_ VGND VGND VPWR
+ VPWR _1471_ sky130_fd_sc_hd__a221o_1
X_4293_ _1935_ _1060_ VGND VGND VPWR VPWR _2234_ sky130_fd_sc_hd__nor2_1
X_3244_ _1001_ _1389_ _1394_ _1204_ _1402_ VGND VGND VPWR VPWR _1403_ sky130_fd_sc_hd__o32a_1
XTAP_TAPCELL_ROW_69_759 VGND VPWR sky130_fd_sc_hd__tapvpwrvgnd_1
X_3175_ _1053_ _1008_ _1073_ VGND VGND VPWR VPWR _1334_ sky130_fd_sc_hd__mux2_1
Xrebuffer13 net47 VGND VGND VPWR VPWR net48 sky130_fd_sc_hd__dlymetal6s2s_1
XFILLER_0_76_300 VGND VGND VPWR VPWR sky130_fd_sc_hd__decap_8
XFILLER_0_76_333 VGND VGND VPWR VPWR sky130_fd_sc_hd__decap_4
XTAP_TAPCELL_ROW_52_615 VGND VPWR sky130_fd_sc_hd__tapvpwrvgnd_1
X_2959_ RF0.regs\[10\]\[10\] _0616_ _0931_ RF0.regs\[25\]\[10\] VGND VGND VPWR VPWR
+ _1119_ sky130_fd_sc_hd__a22o_1
XFILLER_0_32_414 VGND VGND VPWR VPWR sky130_fd_sc_hd__decap_6
XFILLER_0_32_425 VGND VGND VPWR VPWR sky130_fd_sc_hd__fill_1
XFILLER_0_32_447 VGND VGND VPWR VPWR sky130_fd_sc_hd__decap_6
X_4629_ clknet_leaf_6_clk _0279_ _0023_ VGND VGND VPWR VPWR RF0.regs\[30\]\[23\] sky130_fd_sc_hd__dfrtp_1
XTAP_TAPCELL_ROW_15_306 VGND VPWR sky130_fd_sc_hd__tapvpwrvgnd_1
XFILLER_0_67_388 VGND VGND VPWR VPWR sky130_fd_sc_hd__decap_4
XTAP_TAPCELL_ROW_23_372 VGND VPWR sky130_fd_sc_hd__tapvpwrvgnd_1
XFILLER_0_35_263 VGND VGND VPWR VPWR sky130_fd_sc_hd__decap_6
Xoutput3 net3 VGND VGND VPWR VPWR Result[11] sky130_fd_sc_hd__buf_2
XFILLER_0_37_57 VGND VGND VPWR VPWR sky130_fd_sc_hd__decap_4
X_3931_ _1959_ RF0.regs\[10\]\[20\] _2035_ VGND VGND VPWR VPWR _2037_ sky130_fd_sc_hd__mux2_1
X_3862_ _1991_ VGND VGND VPWR VPWR _0428_ sky130_fd_sc_hd__clkbuf_1
X_2813_ _0795_ _0796_ VGND VGND VPWR VPWR _0974_ sky130_fd_sc_hd__and2_4
XFILLER_0_26_241 VGND VGND VPWR VPWR sky130_fd_sc_hd__fill_2
X_3793_ _1788_ _1864_ _1919_ _1933_ VGND VGND VPWR VPWR _1934_ sky130_fd_sc_hd__a31o_2
X_2744_ _0903_ _0904_ VGND VGND VPWR VPWR _0905_ sky130_fd_sc_hd__xnor2_1
XFILLER_0_14_469 VGND VGND VPWR VPWR sky130_fd_sc_hd__decap_6
X_2675_ _0811_ _0835_ _0807_ VGND VGND VPWR VPWR _0836_ sky130_fd_sc_hd__a21oi_1
XFILLER_0_78_53 VPWR VGND VPWR VGND sky130_ef_sc_hd__decap_12
X_4414_ _2261_ VGND VGND VPWR VPWR _0089_ sky130_fd_sc_hd__inv_2
X_4345_ _2252_ VGND VGND VPWR VPWR _0029_ sky130_fd_sc_hd__inv_2
XFILLER_0_1_385 VGND VGND VPWR VPWR sky130_fd_sc_hd__decap_6
X_4276_ _1056_ _1012_ _1059_ VGND VGND VPWR VPWR _2221_ sky130_fd_sc_hd__mux2_1
X_3227_ _1385_ VGND VGND VPWR VPWR _1386_ sky130_fd_sc_hd__inv_2
X_3158_ _1244_ _1249_ _1075_ VGND VGND VPWR VPWR _1317_ sky130_fd_sc_hd__mux2_1
X_3089_ _1182_ _1184_ _1042_ VGND VGND VPWR VPWR _1249_ sky130_fd_sc_hd__mux2_1
XTAP_TAPCELL_ROW_20_342 VGND VPWR sky130_fd_sc_hd__tapvpwrvgnd_1
XFILLER_0_32_222 VGND VGND VPWR VPWR sky130_fd_sc_hd__fill_1
XFILLER_0_20_417 VGND VGND VPWR VPWR sky130_fd_sc_hd__decap_3
XFILLER_0_59_119 VGND VGND VPWR VPWR sky130_fd_sc_hd__fill_2
XTAP_TAPCELL_ROW_71_776 VGND VPWR sky130_fd_sc_hd__tapvpwrvgnd_1
XFILLER_0_55_347 VPWR VGND VPWR VGND sky130_ef_sc_hd__decap_12
XFILLER_0_70_306 VGND VGND VPWR VPWR sky130_fd_sc_hd__fill_2
XFILLER_0_2_127 VGND VGND VPWR VPWR sky130_fd_sc_hd__fill_2
XFILLER_0_2_138 VGND VGND VPWR VPWR sky130_fd_sc_hd__fill_2
X_2460_ _0513_ _0514_ _0602_ VGND VGND VPWR VPWR _0621_ sky130_fd_sc_hd__and3_1
X_2391_ _0570_ VGND VGND VPWR VPWR _0466_ sky130_fd_sc_hd__clkbuf_1
X_4130_ _1951_ RF0.regs\[25\]\[23\] _2134_ VGND VGND VPWR VPWR _2143_ sky130_fd_sc_hd__mux2_1
XPHY_EDGE_ROW_79_Left_161 VGND VGND VPWR VPWR sky130_fd_sc_hd__decap_3
XFILLER_0_3_36 VPWR VGND VPWR VGND sky130_ef_sc_hd__decap_12
X_4061_ _2106_ VGND VGND VPWR VPWR _0344_ sky130_fd_sc_hd__clkbuf_1
X_3012_ _1170_ _1171_ _1052_ VGND VGND VPWR VPWR _1172_ sky130_fd_sc_hd__mux2_1
XFILLER_0_80_65 VPWR VGND VPWR VGND sky130_ef_sc_hd__decap_12
X_3914_ _1845_ RF0.regs\[10\]\[28\] _2024_ VGND VGND VPWR VPWR _2028_ sky130_fd_sc_hd__mux2_1
XTAP_TAPCELL_ROW_34_467 VGND VPWR sky130_fd_sc_hd__tapvpwrvgnd_1
XFILLER_0_46_303 VGND VGND VPWR VPWR sky130_fd_sc_hd__fill_1
XFILLER_0_80_98 VGND VGND VPWR VPWR sky130_fd_sc_hd__fill_2
XFILLER_0_46_336 VPWR VGND VPWR VGND sky130_ef_sc_hd__decap_12
XFILLER_0_13_92 VPWR VGND VPWR VGND sky130_ef_sc_hd__decap_12
XFILLER_0_6_433 VPWR VGND VPWR VGND sky130_ef_sc_hd__decap_12
X_3845_ _1712_ _1977_ VGND VGND VPWR VPWR _1978_ sky130_fd_sc_hd__nor2_1
XFILLER_0_6_477 VGND VGND VPWR VPWR sky130_fd_sc_hd__decap_4
X_3776_ _1487_ _1911_ _1499_ _1916_ VGND VGND VPWR VPWR _1917_ sky130_fd_sc_hd__a2bb2o_1
X_2727_ _0850_ _0887_ VGND VGND VPWR VPWR _0888_ sky130_fd_sc_hd__nand2_1
XFILLER_0_14_288 VGND VGND VPWR VPWR sky130_fd_sc_hd__decap_3
XFILLER_0_14_277 VGND VGND VPWR VPWR sky130_fd_sc_hd__decap_4
XFILLER_0_73_3 VPWR VGND VPWR VGND sky130_ef_sc_hd__decap_12
X_2658_ _0817_ _0818_ VGND VGND VPWR VPWR _0819_ sky130_fd_sc_hd__nor2_1
X_2589_ _0747_ _0694_ _0692_ _0749_ VGND VGND VPWR VPWR _0750_ sky130_fd_sc_hd__and4_1
X_4328_ _2250_ VGND VGND VPWR VPWR _0014_ sky130_fd_sc_hd__inv_2
X_4259_ _2211_ _1433_ VGND VGND VPWR VPWR _2212_ sky130_fd_sc_hd__nor2_1
XFILLER_0_77_461 VPWR VGND VPWR VGND sky130_ef_sc_hd__decap_12
XFILLER_0_49_163 VGND VGND VPWR VPWR sky130_fd_sc_hd__decap_4
XFILLER_0_64_111 VGND VGND VPWR VPWR sky130_fd_sc_hd__fill_1
XFILLER_0_52_306 VGND VGND VPWR VPWR sky130_fd_sc_hd__fill_2
XFILLER_0_60_383 VGND VGND VPWR VPWR sky130_fd_sc_hd__fill_1
XFILLER_0_18_26 VGND VGND VPWR VPWR sky130_fd_sc_hd__fill_2
XTAP_TAPCELL_ROW_76_824 VGND VPWR sky130_fd_sc_hd__tapvpwrvgnd_1
XTAP_TAPCELL_ROW_31_437 VGND VPWR sky130_fd_sc_hd__tapvpwrvgnd_1
XFILLER_0_43_317 VGND VGND VPWR VPWR sky130_fd_sc_hd__decap_4
X_3630_ _1034_ _1780_ VGND VGND VPWR VPWR _1781_ sky130_fd_sc_hd__nand2_1
XFILLER_0_70_136 VGND VGND VPWR VPWR sky130_fd_sc_hd__fill_1
X_3561_ RF0.regs\[5\]\[17\] _0634_ _0638_ RF0.regs\[30\]\[17\] _0641_ VGND VGND VPWR
+ VPWR _1714_ sky130_fd_sc_hd__a221o_1
XFILLER_0_11_214 VGND VGND VPWR VPWR sky130_fd_sc_hd__decap_6
XFILLER_0_11_203 VGND VGND VPWR VPWR sky130_fd_sc_hd__decap_3
XFILLER_0_51_383 VGND VGND VPWR VPWR sky130_fd_sc_hd__decap_8
X_2512_ _0672_ VGND VGND VPWR VPWR _0673_ sky130_fd_sc_hd__buf_4
XFILLER_0_11_225 VPWR VGND VPWR VGND sky130_ef_sc_hd__decap_12
X_3492_ _1153_ _1647_ VGND VGND VPWR VPWR _1648_ sky130_fd_sc_hd__and2_1
XFILLER_0_59_55 VGND VGND VPWR VPWR sky130_fd_sc_hd__fill_1
X_2443_ _0603_ VGND VGND VPWR VPWR _0604_ sky130_fd_sc_hd__clkbuf_4
X_2374_ net110 VGND VGND VPWR VPWR _0562_ sky130_fd_sc_hd__clkbuf_1
X_4113_ _2133_ VGND VGND VPWR VPWR _2134_ sky130_fd_sc_hd__clkbuf_4
XTAP_TAPCELL_ROW_39_504 VGND VPWR sky130_fd_sc_hd__tapvpwrvgnd_1
X_4044_ _0512_ _0627_ VGND VGND VPWR VPWR _2097_ sky130_fd_sc_hd__and2_2
XFILLER_0_74_475 VGND VGND VPWR VPWR sky130_fd_sc_hd__fill_1
X_3828_ _1766_ _1964_ VGND VGND VPWR VPWR _1965_ sky130_fd_sc_hd__xnor2_2
XFILLER_0_61_169 VGND VGND VPWR VPWR sky130_fd_sc_hd__fill_2
X_3759_ _1899_ VGND VGND VPWR VPWR _1900_ sky130_fd_sc_hd__inv_2
XTAP_TAPCELL_ROW_2_195 VGND VPWR sky130_fd_sc_hd__tapvpwrvgnd_1
XTAP_TAPCELL_ROW_81_871 VGND VPWR sky130_fd_sc_hd__tapvpwrvgnd_1
XFILLER_0_80_412 VGND VGND VPWR VPWR sky130_fd_sc_hd__decap_8
XFILLER_0_80_445 VPWR VGND VPWR VGND sky130_ef_sc_hd__decap_12
XFILLER_0_20_27 VGND VGND VPWR VPWR sky130_fd_sc_hd__fill_1
XFILLER_0_40_309 VGND VGND VPWR VPWR sky130_fd_sc_hd__fill_2
XFILLER_0_0_417 VGND VGND VPWR VPWR sky130_fd_sc_hd__decap_3
XFILLER_0_33_383 VGND VGND VPWR VPWR sky130_fd_sc_hd__decap_8
XFILLER_0_0_15 VPWR VGND VPWR VGND sky130_ef_sc_hd__decap_12
X_4800_ clknet_leaf_17_clk _0450_ _0194_ VGND VGND VPWR VPWR RF0.regs\[0\]\[2\] sky130_fd_sc_hd__dfrtp_1
X_2992_ _1151_ VGND VGND VPWR VPWR _1152_ sky130_fd_sc_hd__buf_2
XTAP_TAPCELL_ROW_44_551 VGND VPWR sky130_fd_sc_hd__tapvpwrvgnd_1
XFILLER_0_56_431 VGND VGND VPWR VPWR sky130_fd_sc_hd__fill_1
X_4731_ clknet_leaf_8_clk _0381_ _0125_ VGND VGND VPWR VPWR RF0.regs\[15\]\[29\] sky130_fd_sc_hd__dfrtp_1
X_4662_ clknet_leaf_11_clk _0312_ _0056_ VGND VGND VPWR VPWR RF0.regs\[25\]\[24\]
+ sky130_fd_sc_hd__dfrtp_1
XFILLER_0_9_46 VGND VGND VPWR VPWR sky130_fd_sc_hd__fill_2
X_3613_ _1038_ _1265_ _1763_ _1083_ VGND VGND VPWR VPWR _1764_ sky130_fd_sc_hd__o211a_1
X_4593_ _2286_ VGND VGND VPWR VPWR _0243_ sky130_fd_sc_hd__inv_2
XFILLER_0_43_169 VPWR VGND VPWR VGND sky130_ef_sc_hd__decap_12
X_3544_ _0840_ _1557_ net43 VGND VGND VPWR VPWR _1698_ sky130_fd_sc_hd__o21ai_1
X_3475_ _1630_ _0882_ VGND VGND VPWR VPWR _1631_ sky130_fd_sc_hd__xor2_1
X_2426_ net111 VGND VGND VPWR VPWR _0588_ sky130_fd_sc_hd__clkbuf_1
X_2357_ _0512_ _0513_ _0514_ IM0.addr\[2\] VGND VGND VPWR VPWR _0553_ sky130_fd_sc_hd__a31o_1
XFILLER_0_36_3 VPWR VGND VPWR VGND sky130_ef_sc_hd__decap_12
X_2288_ IM0.addr\[1\] VGND VGND VPWR VPWR _0513_ sky130_fd_sc_hd__buf_2
X_4027_ _2087_ VGND VGND VPWR VPWR _0359_ sky130_fd_sc_hd__clkbuf_1
XFILLER_0_81_209 VGND VGND VPWR VPWR sky130_fd_sc_hd__decap_4
XFILLER_0_19_133 VGND VGND VPWR VPWR sky130_fd_sc_hd__decap_8
XFILLER_0_19_166 VGND VGND VPWR VPWR sky130_fd_sc_hd__fill_2
XFILLER_0_47_475 VGND VGND VPWR VPWR sky130_fd_sc_hd__decap_6
XTAP_TAPCELL_ROW_50_598 VGND VPWR sky130_fd_sc_hd__tapvpwrvgnd_1
XFILLER_0_22_309 VPWR VGND VPWR VGND sky130_ef_sc_hd__decap_12
XFILLER_0_15_383 VGND VGND VPWR VPWR sky130_fd_sc_hd__fill_1
XTAP_TAPCELL_ROW_7_232 VGND VPWR sky130_fd_sc_hd__tapvpwrvgnd_1
XTAP_TAPCELL_ROW_58_665 VGND VPWR sky130_fd_sc_hd__tapvpwrvgnd_1
XFILLER_0_57_239 VGND VGND VPWR VPWR sky130_fd_sc_hd__decap_3
XFILLER_0_31_15 VPWR VGND VPWR VGND sky130_ef_sc_hd__decap_12
XTAP_TAPCELL_ROW_41_521 VGND VPWR sky130_fd_sc_hd__tapvpwrvgnd_1
XFILLER_0_80_253 VGND VGND VPWR VPWR sky130_fd_sc_hd__decap_8
XTAP_TAPCELL_ROW_13_289 VGND VPWR sky130_fd_sc_hd__tapvpwrvgnd_1
XFILLER_0_0_225 VPWR VGND VPWR VGND sky130_ef_sc_hd__decap_12
X_3260_ _1260_ _1262_ _1063_ VGND VGND VPWR VPWR _1418_ sky130_fd_sc_hd__mux2_1
X_3191_ _1160_ _1173_ _1063_ VGND VGND VPWR VPWR _1350_ sky130_fd_sc_hd__mux2_1
XFILLER_0_48_217 VGND VGND VPWR VPWR sky130_fd_sc_hd__fill_1
XFILLER_0_8_347 VGND VGND VPWR VPWR sky130_fd_sc_hd__decap_8
X_4714_ clknet_leaf_1_clk _0364_ _0108_ VGND VGND VPWR VPWR RF0.regs\[15\]\[12\] sky130_fd_sc_hd__dfrtp_1
X_2975_ _1134_ VGND VGND VPWR VPWR _1135_ sky130_fd_sc_hd__clkbuf_4
XFILLER_0_56_261 VGND VGND VPWR VPWR sky130_fd_sc_hd__decap_3
X_4645_ clknet_leaf_20_clk _0295_ _0039_ VGND VGND VPWR VPWR RF0.regs\[25\]\[7\] sky130_fd_sc_hd__dfrtp_1
XFILLER_0_31_106 VGND VGND VPWR VPWR sky130_fd_sc_hd__decap_3
X_4576_ _2284_ VGND VGND VPWR VPWR _0228_ sky130_fd_sc_hd__inv_2
X_3527_ _1052_ _0866_ VGND VGND VPWR VPWR _1681_ sky130_fd_sc_hd__and2_1
X_3458_ RF0.regs\[10\]\[5\] _0629_ _1613_ VGND VGND VPWR VPWR _1614_ sky130_fd_sc_hd__a21o_1
XTAP_TAPCELL_ROW_4_213 VGND VPWR sky130_fd_sc_hd__tapvpwrvgnd_1
X_2409_ _0579_ VGND VGND VPWR VPWR _0457_ sky130_fd_sc_hd__clkbuf_1
X_3389_ _1533_ _1543_ _1545_ VGND VGND VPWR VPWR _1546_ sky130_fd_sc_hd__o21bai_1
XPHY_EDGE_ROW_24_Left_106 VGND VGND VPWR VPWR sky130_fd_sc_hd__decap_3
XTAP_TAPCELL_ROW_55_646 VGND VPWR sky130_fd_sc_hd__tapvpwrvgnd_1
XPHY_EDGE_ROW_33_Left_115 VGND VGND VPWR VPWR sky130_fd_sc_hd__decap_3
XFILLER_0_62_253 VGND VGND VPWR VPWR sky130_fd_sc_hd__fill_1
XTAP_TAPCELL_ROW_10_259 VGND VPWR sky130_fd_sc_hd__tapvpwrvgnd_1
XFILLER_0_30_161 VGND VGND VPWR VPWR sky130_fd_sc_hd__fill_1
XFILLER_0_30_183 VGND VGND VPWR VPWR sky130_fd_sc_hd__fill_1
XPHY_EDGE_ROW_42_Left_124 VGND VGND VPWR VPWR sky130_fd_sc_hd__decap_3
Xhold60 RF0.regs\[0\]\[8\] VGND VGND VPWR VPWR net95 sky130_fd_sc_hd__dlygate4sd3_1
Xhold71 RF0.regs\[0\]\[11\] VGND VGND VPWR VPWR net106 sky130_fd_sc_hd__dlygate4sd3_1
Xhold82 RF0.regs\[0\]\[24\] VGND VGND VPWR VPWR net117 sky130_fd_sc_hd__dlygate4sd3_1
Xhold93 RF0.regs\[20\]\[27\] VGND VGND VPWR VPWR net128 sky130_fd_sc_hd__dlygate4sd3_1
XTAP_TAPCELL_ROW_18_326 VGND VPWR sky130_fd_sc_hd__tapvpwrvgnd_1
XPHY_EDGE_ROW_51_Left_133 VGND VGND VPWR VPWR sky130_fd_sc_hd__decap_3
XFILLER_0_38_261 VPWR VGND VPWR VGND sky130_ef_sc_hd__decap_12
X_2760_ net33 _0898_ VGND VGND VPWR VPWR _0921_ sky130_fd_sc_hd__nand2_1
X_2691_ _0850_ _0851_ VGND VGND VPWR VPWR _0852_ sky130_fd_sc_hd__nor2_1
XFILLER_0_53_264 VGND VGND VPWR VPWR sky130_fd_sc_hd__decap_6
XFILLER_0_53_275 VGND VGND VPWR VPWR sky130_fd_sc_hd__decap_4
X_4430_ _2264_ VGND VGND VPWR VPWR _0102_ sky130_fd_sc_hd__inv_2
XANTENNA_2 _1432_ VGND VGND VPWR VPWR sky130_fd_sc_hd__diode_2
XFILLER_0_6_25 VGND VGND VPWR VPWR sky130_fd_sc_hd__decap_3
XFILLER_0_21_161 VGND VGND VPWR VPWR sky130_fd_sc_hd__decap_6
X_4361_ _2255_ VGND VGND VPWR VPWR _0042_ sky130_fd_sc_hd__inv_2
X_3312_ RF0.regs\[10\]\[20\] _0630_ _0618_ RF0.regs\[25\]\[20\] VGND VGND VPWR VPWR
+ _1470_ sky130_fd_sc_hd__a22o_1
X_4292_ _2233_ VGND VGND VPWR VPWR net15 sky130_fd_sc_hd__inv_2
XPHY_EDGE_ROW_60_Left_142 VGND VGND VPWR VPWR sky130_fd_sc_hd__decap_3
XFILLER_0_67_55 VGND VGND VPWR VPWR sky130_fd_sc_hd__fill_1
X_3243_ _1291_ _1396_ _1401_ _1300_ VGND VGND VPWR VPWR _1402_ sky130_fd_sc_hd__a22o_1
X_3174_ _1084_ _1101_ VGND VGND VPWR VPWR _1333_ sky130_fd_sc_hd__nor2_1
Xrebuffer14 net7 VGND VGND VPWR VPWR net49 sky130_fd_sc_hd__dlygate4sd1_1
XTAP_TAPCELL_ROW_52_616 VGND VPWR sky130_fd_sc_hd__tapvpwrvgnd_1
XFILLER_0_8_166 VGND VGND VPWR VPWR sky130_fd_sc_hd__fill_1
X_2958_ _0838_ _0845_ _1007_ VGND VGND VPWR VPWR _1118_ sky130_fd_sc_hd__mux2_1
XTAP_TAPCELL_ROW_60_682 VGND VPWR sky130_fd_sc_hd__tapvpwrvgnd_1
XFILLER_0_4_361 VGND VGND VPWR VPWR sky130_fd_sc_hd__decap_3
X_2889_ _1043_ _1046_ _1049_ VGND VGND VPWR VPWR _1050_ sky130_fd_sc_hd__mux2_1
X_4628_ clknet_leaf_6_clk _0278_ _0022_ VGND VGND VPWR VPWR RF0.regs\[30\]\[22\] sky130_fd_sc_hd__dfrtp_1
XFILLER_0_40_470 VGND VGND VPWR VPWR sky130_fd_sc_hd__decap_6
X_4559_ _2283_ VGND VGND VPWR VPWR _0212_ sky130_fd_sc_hd__inv_2
XFILLER_0_79_172 VGND VGND VPWR VPWR sky130_fd_sc_hd__decap_6
XTAP_TAPCELL_ROW_15_307 VGND VPWR sky130_fd_sc_hd__tapvpwrvgnd_1
XTAP_TAPCELL_ROW_23_373 VGND VPWR sky130_fd_sc_hd__tapvpwrvgnd_1
XFILLER_0_2_309 VPWR VGND VPWR VGND sky130_ef_sc_hd__decap_12
Xoutput4 net4 VGND VGND VPWR VPWR Result[12] sky130_fd_sc_hd__buf_2
X_3930_ _2036_ VGND VGND VPWR VPWR _0405_ sky130_fd_sc_hd__clkbuf_1
XFILLER_0_53_79 VGND VGND VPWR VPWR sky130_fd_sc_hd__decap_8
X_3861_ _1990_ RF0.regs\[5\]\[12\] _1957_ VGND VGND VPWR VPWR _1991_ sky130_fd_sc_hd__mux2_1
X_3792_ _1788_ _1925_ _1931_ _1932_ VGND VGND VPWR VPWR _1933_ sky130_fd_sc_hd__a22o_1
X_2812_ _0959_ _0970_ _0972_ VGND VGND VPWR VPWR _0973_ sky130_fd_sc_hd__o21ai_1
XFILLER_0_5_125 VGND VGND VPWR VPWR sky130_fd_sc_hd__decap_8
X_2743_ RF0.regs\[10\]\[14\] _0615_ _0672_ RF0.regs\[25\]\[14\] VGND VGND VPWR VPWR
+ _0904_ sky130_fd_sc_hd__a22o_1
XFILLER_0_41_223 VGND VGND VPWR VPWR sky130_fd_sc_hd__fill_1
X_2674_ _0771_ _0815_ _0834_ VGND VGND VPWR VPWR _0835_ sky130_fd_sc_hd__a21bo_1
XFILLER_0_78_65 VPWR VGND VPWR VGND sky130_ef_sc_hd__decap_12
XFILLER_0_22_481 VGND VGND VPWR VPWR sky130_fd_sc_hd__fill_1
X_4413_ _2261_ VGND VGND VPWR VPWR _0088_ sky130_fd_sc_hd__inv_2
X_4344_ _2252_ VGND VGND VPWR VPWR _0028_ sky130_fd_sc_hd__inv_2
X_4275_ _1777_ VGND VGND VPWR VPWR net10 sky130_fd_sc_hd__inv_2
X_3226_ _1116_ _1120_ _1074_ VGND VGND VPWR VPWR _1385_ sky130_fd_sc_hd__mux2_1
X_3157_ _1314_ _1315_ _1037_ VGND VGND VPWR VPWR _1316_ sky130_fd_sc_hd__mux2_1
XTAP_TAPCELL_ROW_65_730 VGND VPWR sky130_fd_sc_hd__tapvpwrvgnd_1
X_3088_ _1244_ _1247_ _1048_ VGND VGND VPWR VPWR _1248_ sky130_fd_sc_hd__mux2_1
XTAP_TAPCELL_ROW_37_487 VGND VPWR sky130_fd_sc_hd__tapvpwrvgnd_1
XFILLER_0_76_197 VGND VGND VPWR VPWR sky130_fd_sc_hd__decap_8
XFILLER_0_17_264 VGND VGND VPWR VPWR sky130_fd_sc_hd__decap_4
XTAP_TAPCELL_ROW_20_343 VGND VPWR sky130_fd_sc_hd__tapvpwrvgnd_1
XFILLER_0_13_481 VGND VGND VPWR VPWR sky130_fd_sc_hd__fill_1
XTAP_TAPCELL_ROW_28_410 VGND VPWR sky130_fd_sc_hd__tapvpwrvgnd_1
XFILLER_0_55_315 VGND VGND VPWR VPWR sky130_fd_sc_hd__fill_1
XTAP_TAPCELL_ROW_71_777 VGND VPWR sky130_fd_sc_hd__tapvpwrvgnd_1
XFILLER_0_55_359 VGND VGND VPWR VPWR sky130_fd_sc_hd__fill_1
Xrebuffer5 _0599_ VGND VGND VPWR VPWR net40 sky130_fd_sc_hd__buf_2
XFILLER_0_70_329 VGND VGND VPWR VPWR sky130_fd_sc_hd__fill_1
XFILLER_0_11_418 VPWR VGND VPWR VGND sky130_ef_sc_hd__decap_12
X_2390_ net91 VGND VGND VPWR VPWR _0570_ sky130_fd_sc_hd__clkbuf_1
XTAP_TAPCELL_ROW_79_844 VGND VPWR sky130_fd_sc_hd__tapvpwrvgnd_1
XFILLER_0_3_15 VGND VGND VPWR VPWR sky130_fd_sc_hd__fill_1
X_4060_ net124 _1859_ _2098_ VGND VGND VPWR VPWR _2106_ sky130_fd_sc_hd__mux2_1
XFILLER_0_3_48 VGND VGND VPWR VPWR sky130_fd_sc_hd__fill_2
X_3011_ RF0.regs\[10\]\[16\] _0969_ _0931_ RF0.regs\[25\]\[16\] VGND VGND VPWR VPWR
+ _1171_ sky130_fd_sc_hd__a22o_1
XTAP_TAPCELL_ROW_62_700 VGND VPWR sky130_fd_sc_hd__tapvpwrvgnd_1
X_3913_ _2027_ VGND VGND VPWR VPWR _0413_ sky130_fd_sc_hd__clkbuf_1
XFILLER_0_46_315 VGND VGND VPWR VPWR sky130_fd_sc_hd__decap_4
XFILLER_0_80_77 VGND VGND VPWR VPWR sky130_fd_sc_hd__decap_6
XTAP_TAPCELL_ROW_34_468 VGND VPWR sky130_fd_sc_hd__tapvpwrvgnd_1
X_3844_ _1573_ _1708_ VGND VGND VPWR VPWR _1977_ sky130_fd_sc_hd__and2_1
XFILLER_0_46_348 VGND VGND VPWR VPWR sky130_fd_sc_hd__decap_8
XFILLER_0_58_197 VGND VGND VPWR VPWR sky130_fd_sc_hd__decap_8
XFILLER_0_73_178 VGND VGND VPWR VPWR sky130_fd_sc_hd__decap_8
XFILLER_0_13_82 VGND VGND VPWR VPWR sky130_fd_sc_hd__decap_3
XFILLER_0_6_445 VPWR VGND VPWR VGND sky130_ef_sc_hd__decap_12
XFILLER_0_73_167 VGND VGND VPWR VPWR sky130_fd_sc_hd__fill_1
X_3775_ _1914_ _1204_ _1915_ VGND VGND VPWR VPWR _1916_ sky130_fd_sc_hd__a21bo_1
X_2726_ RF0.regs\[10\]\[6\] _0809_ _0670_ RF0.regs\[25\]\[6\] VGND VGND VPWR VPWR
+ _0887_ sky130_fd_sc_hd__a22o_1
X_2657_ _0771_ _0815_ _0816_ VGND VGND VPWR VPWR _0818_ sky130_fd_sc_hd__and3_1
XFILLER_0_66_3 VPWR VGND VPWR VGND sky130_ef_sc_hd__decap_12
X_2588_ _0658_ _0748_ VGND VGND VPWR VPWR _0749_ sky130_fd_sc_hd__nand2_1
X_4327_ _2250_ VGND VGND VPWR VPWR _0013_ sky130_fd_sc_hd__inv_2
X_4258_ _2210_ _1294_ _1059_ VGND VGND VPWR VPWR _2211_ sky130_fd_sc_hd__mux2_1
X_3209_ _1178_ _1185_ _1048_ VGND VGND VPWR VPWR _1368_ sky130_fd_sc_hd__mux2_1
X_4189_ _2174_ VGND VGND VPWR VPWR _0284_ sky130_fd_sc_hd__clkbuf_1
XFILLER_0_77_473 VGND VGND VPWR VPWR sky130_fd_sc_hd__decap_8
XFILLER_0_37_315 VGND VGND VPWR VPWR sky130_fd_sc_hd__fill_1
XFILLER_0_9_294 VGND VGND VPWR VPWR sky130_fd_sc_hd__fill_1
XTAP_TAPCELL_ROW_76_825 VGND VPWR sky130_fd_sc_hd__tapvpwrvgnd_1
XPHY_EDGE_ROW_16_Right_16 VGND VGND VPWR VPWR sky130_fd_sc_hd__decap_3
XFILLER_0_34_15 VPWR VGND VPWR VGND sky130_ef_sc_hd__decap_12
XTAP_TAPCELL_ROW_31_438 VGND VPWR sky130_fd_sc_hd__tapvpwrvgnd_1
XFILLER_0_55_167 VGND VGND VPWR VPWR sky130_fd_sc_hd__fill_1
XFILLER_0_55_178 VGND VGND VPWR VPWR sky130_fd_sc_hd__decap_8
XPHY_EDGE_ROW_25_Right_25 VGND VGND VPWR VPWR sky130_fd_sc_hd__decap_3
X_3560_ _1573_ _1708_ _1712_ _1709_ VGND VGND VPWR VPWR _1713_ sky130_fd_sc_hd__a211oi_2
X_2511_ _0671_ VGND VGND VPWR VPWR _0672_ sky130_fd_sc_hd__buf_4
XFILLER_0_51_351 VGND VGND VPWR VPWR sky130_fd_sc_hd__fill_1
XFILLER_0_11_237 VGND VGND VPWR VPWR sky130_fd_sc_hd__decap_6
X_3491_ _1019_ _1032_ VGND VGND VPWR VPWR _1647_ sky130_fd_sc_hd__nor2_1
X_2442_ _0602_ VGND VGND VPWR VPWR _0603_ sky130_fd_sc_hd__buf_4
XFILLER_0_59_89 VGND VGND VPWR VPWR sky130_fd_sc_hd__decap_4
X_2373_ _0561_ VGND VGND VPWR VPWR _0475_ sky130_fd_sc_hd__clkbuf_1
XFILLER_0_75_55 VGND VGND VPWR VPWR sky130_fd_sc_hd__fill_1
X_4112_ _0512_ _0619_ VGND VGND VPWR VPWR _2133_ sky130_fd_sc_hd__nand2_2
X_4043_ _2096_ VGND VGND VPWR VPWR _0352_ sky130_fd_sc_hd__clkbuf_1
XTAP_TAPCELL_ROW_39_505 VGND VPWR sky130_fd_sc_hd__tapvpwrvgnd_1
XPHY_EDGE_ROW_34_Right_34 VGND VGND VPWR VPWR sky130_fd_sc_hd__decap_3
XFILLER_0_19_304 VGND VGND VPWR VPWR sky130_fd_sc_hd__fill_1
XFILLER_0_74_421 VPWR VGND VPWR VGND sky130_ef_sc_hd__decap_12
XFILLER_0_19_337 VGND VGND VPWR VPWR sky130_fd_sc_hd__fill_2
XFILLER_0_34_307 VGND VGND VPWR VPWR sky130_fd_sc_hd__fill_1
XFILLER_0_6_253 VGND VGND VPWR VPWR sky130_fd_sc_hd__decap_3
XPHY_EDGE_ROW_43_Right_43 VGND VGND VPWR VPWR sky130_fd_sc_hd__decap_3
X_3827_ _1786_ _1963_ VGND VGND VPWR VPWR _1964_ sky130_fd_sc_hd__or2_1
X_3758_ _1877_ _1898_ _1063_ VGND VGND VPWR VPWR _1899_ sky130_fd_sc_hd__mux2_1
X_2709_ _0864_ _0868_ _0869_ VGND VGND VPWR VPWR _0870_ sky130_fd_sc_hd__a21bo_1
X_3689_ _1094_ _1147_ _1149_ VGND VGND VPWR VPWR _1837_ sky130_fd_sc_hd__a21bo_1
XFILLER_0_2_481 VGND VGND VPWR VPWR sky130_fd_sc_hd__fill_1
XPHY_EDGE_ROW_52_Right_52 VGND VGND VPWR VPWR sky130_fd_sc_hd__decap_3
XTAP_TAPCELL_ROW_2_196 VGND VPWR sky130_fd_sc_hd__tapvpwrvgnd_1
XTAP_TAPCELL_ROW_81_872 VGND VPWR sky130_fd_sc_hd__tapvpwrvgnd_1
XTAP_TAPCELL_ROW_81_861 VGND VPWR sky130_fd_sc_hd__tapvpwrvgnd_1
XFILLER_0_77_281 VGND VGND VPWR VPWR sky130_fd_sc_hd__decap_6
XFILLER_0_37_101 VGND VGND VPWR VPWR sky130_fd_sc_hd__fill_1
XFILLER_0_25_307 VGND VGND VPWR VPWR sky130_fd_sc_hd__decap_6
XFILLER_0_37_167 VGND VGND VPWR VPWR sky130_fd_sc_hd__fill_1
XPHY_EDGE_ROW_61_Right_61 VGND VGND VPWR VPWR sky130_fd_sc_hd__decap_3
XFILLER_0_25_329 VGND VGND VPWR VPWR sky130_fd_sc_hd__decap_6
XFILLER_0_80_457 VPWR VGND VPWR VGND sky130_ef_sc_hd__decap_12
XFILLER_0_29_15 VPWR VGND VPWR VGND sky130_ef_sc_hd__decap_12
XPHY_EDGE_ROW_70_Right_70 VGND VGND VPWR VPWR sky130_fd_sc_hd__decap_3
XFILLER_0_0_27 VGND VGND VPWR VPWR sky130_fd_sc_hd__fill_1
X_2991_ _1083_ _1150_ VGND VGND VPWR VPWR _1151_ sky130_fd_sc_hd__nand2_4
XTAP_TAPCELL_ROW_44_552 VGND VPWR sky130_fd_sc_hd__tapvpwrvgnd_1
XFILLER_0_61_57 VGND VGND VPWR VPWR sky130_fd_sc_hd__fill_2
XFILLER_0_28_156 VGND VGND VPWR VPWR sky130_fd_sc_hd__fill_1
XFILLER_0_56_454 VGND VGND VPWR VPWR sky130_fd_sc_hd__fill_1
X_4730_ clknet_leaf_7_clk _0380_ _0124_ VGND VGND VPWR VPWR RF0.regs\[15\]\[28\] sky130_fd_sc_hd__dfrtp_1
X_4661_ clknet_leaf_11_clk _0311_ _0055_ VGND VGND VPWR VPWR RF0.regs\[25\]\[23\]
+ sky130_fd_sc_hd__dfrtp_1
X_3612_ _1038_ _1258_ VGND VGND VPWR VPWR _1763_ sky130_fd_sc_hd__nand2_1
X_4592_ _2286_ VGND VGND VPWR VPWR _0242_ sky130_fd_sc_hd__inv_2
XFILLER_0_24_362 VGND VGND VPWR VPWR sky130_fd_sc_hd__fill_2
XFILLER_0_24_373 VPWR VGND VPWR VGND sky130_ef_sc_hd__decap_12
X_3543_ _1694_ _1696_ VGND VGND VPWR VPWR _1697_ sky130_fd_sc_hd__or2_1
X_3474_ _0859_ _1023_ VGND VGND VPWR VPWR _1630_ sky130_fd_sc_hd__xnor2_1
X_2425_ _0587_ VGND VGND VPWR VPWR _0449_ sky130_fd_sc_hd__clkbuf_1
X_2356_ net59 _0515_ VGND VGND VPWR VPWR _0483_ sky130_fd_sc_hd__xor2_1
X_2287_ control VGND VGND VPWR VPWR _0512_ sky130_fd_sc_hd__buf_4
X_4026_ _2007_ RF0.regs\[15\]\[7\] _2082_ VGND VGND VPWR VPWR _2087_ sky130_fd_sc_hd__mux2_1
XFILLER_0_29_3 VPWR VGND VPWR VGND sky130_ef_sc_hd__decap_12
XFILLER_0_59_281 VGND VGND VPWR VPWR sky130_fd_sc_hd__decap_6
XFILLER_0_47_465 VGND VGND VPWR VPWR sky130_fd_sc_hd__fill_1
X_4859_ clknet_leaf_24_clk _0509_ _0253_ VGND VGND VPWR VPWR IM0.addr\[29\] sky130_fd_sc_hd__dfrtp_1
XFILLER_0_34_148 VGND VGND VPWR VPWR sky130_fd_sc_hd__fill_2
XTAP_TAPCELL_ROW_50_599 VGND VPWR sky130_fd_sc_hd__tapvpwrvgnd_1
XFILLER_0_62_446 VPWR VGND VPWR VGND sky130_ef_sc_hd__decap_12
XFILLER_0_30_321 VGND VGND VPWR VPWR sky130_fd_sc_hd__decap_8
XTAP_TAPCELL_ROW_7_233 VGND VPWR sky130_fd_sc_hd__tapvpwrvgnd_1
XTAP_TAPCELL_ROW_58_666 VGND VPWR sky130_fd_sc_hd__tapvpwrvgnd_1
XFILLER_0_38_421 VGND VGND VPWR VPWR sky130_fd_sc_hd__fill_1
XFILLER_0_38_454 VGND VGND VPWR VPWR sky130_fd_sc_hd__fill_1
XTAP_TAPCELL_ROW_41_522 VGND VPWR sky130_fd_sc_hd__tapvpwrvgnd_1
XFILLER_0_31_27 VPWR VGND VPWR VGND sky130_ef_sc_hd__decap_12
XFILLER_0_53_402 VPWR VGND VPWR VGND sky130_ef_sc_hd__decap_12
XFILLER_0_21_321 VPWR VGND VPWR VGND sky130_ef_sc_hd__decap_12
XFILLER_0_0_237 VPWR VGND VPWR VGND sky130_ef_sc_hd__decap_12
XFILLER_0_21_354 VGND VGND VPWR VPWR sky130_fd_sc_hd__fill_2
XFILLER_0_21_365 VGND VGND VPWR VPWR sky130_fd_sc_hd__decap_3
XFILLER_0_21_376 VGND VGND VPWR VPWR sky130_fd_sc_hd__decap_4
X_3190_ _1179_ _1186_ _1065_ VGND VGND VPWR VPWR _1349_ sky130_fd_sc_hd__mux2_1
XFILLER_0_8_326 VGND VGND VPWR VPWR sky130_fd_sc_hd__fill_2
X_2974_ _1034_ VGND VGND VPWR VPWR _1134_ sky130_fd_sc_hd__buf_2
XFILLER_0_29_476 VGND VGND VPWR VPWR sky130_fd_sc_hd__fill_2
X_4713_ clknet_leaf_2_clk _0363_ _0107_ VGND VGND VPWR VPWR RF0.regs\[15\]\[11\] sky130_fd_sc_hd__dfrtp_1
XFILLER_0_44_402 VPWR VGND VPWR VGND sky130_ef_sc_hd__decap_12
XFILLER_0_56_251 VGND VGND VPWR VPWR sky130_fd_sc_hd__fill_1
X_4644_ clknet_leaf_19_clk _0294_ _0038_ VGND VGND VPWR VPWR RF0.regs\[25\]\[6\] sky130_fd_sc_hd__dfrtp_1
XFILLER_0_71_276 VGND VGND VPWR VPWR sky130_fd_sc_hd__fill_1
X_4575_ _2284_ VGND VGND VPWR VPWR _0227_ sky130_fd_sc_hd__inv_2
XFILLER_0_12_321 VGND VGND VPWR VPWR sky130_fd_sc_hd__decap_8
X_3526_ _1677_ _1679_ VGND VGND VPWR VPWR _1680_ sky130_fd_sc_hd__nor2_1
XFILLER_0_12_365 VGND VGND VPWR VPWR sky130_fd_sc_hd__decap_4
X_3457_ RF0.regs\[5\]\[5\] _0633_ _0637_ RF0.regs\[30\]\[5\] _0640_ VGND VGND VPWR
+ VPWR _1613_ sky130_fd_sc_hd__a221o_1
XTAP_TAPCELL_ROW_4_214 VGND VPWR sky130_fd_sc_hd__tapvpwrvgnd_1
X_2408_ net93 VGND VGND VPWR VPWR _0579_ sky130_fd_sc_hd__clkbuf_1
X_3388_ _1513_ _1544_ VGND VGND VPWR VPWR _1545_ sky130_fd_sc_hd__nor2_1
X_2339_ IM0.addr\[12\] _0521_ net66 VGND VGND VPWR VPWR _0546_ sky130_fd_sc_hd__a21oi_1
XPHY_EDGE_ROW_2_Right_2 VGND VGND VPWR VPWR sky130_fd_sc_hd__decap_3
X_4009_ _1981_ RF0.regs\[15\]\[15\] _2071_ VGND VGND VPWR VPWR _2078_ sky130_fd_sc_hd__mux2_1
XTAP_TAPCELL_ROW_55_647 VGND VPWR sky130_fd_sc_hd__tapvpwrvgnd_1
XFILLER_0_62_221 VGND VGND VPWR VPWR sky130_fd_sc_hd__decap_3
XFILLER_0_50_427 VGND VGND VPWR VPWR sky130_fd_sc_hd__fill_1
Xhold50 IM0.addr\[14\] VGND VGND VPWR VPWR net85 sky130_fd_sc_hd__dlygate4sd3_1
Xhold83 RF0.regs\[20\]\[7\] VGND VGND VPWR VPWR net118 sky130_fd_sc_hd__dlygate4sd3_1
XFILLER_0_26_27 VGND VGND VPWR VPWR sky130_fd_sc_hd__fill_1
Xhold72 RF0.regs\[0\]\[10\] VGND VGND VPWR VPWR net107 sky130_fd_sc_hd__dlygate4sd3_1
Xhold61 RF0.regs\[0\]\[15\] VGND VGND VPWR VPWR net96 sky130_fd_sc_hd__dlygate4sd3_1
Xhold94 RF0.regs\[20\]\[23\] VGND VGND VPWR VPWR net129 sky130_fd_sc_hd__dlygate4sd3_1
XTAP_TAPCELL_ROW_18_327 VGND VPWR sky130_fd_sc_hd__tapvpwrvgnd_1
XFILLER_0_42_15 VPWR VGND VPWR VGND sky130_ef_sc_hd__decap_12
XTAP_TAPCELL_ROW_26_393 VGND VPWR sky130_fd_sc_hd__tapvpwrvgnd_1
XFILLER_0_38_273 VGND VGND VPWR VPWR sky130_fd_sc_hd__fill_2
XFILLER_0_5_307 VGND VGND VPWR VPWR sky130_fd_sc_hd__decap_3
X_2690_ RF0.regs\[10\]\[6\] _0615_ _0671_ RF0.regs\[25\]\[6\] VGND VGND VPWR VPWR
+ _0851_ sky130_fd_sc_hd__a22o_2
XFILLER_0_41_449 VGND VGND VPWR VPWR sky130_fd_sc_hd__fill_2
XFILLER_0_6_15 VGND VGND VPWR VPWR sky130_fd_sc_hd__decap_6
X_4360_ _2255_ VGND VGND VPWR VPWR _0041_ sky130_fd_sc_hd__inv_2
X_3311_ _1454_ net44 VGND VGND VPWR VPWR _1469_ sky130_fd_sc_hd__nor2_1
X_4291_ _1099_ _1414_ _1443_ _2231_ _2232_ VGND VGND VPWR VPWR _2233_ sky130_fd_sc_hd__o32a_1
X_3242_ _1397_ _1400_ _1057_ VGND VGND VPWR VPWR _1401_ sky130_fd_sc_hd__mux2_1
X_3173_ _1330_ _1331_ _1034_ VGND VGND VPWR VPWR _1332_ sky130_fd_sc_hd__mux2_1
Xrebuffer15 _0812_ VGND VGND VPWR VPWR net50 sky130_fd_sc_hd__dlygate4sd1_1
XFILLER_0_16_82 VGND VGND VPWR VPWR sky130_fd_sc_hd__fill_2
XTAP_TAPCELL_ROW_52_617 VGND VPWR sky130_fd_sc_hd__tapvpwrvgnd_1
X_2957_ _1114_ _1116_ _1073_ VGND VGND VPWR VPWR _1117_ sky130_fd_sc_hd__mux2_1
XTAP_TAPCELL_ROW_60_683 VGND VPWR sky130_fd_sc_hd__tapvpwrvgnd_1
X_2888_ _1048_ VGND VGND VPWR VPWR _1049_ sky130_fd_sc_hd__clkbuf_4
X_4627_ clknet_leaf_6_clk _0277_ _0021_ VGND VGND VPWR VPWR RF0.regs\[30\]\[21\] sky130_fd_sc_hd__dfrtp_1
XFILLER_0_12_151 VGND VGND VPWR VPWR sky130_fd_sc_hd__decap_4
X_4558_ _2283_ VGND VGND VPWR VPWR _0211_ sky130_fd_sc_hd__inv_2
XFILLER_0_12_184 VGND VGND VPWR VPWR sky130_fd_sc_hd__fill_1
X_3509_ _1096_ _1656_ _1657_ _1663_ _1539_ VGND VGND VPWR VPWR _1664_ sky130_fd_sc_hd__o32a_1
X_4489_ _2272_ VGND VGND VPWR VPWR _0153_ sky130_fd_sc_hd__inv_2
XTAP_TAPCELL_ROW_68_750 VGND VPWR sky130_fd_sc_hd__tapvpwrvgnd_1
XFILLER_0_67_335 VGND VGND VPWR VPWR sky130_fd_sc_hd__fill_1
XTAP_TAPCELL_ROW_23_374 VGND VPWR sky130_fd_sc_hd__tapvpwrvgnd_1
XFILLER_0_35_210 VGND VGND VPWR VPWR sky130_fd_sc_hd__fill_1
XFILLER_0_23_427 VGND VGND VPWR VPWR sky130_fd_sc_hd__fill_1
XFILLER_0_50_213 VGND VGND VPWR VPWR sky130_fd_sc_hd__fill_1
XFILLER_0_23_449 VPWR VGND VPWR VGND sky130_ef_sc_hd__decap_12
Xoutput5 net5 VGND VGND VPWR VPWR Result[13] sky130_fd_sc_hd__buf_2
XFILLER_0_37_15 VPWR VGND VPWR VGND sky130_ef_sc_hd__decap_12
XFILLER_0_58_346 VGND VGND VPWR VPWR sky130_fd_sc_hd__fill_1
XFILLER_0_58_368 VPWR VGND VPWR VGND sky130_ef_sc_hd__decap_12
X_3860_ _1711_ _1907_ VGND VGND VPWR VPWR _1990_ sky130_fd_sc_hd__xnor2_2
XFILLER_0_73_349 VGND VGND VPWR VPWR sky130_fd_sc_hd__fill_2
X_3791_ _1756_ _1765_ VGND VGND VPWR VPWR _1932_ sky130_fd_sc_hd__nand2_1
X_2811_ _0959_ _0970_ _0963_ _0971_ VGND VGND VPWR VPWR _0972_ sky130_fd_sc_hd__a22o_1
X_2742_ _0900_ _0901_ _0902_ VGND VGND VPWR VPWR _0903_ sky130_fd_sc_hd__mux2_1
XFILLER_0_81_393 VPWR VGND VPWR VGND sky130_ef_sc_hd__decap_12
XFILLER_0_26_276 VGND VGND VPWR VPWR sky130_fd_sc_hd__decap_3
X_2673_ RF0.regs\[10\]\[10\] _0828_ _0671_ RF0.regs\[25\]\[10\] VGND VGND VPWR VPWR
+ _0834_ sky130_fd_sc_hd__a22o_1
X_4412_ _2261_ VGND VGND VPWR VPWR _0087_ sky130_fd_sc_hd__inv_2
XFILLER_0_41_279 VGND VGND VPWR VPWR sky130_fd_sc_hd__fill_1
XFILLER_0_78_77 VGND VGND VPWR VPWR sky130_fd_sc_hd__decap_6
X_4343_ _2249_ VGND VGND VPWR VPWR _2252_ sky130_fd_sc_hd__clkbuf_2
X_4274_ _0654_ _1490_ _2220_ _1205_ _1123_ VGND VGND VPWR VPWR net6 sky130_fd_sc_hd__a32o_1
X_3225_ _1309_ VGND VGND VPWR VPWR _1384_ sky130_fd_sc_hd__inv_2
XFILLER_0_27_81 VGND VGND VPWR VPWR sky130_fd_sc_hd__decap_6
X_3156_ _1219_ _1224_ _1062_ VGND VGND VPWR VPWR _1315_ sky130_fd_sc_hd__mux2_1
Xclkbuf_leaf_19_clk clknet_1_0__leaf_clk VGND VGND VPWR VPWR clknet_leaf_19_clk sky130_fd_sc_hd__clkbuf_8
XTAP_TAPCELL_ROW_65_731 VGND VPWR sky130_fd_sc_hd__tapvpwrvgnd_1
X_3087_ _1245_ _1246_ _1044_ VGND VGND VPWR VPWR _1247_ sky130_fd_sc_hd__mux2_1
XFILLER_0_11_3 VPWR VGND VPWR VGND sky130_ef_sc_hd__decap_12
XTAP_TAPCELL_ROW_37_488 VGND VPWR sky130_fd_sc_hd__tapvpwrvgnd_1
XFILLER_0_76_176 VGND VGND VPWR VPWR sky130_fd_sc_hd__decap_8
X_3989_ _2067_ VGND VGND VPWR VPWR _0377_ sky130_fd_sc_hd__clkbuf_1
XTAP_TAPCELL_ROW_20_344 VGND VPWR sky130_fd_sc_hd__tapvpwrvgnd_1
XFILLER_0_32_279 VGND VGND VPWR VPWR sky130_fd_sc_hd__fill_2
XFILLER_0_7_91 VGND VGND VPWR VPWR sky130_fd_sc_hd__fill_2
XTAP_TAPCELL_ROW_28_411 VGND VPWR sky130_fd_sc_hd__tapvpwrvgnd_1
XTAP_TAPCELL_ROW_71_778 VGND VPWR sky130_fd_sc_hd__tapvpwrvgnd_1
XFILLER_0_23_213 VGND VGND VPWR VPWR sky130_fd_sc_hd__decap_8
XFILLER_0_63_382 VGND VGND VPWR VPWR sky130_fd_sc_hd__decap_8
Xrebuffer6 _0723_ VGND VGND VPWR VPWR net41 sky130_fd_sc_hd__dlygate4sd1_1
XFILLER_0_63_393 VPWR VGND VPWR VGND sky130_ef_sc_hd__decap_12
XTAP_TAPCELL_ROW_79_845 VGND VPWR sky130_fd_sc_hd__tapvpwrvgnd_1
X_3010_ RF0.regs\[10\]\[15\] _0969_ _0673_ RF0.regs\[25\]\[15\] VGND VGND VPWR VPWR
+ _1170_ sky130_fd_sc_hd__a22o_1
XFILLER_0_58_110 VGND VGND VPWR VPWR sky130_fd_sc_hd__decap_3
XFILLER_0_58_121 VGND VGND VPWR VPWR sky130_fd_sc_hd__decap_8
XTAP_TAPCELL_ROW_62_701 VGND VPWR sky130_fd_sc_hd__tapvpwrvgnd_1
X_3912_ _1842_ RF0.regs\[10\]\[29\] _2024_ VGND VGND VPWR VPWR _2027_ sky130_fd_sc_hd__mux2_1
XTAP_TAPCELL_ROW_34_469 VGND VPWR sky130_fd_sc_hd__tapvpwrvgnd_1
X_3843_ _1976_ VGND VGND VPWR VPWR _0432_ sky130_fd_sc_hd__clkbuf_1
XFILLER_0_61_308 VPWR VGND VPWR VGND sky130_ef_sc_hd__decap_12
XFILLER_0_6_457 VPWR VGND VPWR VGND sky130_ef_sc_hd__decap_12
X_3774_ _1098_ _1501_ _1502_ VGND VGND VPWR VPWR _1915_ sky130_fd_sc_hd__or3_1
X_2725_ _0861_ _0882_ _0884_ _0885_ VGND VGND VPWR VPWR _0886_ sky130_fd_sc_hd__a211oi_1
Xclkbuf_leaf_8_clk clknet_1_1__leaf_clk VGND VGND VPWR VPWR clknet_leaf_8_clk sky130_fd_sc_hd__clkbuf_8
X_2656_ _0771_ _0815_ _0816_ VGND VGND VPWR VPWR _0817_ sky130_fd_sc_hd__a21oi_2
XFILLER_0_59_3 VPWR VGND VPWR VGND sky130_ef_sc_hd__decap_12
X_2587_ RF0.regs\[15\]\[22\] _0663_ _0672_ RF0.regs\[5\]\[22\] VGND VGND VPWR VPWR
+ _0748_ sky130_fd_sc_hd__a22o_1
X_4326_ _2250_ VGND VGND VPWR VPWR _0012_ sky130_fd_sc_hd__inv_2
X_4257_ _1298_ VGND VGND VPWR VPWR _2210_ sky130_fd_sc_hd__inv_2
X_4188_ _1845_ net151 _2170_ VGND VGND VPWR VPWR _2174_ sky130_fd_sc_hd__mux2_1
X_3208_ _1183_ _1366_ _1049_ VGND VGND VPWR VPWR _1367_ sky130_fd_sc_hd__mux2_1
X_3139_ _1298_ _1121_ _1063_ VGND VGND VPWR VPWR _1299_ sky130_fd_sc_hd__mux2_1
XFILLER_0_77_441 VGND VGND VPWR VPWR sky130_fd_sc_hd__decap_6
XFILLER_0_37_305 VGND VGND VPWR VPWR sky130_fd_sc_hd__fill_1
XFILLER_0_45_382 VGND VGND VPWR VPWR sky130_fd_sc_hd__fill_1
XFILLER_0_60_363 VGND VGND VPWR VPWR sky130_fd_sc_hd__fill_1
XFILLER_0_0_3 VPWR VGND VPWR VGND sky130_ef_sc_hd__decap_12
XFILLER_0_18_39 VGND VGND VPWR VPWR sky130_fd_sc_hd__decap_3
XTAP_TAPCELL_ROW_76_826 VGND VPWR sky130_fd_sc_hd__tapvpwrvgnd_1
XFILLER_0_34_27 VGND VGND VPWR VPWR sky130_fd_sc_hd__fill_1
XFILLER_0_50_15 VPWR VGND VPWR VGND sky130_ef_sc_hd__decap_12
XTAP_TAPCELL_ROW_31_439 VGND VPWR sky130_fd_sc_hd__tapvpwrvgnd_1
XFILLER_0_3_449 VPWR VGND VPWR VGND sky130_ef_sc_hd__decap_12
X_3490_ _1644_ VGND VGND VPWR VPWR _1646_ sky130_fd_sc_hd__inv_2
X_2510_ _0670_ VGND VGND VPWR VPWR _0671_ sky130_fd_sc_hd__buf_4
X_2441_ _0601_ VGND VGND VPWR VPWR _0602_ sky130_fd_sc_hd__clkbuf_4
XFILLER_0_59_57 VPWR VGND VPWR VGND sky130_ef_sc_hd__decap_12
XFILLER_0_59_79 VGND VGND VPWR VPWR sky130_fd_sc_hd__fill_1
X_2372_ net109 VGND VGND VPWR VPWR _0561_ sky130_fd_sc_hd__clkbuf_1
X_4111_ _2132_ VGND VGND VPWR VPWR _0320_ sky130_fd_sc_hd__clkbuf_1
X_4042_ _2095_ RF0.regs\[15\]\[0\] _2059_ VGND VGND VPWR VPWR _2096_ sky130_fd_sc_hd__mux2_1
XTAP_TAPCELL_ROW_39_506 VGND VPWR sky130_fd_sc_hd__tapvpwrvgnd_1
XTAP_TAPCELL_ROW_47_572 VGND VPWR sky130_fd_sc_hd__tapvpwrvgnd_1
XFILLER_0_59_430 VPWR VGND VPWR VGND sky130_ef_sc_hd__decap_12
XFILLER_0_74_433 VPWR VGND VPWR VGND sky130_ef_sc_hd__decap_12
XFILLER_0_19_316 VGND VGND VPWR VPWR sky130_fd_sc_hd__decap_3
XFILLER_0_74_477 VGND VGND VPWR VPWR sky130_fd_sc_hd__decap_4
X_3826_ _1961_ _1962_ _1787_ VGND VGND VPWR VPWR _1963_ sky130_fd_sc_hd__a21oi_1
X_3757_ _1522_ _1520_ _1075_ VGND VGND VPWR VPWR _1898_ sky130_fd_sc_hd__mux2_1
X_2708_ _0723_ _0862_ _0863_ VGND VGND VPWR VPWR _0869_ sky130_fd_sc_hd__a21o_1
XFILLER_0_6_298 VGND VGND VPWR VPWR sky130_fd_sc_hd__decap_8
X_3688_ _1836_ VGND VGND VPWR VPWR _0447_ sky130_fd_sc_hd__clkbuf_1
X_2639_ _0798_ _0799_ VGND VGND VPWR VPWR _0800_ sky130_fd_sc_hd__nand2_1
X_4309_ reset VGND VGND VPWR VPWR _2246_ sky130_fd_sc_hd__clkbuf_4
XFILLER_0_69_216 VGND VGND VPWR VPWR sky130_fd_sc_hd__fill_2
XTAP_TAPCELL_ROW_2_197 VGND VPWR sky130_fd_sc_hd__tapvpwrvgnd_1
XFILLER_0_69_249 VPWR VGND VPWR VGND sky130_ef_sc_hd__decap_12
XTAP_TAPCELL_ROW_81_873 VGND VPWR sky130_fd_sc_hd__tapvpwrvgnd_1
XTAP_TAPCELL_ROW_81_862 VGND VPWR sky130_fd_sc_hd__tapvpwrvgnd_1
XFILLER_0_77_271 VGND VGND VPWR VPWR sky130_fd_sc_hd__decap_8
XFILLER_0_37_113 VPWR VGND VPWR VGND sky130_ef_sc_hd__decap_12
XFILLER_0_80_469 VGND VGND VPWR VPWR sky130_fd_sc_hd__decap_6
XFILLER_0_20_29 VGND VGND VPWR VPWR sky130_fd_sc_hd__decap_4
XFILLER_0_52_127 VPWR VGND VPWR VGND sky130_ef_sc_hd__decap_12
XFILLER_0_33_341 VGND VGND VPWR VPWR sky130_fd_sc_hd__fill_1
XFILLER_0_29_27 VGND VGND VPWR VPWR sky130_fd_sc_hd__decap_6
XFILLER_0_45_15 VPWR VGND VPWR VGND sky130_ef_sc_hd__decap_12
X_2990_ _0606_ _0647_ VGND VGND VPWR VPWR _1150_ sky130_fd_sc_hd__nor2_4
XFILLER_0_28_113 VGND VGND VPWR VPWR sky130_fd_sc_hd__fill_1
XTAP_TAPCELL_ROW_44_553 VGND VPWR sky130_fd_sc_hd__tapvpwrvgnd_1
XFILLER_0_56_444 VGND VGND VPWR VPWR sky130_fd_sc_hd__fill_1
XFILLER_0_9_15 VGND VGND VPWR VPWR sky130_fd_sc_hd__decap_3
XFILLER_0_28_168 VGND VGND VPWR VPWR sky130_fd_sc_hd__decap_4
XFILLER_0_43_116 VGND VGND VPWR VPWR sky130_fd_sc_hd__decap_6
XFILLER_0_56_477 VGND VGND VPWR VPWR sky130_fd_sc_hd__decap_4
X_4660_ clknet_leaf_11_clk _0310_ _0054_ VGND VGND VPWR VPWR RF0.regs\[25\]\[22\]
+ sky130_fd_sc_hd__dfrtp_1
X_3611_ _1433_ _1261_ _1151_ VGND VGND VPWR VPWR _1762_ sky130_fd_sc_hd__o21a_1
XFILLER_0_71_447 VGND VGND VPWR VPWR sky130_fd_sc_hd__fill_1
X_4591_ _2286_ VGND VGND VPWR VPWR _0241_ sky130_fd_sc_hd__inv_2
XFILLER_0_24_385 VGND VGND VPWR VPWR sky130_fd_sc_hd__decap_6
X_3542_ RF0.regs\[20\]\[9\] _0625_ _1090_ RF0.regs\[25\]\[9\] _1695_ VGND VGND VPWR
+ VPWR _1696_ sky130_fd_sc_hd__a221o_1
X_3473_ _1626_ _1628_ VGND VGND VPWR VPWR _1629_ sky130_fd_sc_hd__nor2_1
X_2424_ net105 VGND VGND VPWR VPWR _0587_ sky130_fd_sc_hd__clkbuf_1
X_2355_ _0516_ net53 VGND VGND VPWR VPWR _0484_ sky130_fd_sc_hd__nor2_1
X_4025_ _2086_ VGND VGND VPWR VPWR _0360_ sky130_fd_sc_hd__clkbuf_1
XFILLER_0_19_113 VGND VGND VPWR VPWR sky130_fd_sc_hd__decap_4
XFILLER_0_59_271 VGND VGND VPWR VPWR sky130_fd_sc_hd__fill_2
XFILLER_0_74_230 VGND VGND VPWR VPWR sky130_fd_sc_hd__fill_2
XFILLER_0_19_124 VGND VGND VPWR VPWR sky130_fd_sc_hd__decap_6
XFILLER_0_47_444 VGND VGND VPWR VPWR sky130_fd_sc_hd__decap_4
XFILLER_0_47_455 VGND VGND VPWR VPWR sky130_fd_sc_hd__fill_1
X_4858_ clknet_leaf_25_clk _0508_ _0252_ VGND VGND VPWR VPWR IM0.addr\[28\] sky130_fd_sc_hd__dfrtp_1
XFILLER_0_51_80 VGND VGND VPWR VPWR sky130_fd_sc_hd__fill_2
X_3809_ _1450_ _1948_ _1949_ VGND VGND VPWR VPWR _1950_ sky130_fd_sc_hd__o21ai_1
XFILLER_0_62_458 VPWR VGND VPWR VGND sky130_ef_sc_hd__decap_12
X_4789_ clknet_leaf_6_clk _0439_ _0183_ VGND VGND VPWR VPWR RF0.regs\[5\]\[23\] sky130_fd_sc_hd__dfrtp_1
XFILLER_0_2_290 VGND VGND VPWR VPWR sky130_fd_sc_hd__fill_1
XFILLER_0_30_388 VGND VGND VPWR VPWR sky130_fd_sc_hd__fill_2
XFILLER_0_30_399 VGND VGND VPWR VPWR sky130_fd_sc_hd__decap_4
XTAP_TAPCELL_ROW_7_234 VGND VPWR sky130_fd_sc_hd__tapvpwrvgnd_1
XTAP_TAPCELL_ROW_58_667 VGND VPWR sky130_fd_sc_hd__tapvpwrvgnd_1
XFILLER_0_57_219 VGND VGND VPWR VPWR sky130_fd_sc_hd__decap_4
XTAP_TAPCELL_ROW_41_523 VGND VPWR sky130_fd_sc_hd__tapvpwrvgnd_1
XFILLER_0_31_39 VPWR VGND VPWR VGND sky130_ef_sc_hd__decap_12
XFILLER_0_38_477 VGND VGND VPWR VPWR sky130_fd_sc_hd__decap_4
XFILLER_0_53_425 VGND VGND VPWR VPWR sky130_fd_sc_hd__fill_1
XFILLER_0_80_244 VGND VGND VPWR VPWR sky130_fd_sc_hd__decap_8
XFILLER_0_53_447 VGND VGND VPWR VPWR sky130_fd_sc_hd__fill_1
XFILLER_0_61_480 VGND VGND VPWR VPWR sky130_fd_sc_hd__fill_2
XFILLER_0_21_333 VGND VGND VPWR VPWR sky130_fd_sc_hd__decap_3
XFILLER_0_21_344 VGND VGND VPWR VPWR sky130_fd_sc_hd__decap_6
XFILLER_0_0_249 VGND VGND VPWR VPWR sky130_fd_sc_hd__decap_3
XFILLER_0_56_230 VGND VGND VPWR VPWR sky130_fd_sc_hd__decap_8
X_2973_ _1131_ _1132_ _1049_ VGND VGND VPWR VPWR _1133_ sky130_fd_sc_hd__mux2_1
X_4712_ clknet_leaf_2_clk _0362_ _0106_ VGND VGND VPWR VPWR RF0.regs\[15\]\[10\] sky130_fd_sc_hd__dfrtp_1
XFILLER_0_44_414 VGND VGND VPWR VPWR sky130_fd_sc_hd__decap_6
XTAP_TAPCELL_ROW_12_280 VGND VPWR sky130_fd_sc_hd__tapvpwrvgnd_1
X_4643_ clknet_leaf_19_clk _0293_ _0037_ VGND VGND VPWR VPWR RF0.regs\[25\]\[5\] sky130_fd_sc_hd__dfrtp_2
X_4574_ _2284_ VGND VGND VPWR VPWR _0226_ sky130_fd_sc_hd__inv_2
X_3525_ RF0.regs\[20\]\[0\] _0623_ _0828_ RF0.regs\[25\]\[0\] _1678_ VGND VGND VPWR
+ VPWR _1679_ sky130_fd_sc_hd__a221o_1
XFILLER_0_12_399 VPWR VGND VPWR VGND sky130_ef_sc_hd__decap_12
X_3456_ _1611_ VGND VGND VPWR VPWR _1612_ sky130_fd_sc_hd__inv_2
X_2407_ _0578_ VGND VGND VPWR VPWR _0458_ sky130_fd_sc_hd__clkbuf_1
X_3387_ _1204_ _1229_ _1531_ VGND VGND VPWR VPWR _1544_ sky130_fd_sc_hd__a21oi_1
XFILLER_0_41_3 VPWR VGND VPWR VGND sky130_ef_sc_hd__decap_12
X_2338_ _0523_ _0545_ VGND VGND VPWR VPWR _0494_ sky130_fd_sc_hd__nor2_1
X_4008_ _2077_ VGND VGND VPWR VPWR _0368_ sky130_fd_sc_hd__clkbuf_1
XFILLER_0_62_277 VGND VGND VPWR VPWR sky130_fd_sc_hd__decap_8
Xhold40 _0548_ VGND VGND VPWR VPWR net75 sky130_fd_sc_hd__dlygate4sd3_1
Xhold51 IM0.addr\[23\] VGND VGND VPWR VPWR net86 sky130_fd_sc_hd__dlygate4sd3_1
Xhold62 RF0.regs\[0\]\[12\] VGND VGND VPWR VPWR net97 sky130_fd_sc_hd__dlygate4sd3_1
Xhold73 RF0.regs\[0\]\[20\] VGND VGND VPWR VPWR net108 sky130_fd_sc_hd__dlygate4sd3_1
Xhold84 RF0.regs\[20\]\[9\] VGND VGND VPWR VPWR net119 sky130_fd_sc_hd__dlygate4sd3_1
Xhold95 RF0.regs\[20\]\[19\] VGND VGND VPWR VPWR net130 sky130_fd_sc_hd__dlygate4sd3_1
XTAP_TAPCELL_ROW_18_328 VGND VPWR sky130_fd_sc_hd__tapvpwrvgnd_1
XFILLER_0_42_27 VGND VGND VPWR VPWR sky130_fd_sc_hd__fill_1
XTAP_TAPCELL_ROW_26_394 VGND VPWR sky130_fd_sc_hd__tapvpwrvgnd_1
X_3310_ RF0.regs\[0\]\[21\] _0604_ _1467_ _1454_ VGND VGND VPWR VPWR _1468_ sky130_fd_sc_hd__a2bb2o_4
X_4290_ _1205_ _2212_ VGND VGND VPWR VPWR _2232_ sky130_fd_sc_hd__nor2_1
XFILLER_0_67_57 VPWR VGND VPWR VGND sky130_ef_sc_hd__decap_12
X_3241_ _1399_ VGND VGND VPWR VPWR _1400_ sky130_fd_sc_hd__inv_2
X_3172_ _1019_ _1072_ _1029_ VGND VGND VPWR VPWR _1331_ sky130_fd_sc_hd__nor3_2
XTAP_TAPCELL_ROW_52_618 VGND VPWR sky130_fd_sc_hd__tapvpwrvgnd_1
XFILLER_0_29_263 VPWR VGND VPWR VGND sky130_ef_sc_hd__decap_12
XFILLER_0_29_296 VGND VGND VPWR VPWR sky130_fd_sc_hd__fill_2
X_2956_ _1014_ _0913_ _1115_ VGND VGND VPWR VPWR _1116_ sky130_fd_sc_hd__o21ai_1
X_2887_ _1047_ VGND VGND VPWR VPWR _1048_ sky130_fd_sc_hd__clkbuf_4
XFILLER_0_32_93 VPWR VGND VPWR VGND sky130_ef_sc_hd__decap_12
XTAP_TAPCELL_ROW_60_684 VGND VPWR sky130_fd_sc_hd__tapvpwrvgnd_1
X_4626_ clknet_leaf_4_clk _0276_ _0020_ VGND VGND VPWR VPWR RF0.regs\[30\]\[20\] sky130_fd_sc_hd__dfrtp_1
X_4557_ _2283_ VGND VGND VPWR VPWR _0210_ sky130_fd_sc_hd__inv_2
X_3508_ _1153_ _1662_ VGND VGND VPWR VPWR _1663_ sky130_fd_sc_hd__nand2_1
X_4488_ _2272_ VGND VGND VPWR VPWR _0152_ sky130_fd_sc_hd__inv_2
X_3439_ _1593_ _1594_ VGND VGND VPWR VPWR _1596_ sky130_fd_sc_hd__nand2_1
XTAP_TAPCELL_ROW_68_751 VGND VPWR sky130_fd_sc_hd__tapvpwrvgnd_1
XTAP_TAPCELL_ROW_23_375 VGND VPWR sky130_fd_sc_hd__tapvpwrvgnd_1
Xoutput6 net6 VGND VGND VPWR VPWR Result[14] sky130_fd_sc_hd__buf_2
Xoutput30 net30 VGND VGND VPWR VPWR Result[7] sky130_fd_sc_hd__buf_2
XFILLER_0_37_27 VPWR VGND VPWR VGND sky130_ef_sc_hd__decap_12
XFILLER_0_53_15 VPWR VGND VPWR VGND sky130_ef_sc_hd__decap_12
XFILLER_0_58_303 VGND VGND VPWR VPWR sky130_fd_sc_hd__decap_4
X_3790_ _1754_ _1930_ _1786_ VGND VGND VPWR VPWR _1931_ sky130_fd_sc_hd__o21bai_1
X_2810_ RF0.regs\[10\]\[20\] _0969_ _0931_ RF0.regs\[25\]\[20\] VGND VGND VPWR VPWR
+ _0971_ sky130_fd_sc_hd__a22o_1
XFILLER_0_5_105 VGND VGND VPWR VPWR sky130_fd_sc_hd__fill_2
X_2741_ _0743_ _0734_ VGND VGND VPWR VPWR _0902_ sky130_fd_sc_hd__nor2_1
XFILLER_0_5_149 VGND VGND VPWR VPWR sky130_fd_sc_hd__decap_6
X_2672_ _0824_ _0830_ _0832_ VGND VGND VPWR VPWR _0833_ sky130_fd_sc_hd__o21ai_1
XFILLER_0_41_225 VGND VGND VPWR VPWR sky130_fd_sc_hd__fill_1
X_4411_ _2261_ VGND VGND VPWR VPWR _0086_ sky130_fd_sc_hd__inv_2
X_4342_ _2251_ VGND VGND VPWR VPWR _0027_ sky130_fd_sc_hd__inv_2
X_4273_ _1493_ VGND VGND VPWR VPWR _2220_ sky130_fd_sc_hd__inv_2
X_3224_ RF0.regs\[0\]\[24\] _0605_ _1358_ VGND VGND VPWR VPWR _1383_ sky130_fd_sc_hd__o21a_1
.ends
