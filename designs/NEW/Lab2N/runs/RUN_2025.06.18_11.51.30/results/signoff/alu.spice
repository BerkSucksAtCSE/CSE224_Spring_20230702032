* NGSPICE file created from alu.ext - technology: sky130A

* Black-box entry subcircuit for sky130_fd_sc_hd__tapvpwrvgnd_1 abstract view
.subckt sky130_fd_sc_hd__tapvpwrvgnd_1 VGND VPWR
.ends

* Black-box entry subcircuit for sky130_fd_sc_hd__decap_3 abstract view
.subckt sky130_fd_sc_hd__decap_3 VGND VNB VPB VPWR
.ends

* Black-box entry subcircuit for sky130_fd_sc_hd__fill_2 abstract view
.subckt sky130_fd_sc_hd__fill_2 VGND VNB VPB VPWR
.ends

* Black-box entry subcircuit for sky130_fd_sc_hd__fill_1 abstract view
.subckt sky130_fd_sc_hd__fill_1 VGND VNB VPB VPWR
.ends

* Black-box entry subcircuit for sky130_fd_sc_hd__nor3_1 abstract view
.subckt sky130_fd_sc_hd__nor3_1 A B C VGND VNB VPB VPWR Y
.ends

* Black-box entry subcircuit for sky130_fd_sc_hd__and2_1 abstract view
.subckt sky130_fd_sc_hd__and2_1 A B VGND VNB VPB VPWR X
.ends

* Black-box entry subcircuit for sky130_fd_sc_hd__buf_2 abstract view
.subckt sky130_fd_sc_hd__buf_2 A VGND VNB VPB VPWR X
.ends

* Black-box entry subcircuit for sky130_fd_sc_hd__o311a_1 abstract view
.subckt sky130_fd_sc_hd__o311a_1 A1 A2 A3 B1 C1 VGND VNB VPB VPWR X
.ends

* Black-box entry subcircuit for sky130_fd_sc_hd__nor2_1 abstract view
.subckt sky130_fd_sc_hd__nor2_1 A B VGND VNB VPB VPWR Y
.ends

* Black-box entry subcircuit for sky130_fd_sc_hd__decap_4 abstract view
.subckt sky130_fd_sc_hd__decap_4 VGND VNB VPB VPWR
.ends

* Black-box entry subcircuit for sky130_fd_sc_hd__and3_1 abstract view
.subckt sky130_fd_sc_hd__and3_1 A B C VGND VNB VPB VPWR X
.ends

* Black-box entry subcircuit for sky130_ef_sc_hd__decap_12 abstract view
.subckt sky130_ef_sc_hd__decap_12 VPWR VGND VPB VNB
.ends

* Black-box entry subcircuit for sky130_fd_sc_hd__decap_8 abstract view
.subckt sky130_fd_sc_hd__decap_8 VGND VNB VPB VPWR
.ends

* Black-box entry subcircuit for sky130_fd_sc_hd__decap_6 abstract view
.subckt sky130_fd_sc_hd__decap_6 VGND VNB VPB VPWR
.ends

* Black-box entry subcircuit for sky130_fd_sc_hd__inv_2 abstract view
.subckt sky130_fd_sc_hd__inv_2 A VGND VNB VPB VPWR Y
.ends

* Black-box entry subcircuit for sky130_fd_sc_hd__a21o_1 abstract view
.subckt sky130_fd_sc_hd__a21o_1 A1 A2 B1 VGND VNB VPB VPWR X
.ends

* Black-box entry subcircuit for sky130_fd_sc_hd__clkbuf_4 abstract view
.subckt sky130_fd_sc_hd__clkbuf_4 A VGND VNB VPB VPWR X
.ends

* Black-box entry subcircuit for sky130_fd_sc_hd__o21a_1 abstract view
.subckt sky130_fd_sc_hd__o21a_1 A1 A2 B1 VGND VNB VPB VPWR X
.ends

* Black-box entry subcircuit for sky130_fd_sc_hd__dfxtp_1 abstract view
.subckt sky130_fd_sc_hd__dfxtp_1 CLK D VGND VNB VPB VPWR Q
.ends

* Black-box entry subcircuit for sky130_fd_sc_hd__clkbuf_16 abstract view
.subckt sky130_fd_sc_hd__clkbuf_16 A VGND VNB VPB VPWR X
.ends

* Black-box entry subcircuit for sky130_fd_sc_hd__o211a_1 abstract view
.subckt sky130_fd_sc_hd__o211a_1 A1 A2 B1 C1 VGND VNB VPB VPWR X
.ends

* Black-box entry subcircuit for sky130_fd_sc_hd__a211o_1 abstract view
.subckt sky130_fd_sc_hd__a211o_1 A1 A2 B1 C1 VGND VNB VPB VPWR X
.ends

* Black-box entry subcircuit for sky130_fd_sc_hd__nand2_1 abstract view
.subckt sky130_fd_sc_hd__nand2_1 A B VGND VNB VPB VPWR Y
.ends

* Black-box entry subcircuit for sky130_fd_sc_hd__xnor2_1 abstract view
.subckt sky130_fd_sc_hd__xnor2_1 A B VGND VNB VPB VPWR Y
.ends

* Black-box entry subcircuit for sky130_fd_sc_hd__a211oi_1 abstract view
.subckt sky130_fd_sc_hd__a211oi_1 A1 A2 B1 C1 VGND VNB VPB VPWR Y
.ends

* Black-box entry subcircuit for sky130_fd_sc_hd__and2b_1 abstract view
.subckt sky130_fd_sc_hd__and2b_1 A_N B VGND VNB VPB VPWR X
.ends

* Black-box entry subcircuit for sky130_fd_sc_hd__buf_1 abstract view
.subckt sky130_fd_sc_hd__buf_1 A VGND VNB VPB VPWR X
.ends

* Black-box entry subcircuit for sky130_fd_sc_hd__a31oi_1 abstract view
.subckt sky130_fd_sc_hd__a31oi_1 A1 A2 A3 B1 VGND VNB VPB VPWR Y
.ends

* Black-box entry subcircuit for sky130_fd_sc_hd__or3_1 abstract view
.subckt sky130_fd_sc_hd__or3_1 A B C VGND VNB VPB VPWR X
.ends

* Black-box entry subcircuit for sky130_fd_sc_hd__a21bo_1 abstract view
.subckt sky130_fd_sc_hd__a21bo_1 A1 A2 B1_N VGND VNB VPB VPWR X
.ends

* Black-box entry subcircuit for sky130_fd_sc_hd__nand3b_1 abstract view
.subckt sky130_fd_sc_hd__nand3b_1 A_N B C VGND VNB VPB VPWR Y
.ends

* Black-box entry subcircuit for sky130_fd_sc_hd__a21oi_1 abstract view
.subckt sky130_fd_sc_hd__a21oi_1 A1 A2 B1 VGND VNB VPB VPWR Y
.ends

* Black-box entry subcircuit for sky130_fd_sc_hd__or2_1 abstract view
.subckt sky130_fd_sc_hd__or2_1 A B VGND VNB VPB VPWR X
.ends

* Black-box entry subcircuit for sky130_fd_sc_hd__dlymetal6s2s_1 abstract view
.subckt sky130_fd_sc_hd__dlymetal6s2s_1 A VGND VNB VPB VPWR X
.ends

* Black-box entry subcircuit for sky130_fd_sc_hd__or3_2 abstract view
.subckt sky130_fd_sc_hd__or3_2 A B C VGND VNB VPB VPWR X
.ends

* Black-box entry subcircuit for sky130_fd_sc_hd__xor2_1 abstract view
.subckt sky130_fd_sc_hd__xor2_1 A B VGND VNB VPB VPWR X
.ends

* Black-box entry subcircuit for sky130_fd_sc_hd__clkbuf_1 abstract view
.subckt sky130_fd_sc_hd__clkbuf_1 A VGND VNB VPB VPWR X
.ends

* Black-box entry subcircuit for sky130_fd_sc_hd__clkbuf_2 abstract view
.subckt sky130_fd_sc_hd__clkbuf_2 A VGND VNB VPB VPWR X
.ends

* Black-box entry subcircuit for sky130_fd_sc_hd__o221a_1 abstract view
.subckt sky130_fd_sc_hd__o221a_1 A1 A2 B1 B2 C1 VGND VNB VPB VPWR X
.ends

* Black-box entry subcircuit for sky130_fd_sc_hd__or2b_1 abstract view
.subckt sky130_fd_sc_hd__or2b_1 A B_N VGND VNB VPB VPWR X
.ends

* Black-box entry subcircuit for sky130_fd_sc_hd__o31a_1 abstract view
.subckt sky130_fd_sc_hd__o31a_1 A1 A2 A3 B1 VGND VNB VPB VPWR X
.ends

* Black-box entry subcircuit for sky130_fd_sc_hd__mux2_1 abstract view
.subckt sky130_fd_sc_hd__mux2_1 A0 A1 S VGND VNB VPB VPWR X
.ends

* Black-box entry subcircuit for sky130_fd_sc_hd__a32o_1 abstract view
.subckt sky130_fd_sc_hd__a32o_1 A1 A2 A3 B1 B2 VGND VNB VPB VPWR X
.ends

* Black-box entry subcircuit for sky130_fd_sc_hd__o21ai_1 abstract view
.subckt sky130_fd_sc_hd__o21ai_1 A1 A2 B1 VGND VNB VPB VPWR Y
.ends

.subckt alu VGND VPWR a[0] a[1] a[2] a[3] a[4] a[5] a[6] a[7] b[0] b[1] b[2] b[3]
+ b[4] b[5] b[6] b[7] clk result[0] result[1] result[2] result[3] result[4] result[5]
+ result[6] result[7] sel[0] sel[1]
XTAP_TAPCELL_ROW_8_44 VGND VPWR sky130_fd_sc_hd__tapvpwrvgnd_1
XFILLER_0_10_85 VGND VGND VPWR VPWR sky130_fd_sc_hd__decap_3
XFILLER_0_9_38 VGND VGND VPWR VPWR sky130_fd_sc_hd__fill_2
XFILLER_0_9_27 VGND VGND VPWR VPWR sky130_fd_sc_hd__fill_1
X_131_ net6 _050_ _051_ VGND VGND VPWR VPWR _052_ sky130_fd_sc_hd__nor3_1
X_114_ net3 _024_ VGND VGND VPWR VPWR _037_ sky130_fd_sc_hd__and2_1
Xoutput20 net20 VGND VGND VPWR VPWR result[1] sky130_fd_sc_hd__buf_2
XTAP_TAPCELL_ROW_2_35 VGND VPWR sky130_fd_sc_hd__tapvpwrvgnd_1
XPHY_EDGE_ROW_12_Right_12 VGND VGND VPWR VPWR sky130_fd_sc_hd__decap_3
X_130_ net12 net13 _030_ _013_ net14 VGND VGND VPWR VPWR _051_ sky130_fd_sc_hd__o311a_1
XFILLER_0_4_72 VGND VGND VPWR VPWR sky130_fd_sc_hd__fill_1
XFILLER_0_10_42 VGND VGND VPWR VPWR sky130_fd_sc_hd__fill_1
X_113_ _034_ _035_ VGND VGND VPWR VPWR _036_ sky130_fd_sc_hd__nor2_1
Xoutput21 net21 VGND VGND VPWR VPWR result[2] sky130_fd_sc_hd__buf_2
XPHY_EDGE_ROW_6_Right_6 VGND VGND VPWR VPWR sky130_fd_sc_hd__decap_3
XFILLER_0_6_29 VGND VGND VPWR VPWR sky130_fd_sc_hd__decap_4
XFILLER_0_10_54 VGND VGND VPWR VPWR sky130_fd_sc_hd__fill_2
XPHY_EDGE_ROW_12_Left_27 VGND VGND VPWR VPWR sky130_fd_sc_hd__decap_3
XFILLER_0_1_63 VGND VGND VPWR VPWR sky130_fd_sc_hd__fill_1
X_112_ net4 _031_ _032_ VGND VGND VPWR VPWR _035_ sky130_fd_sc_hd__and3_1
XFILLER_0_11_7 VPWR VGND VPWR VGND sky130_ef_sc_hd__decap_12
XFILLER_0_7_73 VGND VGND VPWR VPWR sky130_fd_sc_hd__fill_2
Xoutput22 net22 VGND VGND VPWR VPWR result[3] sky130_fd_sc_hd__buf_2
XPHY_EDGE_ROW_0_Left_15 VGND VGND VPWR VPWR sky130_fd_sc_hd__decap_3
XFILLER_0_4_41 VGND VGND VPWR VPWR sky130_fd_sc_hd__decap_8
XFILLER_0_4_85 VGND VGND VPWR VPWR sky130_fd_sc_hd__decap_6
X_111_ _033_ VGND VGND VPWR VPWR _034_ sky130_fd_sc_hd__inv_2
Xoutput23 net23 VGND VGND VPWR VPWR result[4] sky130_fd_sc_hd__buf_2
XFILLER_0_7_63 VGND VGND VPWR VPWR sky130_fd_sc_hd__fill_2
XFILLER_0_4_20 VGND VGND VPWR VPWR sky130_fd_sc_hd__decap_8
X_110_ _031_ _032_ net4 VGND VGND VPWR VPWR _033_ sky130_fd_sc_hd__a21o_1
Xoutput24 net24 VGND VGND VPWR VPWR result[5] sky130_fd_sc_hd__buf_2
XFILLER_0_7_31 VGND VGND VPWR VPWR sky130_fd_sc_hd__fill_2
XFILLER_0_13_89 VGND VGND VPWR VPWR sky130_fd_sc_hd__fill_2
XFILLER_0_10_46 VGND VGND VPWR VPWR sky130_fd_sc_hd__decap_8
XTAP_TAPCELL_ROW_5_39 VGND VPWR sky130_fd_sc_hd__tapvpwrvgnd_1
XFILLER_0_1_11 VGND VGND VPWR VPWR sky130_fd_sc_hd__fill_1
XFILLER_0_1_88 VGND VGND VPWR VPWR sky130_fd_sc_hd__decap_3
Xoutput25 net25 VGND VGND VPWR VPWR result[6] sky130_fd_sc_hd__clkbuf_4
XFILLER_0_13_46 VGND VGND VPWR VPWR sky130_fd_sc_hd__fill_1
XTAP_TAPCELL_ROW_12_49 VGND VPWR sky130_fd_sc_hd__tapvpwrvgnd_1
XFILLER_0_10_25 VGND VGND VPWR VPWR sky130_fd_sc_hd__decap_3
XPHY_EDGE_ROW_4_Left_19 VGND VGND VPWR VPWR sky130_fd_sc_hd__decap_3
XFILLER_0_4_66 VGND VGND VPWR VPWR sky130_fd_sc_hd__decap_6
X_099_ net9 net10 _013_ VGND VGND VPWR VPWR _023_ sky130_fd_sc_hd__o21a_1
Xoutput26 net26 VGND VGND VPWR VPWR result[7] sky130_fd_sc_hd__clkbuf_4
XPHY_EDGE_ROW_7_Left_22 VGND VGND VPWR VPWR sky130_fd_sc_hd__decap_3
XPHY_EDGE_ROW_1_Right_1 VGND VGND VPWR VPWR sky130_fd_sc_hd__decap_3
XTAP_TAPCELL_ROW_0_30 VGND VPWR sky130_fd_sc_hd__tapvpwrvgnd_1
XFILLER_0_4_78 VGND VGND VPWR VPWR sky130_fd_sc_hd__decap_6
X_167_ clknet_1_1__leaf_clk _079_ VGND VGND VPWR VPWR net26 sky130_fd_sc_hd__dfxtp_1
X_098_ _011_ _017_ _016_ VGND VGND VPWR VPWR _022_ sky130_fd_sc_hd__a21o_1
XTAP_TAPCELL_ROW_6_40 VGND VPWR sky130_fd_sc_hd__tapvpwrvgnd_1
XFILLER_0_1_57 VGND VGND VPWR VPWR sky130_fd_sc_hd__decap_3
Xclkbuf_0_clk clk VGND VGND VPWR VPWR clknet_0_clk sky130_fd_sc_hd__clkbuf_16
XFILLER_0_4_13 VGND VGND VPWR VPWR sky130_fd_sc_hd__decap_3
X_166_ clknet_1_1__leaf_clk _078_ VGND VGND VPWR VPWR net25 sky130_fd_sc_hd__dfxtp_1
X_097_ net10 _007_ _020_ _021_ VGND VGND VPWR VPWR _073_ sky130_fd_sc_hd__o211a_1
XFILLER_0_10_38 VGND VGND VPWR VPWR sky130_fd_sc_hd__decap_4
XTAP_TAPCELL_ROW_0_31 VGND VPWR sky130_fd_sc_hd__tapvpwrvgnd_1
X_149_ net15 net7 _068_ net18 VGND VGND VPWR VPWR _069_ sky130_fd_sc_hd__o211a_1
XTAP_TAPCELL_ROW_6_41 VGND VPWR sky130_fd_sc_hd__tapvpwrvgnd_1
XTAP_TAPCELL_ROW_13_51 VGND VPWR sky130_fd_sc_hd__tapvpwrvgnd_1
XTAP_TAPCELL_ROW_0_32 VGND VPWR sky130_fd_sc_hd__tapvpwrvgnd_1
XFILLER_0_5_3 VGND VGND VPWR VPWR sky130_fd_sc_hd__fill_2
X_096_ net17 net10 net2 _006_ VGND VGND VPWR VPWR _021_ sky130_fd_sc_hd__a211o_1
X_148_ net15 net7 net17 VGND VGND VPWR VPWR _068_ sky130_fd_sc_hd__a21o_1
X_165_ clknet_1_0__leaf_clk _077_ VGND VGND VPWR VPWR net24 sky130_fd_sc_hd__dfxtp_1
XFILLER_0_1_37 VGND VGND VPWR VPWR sky130_fd_sc_hd__decap_3
XFILLER_0_7_47 VGND VGND VPWR VPWR sky130_fd_sc_hd__decap_3
XFILLER_0_7_7 VGND VGND VPWR VPWR sky130_fd_sc_hd__decap_8
XPHY_EDGE_ROW_5_Right_5 VGND VGND VPWR VPWR sky130_fd_sc_hd__decap_3
X_095_ _006_ _019_ VGND VGND VPWR VPWR _020_ sky130_fd_sc_hd__nand2_1
XFILLER_0_10_29 VGND VGND VPWR VPWR sky130_fd_sc_hd__decap_3
XFILLER_0_10_18 VGND VGND VPWR VPWR sky130_fd_sc_hd__decap_4
XFILLER_0_1_27 VGND VGND VPWR VPWR sky130_fd_sc_hd__decap_3
X_164_ clknet_1_0__leaf_clk _076_ VGND VGND VPWR VPWR net23 sky130_fd_sc_hd__dfxtp_1
Xoutput19 net19 VGND VGND VPWR VPWR result[0] sky130_fd_sc_hd__clkbuf_4
XPHY_EDGE_ROW_11_Left_26 VGND VGND VPWR VPWR sky130_fd_sc_hd__decap_3
X_147_ _063_ _066_ VGND VGND VPWR VPWR _067_ sky130_fd_sc_hd__xnor2_1
XPHY_EDGE_ROW_11_Right_11 VGND VGND VPWR VPWR sky130_fd_sc_hd__decap_3
XFILLER_0_14_72 VPWR VGND VPWR VGND sky130_ef_sc_hd__decap_12
XFILLER_0_4_49 VGND VGND VPWR VPWR sky130_fd_sc_hd__decap_3
XFILLER_0_11_51 VGND VGND VPWR VPWR sky130_fd_sc_hd__fill_2
X_094_ _011_ _018_ VGND VGND VPWR VPWR _019_ sky130_fd_sc_hd__xnor2_1
X_163_ clknet_1_0__leaf_clk _075_ VGND VGND VPWR VPWR net22 sky130_fd_sc_hd__dfxtp_1
X_146_ _052_ _065_ VGND VGND VPWR VPWR _066_ sky130_fd_sc_hd__nor2_1
X_129_ net13 _013_ _042_ net14 VGND VGND VPWR VPWR _050_ sky130_fd_sc_hd__a211oi_1
XFILLER_0_8_81 VGND VGND VPWR VPWR sky130_fd_sc_hd__decap_3
XFILLER_0_14_51 VGND VGND VPWR VPWR sky130_fd_sc_hd__decap_4
X_093_ _016_ _017_ VGND VGND VPWR VPWR _018_ sky130_fd_sc_hd__and2b_1
X_162_ clknet_1_0__leaf_clk _074_ VGND VGND VPWR VPWR net21 sky130_fd_sc_hd__dfxtp_1
XFILLER_0_3_3 VGND VGND VPWR VPWR sky130_fd_sc_hd__decap_6
Xinput1 a[0] VGND VGND VPWR VPWR net1 sky130_fd_sc_hd__buf_1
X_145_ _033_ _044_ _045_ _064_ VGND VGND VPWR VPWR _065_ sky130_fd_sc_hd__a31oi_1
XPHY_EDGE_ROW_9_Right_9 VGND VGND VPWR VPWR sky130_fd_sc_hd__decap_3
XFILLER_0_7_39 VGND VGND VPWR VPWR sky130_fd_sc_hd__decap_8
X_128_ _006_ _047_ _049_ VGND VGND VPWR VPWR _076_ sky130_fd_sc_hd__a21o_1
XFILLER_0_14_85 VGND VGND VPWR VPWR sky130_fd_sc_hd__fill_2
XFILLER_0_14_41 VGND VGND VPWR VPWR sky130_fd_sc_hd__decap_4
XTAP_TAPCELL_ROW_9_45 VGND VPWR sky130_fd_sc_hd__tapvpwrvgnd_1
XFILLER_0_4_29 VPWR VGND VPWR VGND sky130_ef_sc_hd__decap_12
X_161_ clknet_1_1__leaf_clk _073_ VGND VGND VPWR VPWR net20 sky130_fd_sc_hd__dfxtp_1
XFILLER_0_11_31 VPWR VGND VPWR VGND sky130_ef_sc_hd__decap_12
Xinput2 a[1] VGND VGND VPWR VPWR net2 sky130_fd_sc_hd__buf_1
X_092_ net2 _014_ _015_ VGND VGND VPWR VPWR _017_ sky130_fd_sc_hd__or3_1
XFILLER_0_1_19 VGND VGND VPWR VPWR sky130_fd_sc_hd__decap_8
X_127_ net13 net5 _048_ net18 VGND VGND VPWR VPWR _049_ sky130_fd_sc_hd__o211a_1
X_144_ net5 _043_ _053_ VGND VGND VPWR VPWR _064_ sky130_fd_sc_hd__a21bo_1
XTAP_TAPCELL_ROW_3_36 VGND VPWR sky130_fd_sc_hd__tapvpwrvgnd_1
XPHY_EDGE_ROW_3_Left_18 VGND VGND VPWR VPWR sky130_fd_sc_hd__decap_3
X_160_ clknet_1_1__leaf_clk _072_ VGND VGND VPWR VPWR net19 sky130_fd_sc_hd__dfxtp_1
XFILLER_0_11_43 VGND VGND VPWR VPWR sky130_fd_sc_hd__decap_8
X_143_ _061_ _062_ VGND VGND VPWR VPWR _063_ sky130_fd_sc_hd__nand2_1
XTAP_TAPCELL_ROW_10_46 VGND VPWR sky130_fd_sc_hd__tapvpwrvgnd_1
X_091_ _014_ _015_ net2 VGND VGND VPWR VPWR _016_ sky130_fd_sc_hd__o21a_1
Xinput3 a[2] VGND VGND VPWR VPWR net3 sky130_fd_sc_hd__buf_1
XFILLER_0_7_19 VPWR VGND VPWR VGND sky130_ef_sc_hd__decap_12
XPHY_EDGE_ROW_6_Left_21 VGND VGND VPWR VPWR sky130_fd_sc_hd__decap_3
XPHY_EDGE_ROW_0_Right_0 VGND VGND VPWR VPWR sky130_fd_sc_hd__decap_3
X_126_ net13 net5 net17 VGND VGND VPWR VPWR _048_ sky130_fd_sc_hd__a21o_1
XFILLER_0_2_85 VGND VGND VPWR VPWR sky130_fd_sc_hd__fill_2
XFILLER_0_14_6 VGND VGND VPWR VPWR sky130_fd_sc_hd__decap_4
XFILLER_0_8_73 VGND VGND VPWR VPWR sky130_fd_sc_hd__decap_8
X_109_ net12 _013_ _030_ VGND VGND VPWR VPWR _032_ sky130_fd_sc_hd__nand3b_1
XTAP_TAPCELL_ROW_10_47 VGND VPWR sky130_fd_sc_hd__tapvpwrvgnd_1
X_090_ net9 _013_ net10 VGND VGND VPWR VPWR _015_ sky130_fd_sc_hd__a21oi_1
XFILLER_0_1_3 VGND VGND VPWR VPWR sky130_fd_sc_hd__fill_1
Xinput4 a[3] VGND VGND VPWR VPWR net4 sky130_fd_sc_hd__buf_1
X_142_ net7 _060_ VGND VGND VPWR VPWR _062_ sky130_fd_sc_hd__or2_1
X_125_ _044_ _046_ VGND VGND VPWR VPWR _047_ sky130_fd_sc_hd__xnor2_1
XFILLER_0_8_85 VGND VGND VPWR VPWR sky130_fd_sc_hd__decap_3
XFILLER_0_8_41 VGND VGND VPWR VPWR sky130_fd_sc_hd__decap_6
X_108_ _013_ _030_ net12 VGND VGND VPWR VPWR _031_ sky130_fd_sc_hd__a21bo_1
XFILLER_0_14_55 VGND VGND VPWR VPWR sky130_fd_sc_hd__fill_1
XFILLER_0_5_20 VGND VGND VPWR VPWR sky130_fd_sc_hd__decap_3
X_141_ net7 _060_ VGND VGND VPWR VPWR _061_ sky130_fd_sc_hd__nand2_1
XFILLER_0_5_86 VGND VGND VPWR VPWR sky130_fd_sc_hd__fill_2
Xinput5 a[4] VGND VGND VPWR VPWR net5 sky130_fd_sc_hd__dlymetal6s2s_1
XFILLER_0_2_43 VPWR VGND VPWR VGND sky130_ef_sc_hd__decap_12
X_124_ _033_ _045_ VGND VGND VPWR VPWR _046_ sky130_fd_sc_hd__nand2_1
XFILLER_0_8_20 VGND VGND VPWR VPWR sky130_fd_sc_hd__fill_1
X_107_ net9 net10 net11 VGND VGND VPWR VPWR _030_ sky130_fd_sc_hd__or3_2
XPHY_EDGE_ROW_14_Right_14 VGND VGND VPWR VPWR sky130_fd_sc_hd__decap_3
X_140_ net15 _059_ VGND VGND VPWR VPWR _060_ sky130_fd_sc_hd__xnor2_1
Xinput6 a[5] VGND VGND VPWR VPWR net6 sky130_fd_sc_hd__buf_1
X_106_ net11 _007_ _028_ _029_ VGND VGND VPWR VPWR _074_ sky130_fd_sc_hd__o211a_1
X_123_ _022_ _025_ _035_ _037_ VGND VGND VPWR VPWR _045_ sky130_fd_sc_hd__a211o_1
XPHY_EDGE_ROW_4_Right_4 VGND VGND VPWR VPWR sky130_fd_sc_hd__decap_3
XFILLER_0_12_6 VGND VGND VPWR VPWR sky130_fd_sc_hd__decap_4
XFILLER_0_3_9 VGND VGND VPWR VPWR sky130_fd_sc_hd__fill_1
XFILLER_0_11_69 VGND VGND VPWR VPWR sky130_fd_sc_hd__decap_6
Xinput7 a[6] VGND VGND VPWR VPWR net7 sky130_fd_sc_hd__buf_1
Xinput10 b[1] VGND VGND VPWR VPWR net10 sky130_fd_sc_hd__dlymetal6s2s_1
XPHY_EDGE_ROW_10_Left_25 VGND VGND VPWR VPWR sky130_fd_sc_hd__decap_3
X_122_ net5 _043_ VGND VGND VPWR VPWR _044_ sky130_fd_sc_hd__xor2_1
X_105_ net17 net11 net3 _006_ VGND VGND VPWR VPWR _029_ sky130_fd_sc_hd__a211o_1
Xinput8 a[7] VGND VGND VPWR VPWR net8 sky130_fd_sc_hd__clkbuf_1
Xinput11 b[2] VGND VGND VPWR VPWR net11 sky130_fd_sc_hd__buf_1
X_104_ _026_ _027_ net18 VGND VGND VPWR VPWR _028_ sky130_fd_sc_hd__a21o_1
X_121_ net13 _042_ VGND VGND VPWR VPWR _043_ sky130_fd_sc_hd__xnor2_1
Xclkbuf_1_0__f_clk clknet_0_clk VGND VGND VPWR VPWR clknet_1_0__leaf_clk sky130_fd_sc_hd__clkbuf_16
Xinput9 b[0] VGND VGND VPWR VPWR net9 sky130_fd_sc_hd__dlymetal6s2s_1
XFILLER_0_5_57 VPWR VGND VPWR VGND sky130_ef_sc_hd__decap_12
XPHY_EDGE_ROW_10_Right_10 VGND VGND VPWR VPWR sky130_fd_sc_hd__decap_3
Xinput12 b[3] VGND VGND VPWR VPWR net12 sky130_fd_sc_hd__dlymetal6s2s_1
X_120_ net12 _030_ _013_ VGND VGND VPWR VPWR _042_ sky130_fd_sc_hd__o21a_1
XFILLER_0_14_16 VPWR VGND VPWR VGND sky130_ef_sc_hd__decap_12
X_103_ _022_ _025_ VGND VGND VPWR VPWR _027_ sky130_fd_sc_hd__or2_1
XFILLER_0_10_6 VPWR VGND VPWR VGND sky130_ef_sc_hd__decap_12
XPHY_EDGE_ROW_8_Right_8 VGND VGND VPWR VPWR sky130_fd_sc_hd__decap_3
XFILLER_0_5_69 VGND VGND VPWR VPWR sky130_fd_sc_hd__fill_2
XFILLER_0_5_36 VPWR VGND VPWR VGND sky130_ef_sc_hd__decap_12
XTAP_TAPCELL_ROW_7_42 VGND VPWR sky130_fd_sc_hd__tapvpwrvgnd_1
X_102_ _022_ _025_ VGND VGND VPWR VPWR _026_ sky130_fd_sc_hd__nand2_1
Xinput13 b[4] VGND VGND VPWR VPWR net13 sky130_fd_sc_hd__clkbuf_2
XPHY_EDGE_ROW_14_Left_29 VGND VGND VPWR VPWR sky130_fd_sc_hd__decap_3
XFILLER_0_8_47 VGND VGND VPWR VPWR sky130_fd_sc_hd__fill_1
XTAP_TAPCELL_ROW_14_52 VGND VPWR sky130_fd_sc_hd__tapvpwrvgnd_1
XFILLER_0_8_3 VGND VGND VPWR VPWR sky130_fd_sc_hd__fill_2
XFILLER_0_5_48 VGND VGND VPWR VPWR sky130_fd_sc_hd__decap_8
XTAP_TAPCELL_ROW_1_33 VGND VPWR sky130_fd_sc_hd__tapvpwrvgnd_1
Xinput14 b[5] VGND VGND VPWR VPWR net14 sky130_fd_sc_hd__buf_1
XPHY_EDGE_ROW_2_Left_17 VGND VGND VPWR VPWR sky130_fd_sc_hd__decap_3
X_101_ net3 _024_ VGND VGND VPWR VPWR _025_ sky130_fd_sc_hd__xor2_1
XPHY_EDGE_ROW_5_Left_20 VGND VGND VPWR VPWR sky130_fd_sc_hd__decap_3
XFILLER_0_14_29 VPWR VGND VPWR VGND sky130_ef_sc_hd__decap_12
XTAP_TAPCELL_ROW_14_53 VGND VPWR sky130_fd_sc_hd__tapvpwrvgnd_1
XFILLER_0_11_19 VPWR VGND VPWR VGND sky130_ef_sc_hd__decap_12
XFILLER_0_12_73 VGND VGND VPWR VPWR sky130_fd_sc_hd__fill_1
Xinput15 b[6] VGND VGND VPWR VPWR net15 sky130_fd_sc_hd__buf_1
X_100_ net11 _023_ VGND VGND VPWR VPWR _024_ sky130_fd_sc_hd__xnor2_1
XTAP_TAPCELL_ROW_14_54 VGND VPWR sky130_fd_sc_hd__tapvpwrvgnd_1
XFILLER_0_0_83 VGND VGND VPWR VPWR sky130_fd_sc_hd__fill_1
XFILLER_0_12_85 VGND VGND VPWR VPWR sky130_fd_sc_hd__decap_6
X_159_ _007_ _070_ _004_ net18 _005_ VGND VGND VPWR VPWR _079_ sky130_fd_sc_hd__o221a_1
Xinput16 b[7] VGND VGND VPWR VPWR net16 sky130_fd_sc_hd__clkbuf_1
XFILLER_0_0_51 VGND VGND VPWR VPWR sky130_fd_sc_hd__fill_1
XFILLER_0_6_50 VGND VGND VPWR VPWR sky130_fd_sc_hd__fill_1
Xinput17 sel[0] VGND VGND VPWR VPWR net17 sky130_fd_sc_hd__clkbuf_2
X_158_ net18 _000_ VGND VGND VPWR VPWR _005_ sky130_fd_sc_hd__nand2_1
XPHY_EDGE_ROW_9_Left_24 VGND VGND VPWR VPWR sky130_fd_sc_hd__decap_3
X_089_ net9 net10 _013_ VGND VGND VPWR VPWR _014_ sky130_fd_sc_hd__and3_1
XFILLER_0_8_29 VPWR VGND VPWR VGND sky130_ef_sc_hd__decap_12
Xclkbuf_1_1__f_clk clknet_0_clk VGND VGND VPWR VPWR clknet_1_1__leaf_clk sky130_fd_sc_hd__clkbuf_16
XFILLER_0_0_63 VPWR VGND VPWR VGND sky130_ef_sc_hd__decap_12
XFILLER_0_0_85 VGND VGND VPWR VPWR sky130_fd_sc_hd__decap_6
XPHY_EDGE_ROW_3_Right_3 VGND VGND VPWR VPWR sky130_fd_sc_hd__decap_3
X_157_ _071_ _003_ VGND VGND VPWR VPWR _004_ sky130_fd_sc_hd__xnor2_1
Xinput18 sel[1] VGND VGND VPWR VPWR net18 sky130_fd_sc_hd__buf_2
X_088_ _012_ VGND VGND VPWR VPWR _013_ sky130_fd_sc_hd__buf_2
XFILLER_0_0_75 VGND VGND VPWR VPWR sky130_fd_sc_hd__decap_8
XTAP_TAPCELL_ROW_4_37 VGND VPWR sky130_fd_sc_hd__tapvpwrvgnd_1
XPHY_EDGE_ROW_13_Right_13 VGND VGND VPWR VPWR sky130_fd_sc_hd__decap_3
XFILLER_0_6_85 VGND VGND VPWR VPWR sky130_fd_sc_hd__fill_2
X_156_ _001_ _002_ VGND VGND VPWR VPWR _003_ sky130_fd_sc_hd__xnor2_1
X_087_ net18 net17 VGND VGND VPWR VPWR _012_ sky130_fd_sc_hd__or2b_1
XTAP_TAPCELL_ROW_4_38 VGND VPWR sky130_fd_sc_hd__tapvpwrvgnd_1
X_139_ net13 net14 _042_ _013_ VGND VGND VPWR VPWR _059_ sky130_fd_sc_hd__o31a_1
XTAP_TAPCELL_ROW_11_48 VGND VPWR sky130_fd_sc_hd__tapvpwrvgnd_1
X_086_ net1 net9 VGND VGND VPWR VPWR _011_ sky130_fd_sc_hd__or2b_1
X_155_ net15 _013_ _059_ VGND VGND VPWR VPWR _002_ sky130_fd_sc_hd__a21o_1
XFILLER_0_3_32 VGND VGND VPWR VPWR sky130_fd_sc_hd__fill_1
XFILLER_0_9_86 VGND VGND VPWR VPWR sky130_fd_sc_hd__fill_1
X_138_ _006_ _056_ _058_ VGND VGND VPWR VPWR _077_ sky130_fd_sc_hd__a21o_1
XFILLER_0_0_55 VGND VGND VPWR VPWR sky130_fd_sc_hd__fill_1
XPHY_EDGE_ROW_7_Right_7 VGND VGND VPWR VPWR sky130_fd_sc_hd__decap_3
XFILLER_0_6_76 VGND VGND VPWR VPWR sky130_fd_sc_hd__decap_8
X_154_ _000_ _070_ VGND VGND VPWR VPWR _001_ sky130_fd_sc_hd__nor2_1
X_085_ _010_ VGND VGND VPWR VPWR _072_ sky130_fd_sc_hd__clkbuf_1
XFILLER_0_3_88 VGND VGND VPWR VPWR sky130_fd_sc_hd__decap_3
XPHY_EDGE_ROW_13_Left_28 VGND VGND VPWR VPWR sky130_fd_sc_hd__decap_3
X_137_ net14 net6 _057_ net18 VGND VGND VPWR VPWR _058_ sky130_fd_sc_hd__o211a_1
XFILLER_0_6_33 VGND VGND VPWR VPWR sky130_fd_sc_hd__fill_1
XPHY_EDGE_ROW_1_Left_16 VGND VGND VPWR VPWR sky130_fd_sc_hd__decap_3
X_084_ net18 _008_ _009_ VGND VGND VPWR VPWR _010_ sky130_fd_sc_hd__mux2_1
X_153_ net16 net8 VGND VGND VPWR VPWR _000_ sky130_fd_sc_hd__nor2_1
XFILLER_0_9_55 VGND VGND VPWR VPWR sky130_fd_sc_hd__fill_1
X_136_ net14 net6 net17 VGND VGND VPWR VPWR _057_ sky130_fd_sc_hd__a21o_1
XFILLER_0_0_57 VGND VGND VPWR VPWR sky130_fd_sc_hd__fill_2
XFILLER_0_6_9 VGND VGND VPWR VPWR sky130_fd_sc_hd__fill_2
X_119_ _006_ _039_ _041_ VGND VGND VPWR VPWR _075_ sky130_fd_sc_hd__a21o_1
XFILLER_0_13_3 VGND VGND VPWR VPWR sky130_fd_sc_hd__fill_1
XFILLER_0_12_48 VGND VGND VPWR VPWR sky130_fd_sc_hd__fill_2
XFILLER_0_12_15 VPWR VGND VPWR VGND sky130_ef_sc_hd__decap_12
XFILLER_0_2_3 VGND VGND VPWR VPWR sky130_fd_sc_hd__decap_3
XTAP_TAPCELL_ROW_12_50 VGND VPWR sky130_fd_sc_hd__tapvpwrvgnd_1
X_083_ net1 net9 VGND VGND VPWR VPWR _009_ sky130_fd_sc_hd__nand2_1
X_152_ _052_ _063_ _065_ _061_ VGND VGND VPWR VPWR _071_ sky130_fd_sc_hd__o31a_1
XFILLER_0_3_24 VGND VGND VPWR VPWR sky130_fd_sc_hd__decap_3
XFILLER_0_9_78 VGND VGND VPWR VPWR sky130_fd_sc_hd__decap_8
X_135_ _054_ _055_ VGND VGND VPWR VPWR _056_ sky130_fd_sc_hd__xor2_1
X_118_ net12 net4 _040_ net18 VGND VGND VPWR VPWR _041_ sky130_fd_sc_hd__o211a_1
XFILLER_0_12_27 VGND VGND VPWR VPWR sky130_fd_sc_hd__fill_1
XFILLER_0_3_36 VGND VGND VPWR VPWR sky130_fd_sc_hd__decap_8
X_151_ net16 net8 VGND VGND VPWR VPWR _070_ sky130_fd_sc_hd__and2_1
X_082_ net1 net9 _007_ VGND VGND VPWR VPWR _008_ sky130_fd_sc_hd__o21a_1
XFILLER_0_0_15 VGND VGND VPWR VPWR sky130_fd_sc_hd__fill_2
X_134_ _033_ _044_ _045_ _043_ net5 VGND VGND VPWR VPWR _055_ sky130_fd_sc_hd__a32o_1
XFILLER_0_10_71 VGND VGND VPWR VPWR sky130_fd_sc_hd__fill_2
XFILLER_0_9_13 VGND VGND VPWR VPWR sky130_fd_sc_hd__fill_1
XFILLER_0_1_80 VGND VGND VPWR VPWR sky130_fd_sc_hd__decap_8
X_117_ net12 net4 net17 VGND VGND VPWR VPWR _040_ sky130_fd_sc_hd__a21o_1
XFILLER_0_6_69 VGND VGND VPWR VPWR sky130_fd_sc_hd__fill_1
XFILLER_0_6_58 VGND VGND VPWR VPWR sky130_fd_sc_hd__decap_4
XFILLER_0_6_25 VGND VGND VPWR VPWR sky130_fd_sc_hd__decap_3
X_150_ _006_ _067_ _069_ VGND VGND VPWR VPWR _078_ sky130_fd_sc_hd__a21o_1
X_081_ _006_ net17 VGND VGND VPWR VPWR _007_ sky130_fd_sc_hd__or2_1
XFILLER_0_10_83 VGND VGND VPWR VPWR sky130_fd_sc_hd__fill_1
XPHY_EDGE_ROW_8_Left_23 VGND VGND VPWR VPWR sky130_fd_sc_hd__decap_3
X_133_ _052_ _053_ VGND VGND VPWR VPWR _054_ sky130_fd_sc_hd__and2b_1
XFILLER_0_0_27 VGND VGND VPWR VPWR sky130_fd_sc_hd__fill_1
X_116_ _036_ _038_ VGND VGND VPWR VPWR _039_ sky130_fd_sc_hd__xnor2_1
XPHY_EDGE_ROW_2_Right_2 VGND VGND VPWR VPWR sky130_fd_sc_hd__decap_3
XFILLER_0_12_29 VGND VGND VPWR VPWR sky130_fd_sc_hd__decap_3
XFILLER_0_3_16 VGND VGND VPWR VPWR sky130_fd_sc_hd__decap_8
X_080_ net18 VGND VGND VPWR VPWR _006_ sky130_fd_sc_hd__inv_2
XTAP_TAPCELL_ROW_8_43 VGND VPWR sky130_fd_sc_hd__tapvpwrvgnd_1
XFILLER_0_0_3 VPWR VGND VPWR VGND sky130_ef_sc_hd__decap_12
X_132_ _050_ _051_ net6 VGND VGND VPWR VPWR _053_ sky130_fd_sc_hd__o21ai_1
XFILLER_0_0_39 VPWR VGND VPWR VGND sky130_ef_sc_hd__decap_12
X_115_ _022_ _025_ _037_ VGND VGND VPWR VPWR _038_ sky130_fd_sc_hd__a21oi_1
XTAP_TAPCELL_ROW_2_34 VGND VPWR sky130_fd_sc_hd__tapvpwrvgnd_1
.ends
