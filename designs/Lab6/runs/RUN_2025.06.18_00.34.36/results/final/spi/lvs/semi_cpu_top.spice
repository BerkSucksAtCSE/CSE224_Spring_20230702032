* NGSPICE file created from semi_cpu_top.ext - technology: sky130A

* Black-box entry subcircuit for sky130_fd_sc_hd__nand2_1 abstract view
.subckt sky130_fd_sc_hd__nand2_1 A B VGND VNB VPB VPWR Y
.ends

* Black-box entry subcircuit for sky130_fd_sc_hd__o21a_1 abstract view
.subckt sky130_fd_sc_hd__o21a_1 A1 A2 B1 VGND VNB VPB VPWR X
.ends

* Black-box entry subcircuit for sky130_fd_sc_hd__tapvpwrvgnd_1 abstract view
.subckt sky130_fd_sc_hd__tapvpwrvgnd_1 VGND VPWR
.ends

* Black-box entry subcircuit for sky130_fd_sc_hd__fill_1 abstract view
.subckt sky130_fd_sc_hd__fill_1 VGND VNB VPB VPWR
.ends

* Black-box entry subcircuit for sky130_fd_sc_hd__clkbuf_1 abstract view
.subckt sky130_fd_sc_hd__clkbuf_1 A VGND VNB VPB VPWR X
.ends

* Black-box entry subcircuit for sky130_fd_sc_hd__fill_2 abstract view
.subckt sky130_fd_sc_hd__fill_2 VGND VNB VPB VPWR
.ends

* Black-box entry subcircuit for sky130_ef_sc_hd__decap_12 abstract view
.subckt sky130_ef_sc_hd__decap_12 VPWR VGND VPB VNB
.ends

* Black-box entry subcircuit for sky130_fd_sc_hd__inv_2 abstract view
.subckt sky130_fd_sc_hd__inv_2 A VGND VNB VPB VPWR Y
.ends

* Black-box entry subcircuit for sky130_fd_sc_hd__decap_8 abstract view
.subckt sky130_fd_sc_hd__decap_8 VGND VNB VPB VPWR
.ends

* Black-box entry subcircuit for sky130_fd_sc_hd__decap_3 abstract view
.subckt sky130_fd_sc_hd__decap_3 VGND VNB VPB VPWR
.ends

* Black-box entry subcircuit for sky130_fd_sc_hd__clkbuf_8 abstract view
.subckt sky130_fd_sc_hd__clkbuf_8 A VGND VNB VPB VPWR X
.ends

* Black-box entry subcircuit for sky130_fd_sc_hd__mux2_1 abstract view
.subckt sky130_fd_sc_hd__mux2_1 A0 A1 S VGND VNB VPB VPWR X
.ends

* Black-box entry subcircuit for sky130_fd_sc_hd__xnor2_4 abstract view
.subckt sky130_fd_sc_hd__xnor2_4 A B VGND VNB VPB VPWR Y
.ends

* Black-box entry subcircuit for sky130_fd_sc_hd__decap_4 abstract view
.subckt sky130_fd_sc_hd__decap_4 VGND VNB VPB VPWR
.ends

* Black-box entry subcircuit for sky130_fd_sc_hd__decap_6 abstract view
.subckt sky130_fd_sc_hd__decap_6 VGND VNB VPB VPWR
.ends

* Black-box entry subcircuit for sky130_fd_sc_hd__a221o_1 abstract view
.subckt sky130_fd_sc_hd__a221o_1 A1 A2 B1 B2 C1 VGND VNB VPB VPWR X
.ends

* Black-box entry subcircuit for sky130_fd_sc_hd__xor2_1 abstract view
.subckt sky130_fd_sc_hd__xor2_1 A B VGND VNB VPB VPWR X
.ends

* Black-box entry subcircuit for sky130_fd_sc_hd__dfrtp_1 abstract view
.subckt sky130_fd_sc_hd__dfrtp_1 CLK D RESET_B VGND VNB VPB VPWR Q
.ends

* Black-box entry subcircuit for sky130_fd_sc_hd__buf_4 abstract view
.subckt sky130_fd_sc_hd__buf_4 A VGND VNB VPB VPWR X
.ends

* Black-box entry subcircuit for sky130_fd_sc_hd__a21oi_1 abstract view
.subckt sky130_fd_sc_hd__a21oi_1 A1 A2 B1 VGND VNB VPB VPWR Y
.ends

* Black-box entry subcircuit for sky130_fd_sc_hd__nor2_1 abstract view
.subckt sky130_fd_sc_hd__nor2_1 A B VGND VNB VPB VPWR Y
.ends

* Black-box entry subcircuit for sky130_fd_sc_hd__dlygate4sd3_1 abstract view
.subckt sky130_fd_sc_hd__dlygate4sd3_1 A VGND VNB VPB VPWR X
.ends

* Black-box entry subcircuit for sky130_fd_sc_hd__o21ai_1 abstract view
.subckt sky130_fd_sc_hd__o21ai_1 A1 A2 B1 VGND VNB VPB VPWR Y
.ends

* Black-box entry subcircuit for sky130_fd_sc_hd__a2111o_1 abstract view
.subckt sky130_fd_sc_hd__a2111o_1 A1 A2 B1 C1 D1 VGND VNB VPB VPWR X
.ends

* Black-box entry subcircuit for sky130_fd_sc_hd__a221oi_4 abstract view
.subckt sky130_fd_sc_hd__a221oi_4 A1 A2 B1 B2 C1 VGND VNB VPB VPWR Y
.ends

* Black-box entry subcircuit for sky130_fd_sc_hd__and2_1 abstract view
.subckt sky130_fd_sc_hd__and2_1 A B VGND VNB VPB VPWR X
.ends

* Black-box entry subcircuit for sky130_fd_sc_hd__a22o_1 abstract view
.subckt sky130_fd_sc_hd__a22o_1 A1 A2 B1 B2 VGND VNB VPB VPWR X
.ends

* Black-box entry subcircuit for sky130_fd_sc_hd__o32a_1 abstract view
.subckt sky130_fd_sc_hd__o32a_1 A1 A2 A3 B1 B2 VGND VNB VPB VPWR X
.ends

* Black-box entry subcircuit for sky130_fd_sc_hd__xnor2_2 abstract view
.subckt sky130_fd_sc_hd__xnor2_2 A B VGND VNB VPB VPWR Y
.ends

* Black-box entry subcircuit for sky130_fd_sc_hd__a21o_1 abstract view
.subckt sky130_fd_sc_hd__a21o_1 A1 A2 B1 VGND VNB VPB VPWR X
.ends

* Black-box entry subcircuit for sky130_fd_sc_hd__dfxtp_1 abstract view
.subckt sky130_fd_sc_hd__dfxtp_1 CLK D VGND VNB VPB VPWR Q
.ends

* Black-box entry subcircuit for sky130_fd_sc_hd__buf_2 abstract view
.subckt sky130_fd_sc_hd__buf_2 A VGND VNB VPB VPWR X
.ends

* Black-box entry subcircuit for sky130_fd_sc_hd__or2_1 abstract view
.subckt sky130_fd_sc_hd__or2_1 A B VGND VNB VPB VPWR X
.ends

* Black-box entry subcircuit for sky130_fd_sc_hd__or3b_4 abstract view
.subckt sky130_fd_sc_hd__or3b_4 A B C_N VGND VNB VPB VPWR X
.ends

* Black-box entry subcircuit for sky130_fd_sc_hd__mux2_4 abstract view
.subckt sky130_fd_sc_hd__mux2_4 A0 A1 S VGND VNB VPB VPWR X
.ends

* Black-box entry subcircuit for sky130_fd_sc_hd__buf_1 abstract view
.subckt sky130_fd_sc_hd__buf_1 A VGND VNB VPB VPWR X
.ends

* Black-box entry subcircuit for sky130_fd_sc_hd__a211o_1 abstract view
.subckt sky130_fd_sc_hd__a211o_1 A1 A2 B1 C1 VGND VNB VPB VPWR X
.ends

* Black-box entry subcircuit for sky130_fd_sc_hd__dfrtp_2 abstract view
.subckt sky130_fd_sc_hd__dfrtp_2 CLK D RESET_B VGND VNB VPB VPWR Q
.ends

* Black-box entry subcircuit for sky130_fd_sc_hd__clkbuf_2 abstract view
.subckt sky130_fd_sc_hd__clkbuf_2 A VGND VNB VPB VPWR X
.ends

* Black-box entry subcircuit for sky130_fd_sc_hd__o31ai_4 abstract view
.subckt sky130_fd_sc_hd__o31ai_4 A1 A2 A3 B1 VGND VNB VPB VPWR Y
.ends

* Black-box entry subcircuit for sky130_fd_sc_hd__xor2_2 abstract view
.subckt sky130_fd_sc_hd__xor2_2 A B VGND VNB VPB VPWR X
.ends

* Black-box entry subcircuit for sky130_fd_sc_hd__a221o_2 abstract view
.subckt sky130_fd_sc_hd__a221o_2 A1 A2 B1 B2 C1 VGND VNB VPB VPWR X
.ends

* Black-box entry subcircuit for sky130_fd_sc_hd__and4bb_4 abstract view
.subckt sky130_fd_sc_hd__and4bb_4 A_N B_N C D VGND VNB VPB VPWR X
.ends

* Black-box entry subcircuit for sky130_fd_sc_hd__a21boi_2 abstract view
.subckt sky130_fd_sc_hd__a21boi_2 A1 A2 B1_N VGND VNB VPB VPWR Y
.ends

* Black-box entry subcircuit for sky130_fd_sc_hd__nor2_4 abstract view
.subckt sky130_fd_sc_hd__nor2_4 A B VGND VNB VPB VPWR Y
.ends

* Black-box entry subcircuit for sky130_fd_sc_hd__dfrtp_4 abstract view
.subckt sky130_fd_sc_hd__dfrtp_4 CLK D RESET_B VGND VNB VPB VPWR Q
.ends

* Black-box entry subcircuit for sky130_fd_sc_hd__nor3_1 abstract view
.subckt sky130_fd_sc_hd__nor3_1 A B C VGND VNB VPB VPWR Y
.ends

* Black-box entry subcircuit for sky130_fd_sc_hd__o211a_1 abstract view
.subckt sky130_fd_sc_hd__o211a_1 A1 A2 B1 C1 VGND VNB VPB VPWR X
.ends

* Black-box entry subcircuit for sky130_fd_sc_hd__and4_1 abstract view
.subckt sky130_fd_sc_hd__and4_1 A B C D VGND VNB VPB VPWR X
.ends

* Black-box entry subcircuit for sky130_fd_sc_hd__and3b_1 abstract view
.subckt sky130_fd_sc_hd__and3b_1 A_N B C VGND VNB VPB VPWR X
.ends

* Black-box entry subcircuit for sky130_fd_sc_hd__nand3_1 abstract view
.subckt sky130_fd_sc_hd__nand3_1 A B C VGND VNB VPB VPWR Y
.ends

* Black-box entry subcircuit for sky130_fd_sc_hd__clkbuf_4 abstract view
.subckt sky130_fd_sc_hd__clkbuf_4 A VGND VNB VPB VPWR X
.ends

* Black-box entry subcircuit for sky130_fd_sc_hd__and3_1 abstract view
.subckt sky130_fd_sc_hd__and3_1 A B C VGND VNB VPB VPWR X
.ends

* Black-box entry subcircuit for sky130_fd_sc_hd__o221a_1 abstract view
.subckt sky130_fd_sc_hd__o221a_1 A1 A2 B1 B2 C1 VGND VNB VPB VPWR X
.ends

* Black-box entry subcircuit for sky130_fd_sc_hd__dlymetal6s4s_1 abstract view
.subckt sky130_fd_sc_hd__dlymetal6s4s_1 A VGND VNB VPB VPWR X
.ends

* Black-box entry subcircuit for sky130_fd_sc_hd__nand2_2 abstract view
.subckt sky130_fd_sc_hd__nand2_2 A B VGND VNB VPB VPWR Y
.ends

* Black-box entry subcircuit for sky130_fd_sc_hd__or3_1 abstract view
.subckt sky130_fd_sc_hd__or3_1 A B C VGND VNB VPB VPWR X
.ends

* Black-box entry subcircuit for sky130_fd_sc_hd__or4_4 abstract view
.subckt sky130_fd_sc_hd__or4_4 A B C D VGND VNB VPB VPWR X
.ends

* Black-box entry subcircuit for sky130_fd_sc_hd__o31a_1 abstract view
.subckt sky130_fd_sc_hd__o31a_1 A1 A2 A3 B1 VGND VNB VPB VPWR X
.ends

* Black-box entry subcircuit for sky130_fd_sc_hd__o311a_1 abstract view
.subckt sky130_fd_sc_hd__o311a_1 A1 A2 A3 B1 C1 VGND VNB VPB VPWR X
.ends

* Black-box entry subcircuit for sky130_fd_sc_hd__o21ai_2 abstract view
.subckt sky130_fd_sc_hd__o21ai_2 A1 A2 B1 VGND VNB VPB VPWR Y
.ends

* Black-box entry subcircuit for sky130_fd_sc_hd__xnor2_1 abstract view
.subckt sky130_fd_sc_hd__xnor2_1 A B VGND VNB VPB VPWR Y
.ends

* Black-box entry subcircuit for sky130_fd_sc_hd__o2bb2a_1 abstract view
.subckt sky130_fd_sc_hd__o2bb2a_1 A1_N A2_N B1 B2 VGND VNB VPB VPWR X
.ends

* Black-box entry subcircuit for sky130_fd_sc_hd__and2b_1 abstract view
.subckt sky130_fd_sc_hd__and2b_1 A_N B VGND VNB VPB VPWR X
.ends

* Black-box entry subcircuit for sky130_fd_sc_hd__or2b_1 abstract view
.subckt sky130_fd_sc_hd__or2b_1 A B_N VGND VNB VPB VPWR X
.ends

* Black-box entry subcircuit for sky130_fd_sc_hd__o2111a_1 abstract view
.subckt sky130_fd_sc_hd__o2111a_1 A1 A2 B1 C1 D1 VGND VNB VPB VPWR X
.ends

* Black-box entry subcircuit for sky130_fd_sc_hd__a21oi_2 abstract view
.subckt sky130_fd_sc_hd__a21oi_2 A1 A2 B1 VGND VNB VPB VPWR Y
.ends

* Black-box entry subcircuit for sky130_fd_sc_hd__o21ai_4 abstract view
.subckt sky130_fd_sc_hd__o21ai_4 A1 A2 B1 VGND VNB VPB VPWR Y
.ends

* Black-box entry subcircuit for sky130_fd_sc_hd__buf_6 abstract view
.subckt sky130_fd_sc_hd__buf_6 A VGND VNB VPB VPWR X
.ends

* Black-box entry subcircuit for sky130_fd_sc_hd__or4_1 abstract view
.subckt sky130_fd_sc_hd__or4_1 A B C D VGND VNB VPB VPWR X
.ends

* Black-box entry subcircuit for sky130_fd_sc_hd__a211oi_1 abstract view
.subckt sky130_fd_sc_hd__a211oi_1 A1 A2 B1 C1 VGND VNB VPB VPWR Y
.ends

* Black-box entry subcircuit for sky130_fd_sc_hd__nor2_2 abstract view
.subckt sky130_fd_sc_hd__nor2_2 A B VGND VNB VPB VPWR Y
.ends

* Black-box entry subcircuit for sky130_fd_sc_hd__or3b_2 abstract view
.subckt sky130_fd_sc_hd__or3b_2 A B C_N VGND VNB VPB VPWR X
.ends

* Black-box entry subcircuit for sky130_fd_sc_hd__o22a_1 abstract view
.subckt sky130_fd_sc_hd__o22a_1 A1 A2 B1 B2 VGND VNB VPB VPWR X
.ends

* Black-box entry subcircuit for sky130_fd_sc_hd__or2_4 abstract view
.subckt sky130_fd_sc_hd__or2_4 A B VGND VNB VPB VPWR X
.ends

* Black-box entry subcircuit for sky130_fd_sc_hd__a21oi_4 abstract view
.subckt sky130_fd_sc_hd__a21oi_4 A1 A2 B1 VGND VNB VPB VPWR Y
.ends

* Black-box entry subcircuit for sky130_fd_sc_hd__nor3b_1 abstract view
.subckt sky130_fd_sc_hd__nor3b_1 A B C_N VGND VNB VPB VPWR Y
.ends

* Black-box entry subcircuit for sky130_fd_sc_hd__a32o_1 abstract view
.subckt sky130_fd_sc_hd__a32o_1 A1 A2 A3 B1 B2 VGND VNB VPB VPWR X
.ends

* Black-box entry subcircuit for sky130_fd_sc_hd__a2bb2o_1 abstract view
.subckt sky130_fd_sc_hd__a2bb2o_1 A1_N A2_N B1 B2 VGND VNB VPB VPWR X
.ends

* Black-box entry subcircuit for sky130_fd_sc_hd__a41o_1 abstract view
.subckt sky130_fd_sc_hd__a41o_1 A1 A2 A3 A4 B1 VGND VNB VPB VPWR X
.ends

* Black-box entry subcircuit for sky130_fd_sc_hd__a31o_1 abstract view
.subckt sky130_fd_sc_hd__a31o_1 A1 A2 A3 B1 VGND VNB VPB VPWR X
.ends

* Black-box entry subcircuit for sky130_fd_sc_hd__a41oi_2 abstract view
.subckt sky130_fd_sc_hd__a41oi_2 A1 A2 A3 A4 B1 VGND VNB VPB VPWR Y
.ends

* Black-box entry subcircuit for sky130_fd_sc_hd__nor4_2 abstract view
.subckt sky130_fd_sc_hd__nor4_2 A B C D VGND VNB VPB VPWR Y
.ends

* Black-box entry subcircuit for sky130_fd_sc_hd__o21bai_4 abstract view
.subckt sky130_fd_sc_hd__o21bai_4 A1 A2 B1_N VGND VNB VPB VPWR Y
.ends

* Black-box entry subcircuit for sky130_fd_sc_hd__inv_8 abstract view
.subckt sky130_fd_sc_hd__inv_8 A VGND VNB VPB VPWR Y
.ends

* Black-box entry subcircuit for sky130_fd_sc_hd__clkinvlp_4 abstract view
.subckt sky130_fd_sc_hd__clkinvlp_4 A VGND VNB VPB VPWR Y
.ends

* Black-box entry subcircuit for sky130_fd_sc_hd__clkinv_2 abstract view
.subckt sky130_fd_sc_hd__clkinv_2 A VGND VNB VPB VPWR Y
.ends

* Black-box entry subcircuit for sky130_fd_sc_hd__nand4_1 abstract view
.subckt sky130_fd_sc_hd__nand4_1 A B C D VGND VNB VPB VPWR Y
.ends

* Black-box entry subcircuit for sky130_fd_sc_hd__a21boi_4 abstract view
.subckt sky130_fd_sc_hd__a21boi_4 A1 A2 B1_N VGND VNB VPB VPWR Y
.ends

* Black-box entry subcircuit for sky130_fd_sc_hd__or3_2 abstract view
.subckt sky130_fd_sc_hd__or3_2 A B C VGND VNB VPB VPWR X
.ends

* Black-box entry subcircuit for sky130_fd_sc_hd__clkinv_1 abstract view
.subckt sky130_fd_sc_hd__clkinv_1 A VGND VNB VPB VPWR Y
.ends

* Black-box entry subcircuit for sky130_fd_sc_hd__bufinv_16 abstract view
.subckt sky130_fd_sc_hd__bufinv_16 A VGND VNB VPB VPWR Y
.ends

* Black-box entry subcircuit for sky130_fd_sc_hd__clkinv_4 abstract view
.subckt sky130_fd_sc_hd__clkinv_4 A VGND VNB VPB VPWR Y
.ends

* Black-box entry subcircuit for sky130_fd_sc_hd__inv_6 abstract view
.subckt sky130_fd_sc_hd__inv_6 A VGND VNB VPB VPWR Y
.ends

* Black-box entry subcircuit for sky130_fd_sc_hd__o211ai_1 abstract view
.subckt sky130_fd_sc_hd__o211ai_1 A1 A2 B1 C1 VGND VNB VPB VPWR Y
.ends

* Black-box entry subcircuit for sky130_fd_sc_hd__a21bo_1 abstract view
.subckt sky130_fd_sc_hd__a21bo_1 A1 A2 B1_N VGND VNB VPB VPWR X
.ends

* Black-box entry subcircuit for sky130_fd_sc_hd__clkbuf_16 abstract view
.subckt sky130_fd_sc_hd__clkbuf_16 A VGND VNB VPB VPWR X
.ends

* Black-box entry subcircuit for sky130_fd_sc_hd__xor2_4 abstract view
.subckt sky130_fd_sc_hd__xor2_4 A B VGND VNB VPB VPWR X
.ends

* Black-box entry subcircuit for sky130_fd_sc_hd__o22ai_1 abstract view
.subckt sky130_fd_sc_hd__o22ai_1 A1 A2 B1 B2 VGND VNB VPB VPWR Y
.ends

* Black-box entry subcircuit for sky130_fd_sc_hd__a31oi_4 abstract view
.subckt sky130_fd_sc_hd__a31oi_4 A1 A2 A3 B1 VGND VNB VPB VPWR Y
.ends

* Black-box entry subcircuit for sky130_fd_sc_hd__nand3b_4 abstract view
.subckt sky130_fd_sc_hd__nand3b_4 A_N B C VGND VNB VPB VPWR Y
.ends

* Black-box entry subcircuit for sky130_fd_sc_hd__clkinv_8 abstract view
.subckt sky130_fd_sc_hd__clkinv_8 A VGND VNB VPB VPWR Y
.ends

* Black-box entry subcircuit for sky130_fd_sc_hd__or2_2 abstract view
.subckt sky130_fd_sc_hd__or2_2 A B VGND VNB VPB VPWR X
.ends

* Black-box entry subcircuit for sky130_fd_sc_hd__nand2_4 abstract view
.subckt sky130_fd_sc_hd__nand2_4 A B VGND VNB VPB VPWR Y
.ends

* Black-box entry subcircuit for sky130_fd_sc_hd__a221oi_1 abstract view
.subckt sky130_fd_sc_hd__a221oi_1 A1 A2 B1 B2 C1 VGND VNB VPB VPWR Y
.ends

* Black-box entry subcircuit for sky130_fd_sc_hd__o21ba_1 abstract view
.subckt sky130_fd_sc_hd__o21ba_1 A1 A2 B1_N VGND VNB VPB VPWR X
.ends

* Black-box entry subcircuit for sky130_fd_sc_hd__nor2b_2 abstract view
.subckt sky130_fd_sc_hd__nor2b_2 A B_N VGND VNB VPB VPWR Y
.ends

* Black-box entry subcircuit for sky130_fd_sc_hd__and2b_2 abstract view
.subckt sky130_fd_sc_hd__and2b_2 A_N B VGND VNB VPB VPWR X
.ends

* Black-box entry subcircuit for sky130_fd_sc_hd__nand3b_1 abstract view
.subckt sky130_fd_sc_hd__nand3b_1 A_N B C VGND VNB VPB VPWR Y
.ends

* Black-box entry subcircuit for sky130_fd_sc_hd__o211a_2 abstract view
.subckt sky130_fd_sc_hd__o211a_2 A1 A2 B1 C1 VGND VNB VPB VPWR X
.ends

* Black-box entry subcircuit for sky130_fd_sc_hd__and4_2 abstract view
.subckt sky130_fd_sc_hd__and4_2 A B C D VGND VNB VPB VPWR X
.ends

* Black-box entry subcircuit for sky130_fd_sc_hd__o21ba_2 abstract view
.subckt sky130_fd_sc_hd__o21ba_2 A1 A2 B1_N VGND VNB VPB VPWR X
.ends

* Black-box entry subcircuit for sky130_fd_sc_hd__a211oi_4 abstract view
.subckt sky130_fd_sc_hd__a211oi_4 A1 A2 B1 C1 VGND VNB VPB VPWR Y
.ends

* Black-box entry subcircuit for sky130_fd_sc_hd__or2b_2 abstract view
.subckt sky130_fd_sc_hd__or2b_2 A B_N VGND VNB VPB VPWR X
.ends

* Black-box entry subcircuit for sky130_fd_sc_hd__and2_2 abstract view
.subckt sky130_fd_sc_hd__and2_2 A B VGND VNB VPB VPWR X
.ends

* Black-box entry subcircuit for sky130_fd_sc_hd__a311o_1 abstract view
.subckt sky130_fd_sc_hd__a311o_1 A1 A2 A3 B1 C1 VGND VNB VPB VPWR X
.ends

* Black-box entry subcircuit for sky130_fd_sc_hd__a211o_4 abstract view
.subckt sky130_fd_sc_hd__a211o_4 A1 A2 B1 C1 VGND VNB VPB VPWR X
.ends

* Black-box entry subcircuit for sky130_fd_sc_hd__or4b_4 abstract view
.subckt sky130_fd_sc_hd__or4b_4 A B C D_N VGND VNB VPB VPWR X
.ends

* Black-box entry subcircuit for sky130_fd_sc_hd__a211oi_2 abstract view
.subckt sky130_fd_sc_hd__a211oi_2 A1 A2 B1 C1 VGND VNB VPB VPWR Y
.ends

* Black-box entry subcircuit for sky130_fd_sc_hd__or3_4 abstract view
.subckt sky130_fd_sc_hd__or3_4 A B C VGND VNB VPB VPWR X
.ends

* Black-box entry subcircuit for sky130_fd_sc_hd__o21bai_1 abstract view
.subckt sky130_fd_sc_hd__o21bai_1 A1 A2 B1_N VGND VNB VPB VPWR Y
.ends

* Black-box entry subcircuit for sky130_fd_sc_hd__a31oi_1 abstract view
.subckt sky130_fd_sc_hd__a31oi_1 A1 A2 A3 B1 VGND VNB VPB VPWR Y
.ends

* Black-box entry subcircuit for sky130_fd_sc_hd__dlymetal6s2s_1 abstract view
.subckt sky130_fd_sc_hd__dlymetal6s2s_1 A VGND VNB VPB VPWR X
.ends

* Black-box entry subcircuit for sky130_fd_sc_hd__nor4_4 abstract view
.subckt sky130_fd_sc_hd__nor4_4 A B C D VGND VNB VPB VPWR Y
.ends

* Black-box entry subcircuit for sky130_fd_sc_hd__o221a_4 abstract view
.subckt sky130_fd_sc_hd__o221a_4 A1 A2 B1 B2 C1 VGND VNB VPB VPWR X
.ends

* Black-box entry subcircuit for sky130_fd_sc_hd__nor2b_1 abstract view
.subckt sky130_fd_sc_hd__nor2b_1 A B_N VGND VNB VPB VPWR Y
.ends

* Black-box entry subcircuit for sky130_fd_sc_hd__a21o_2 abstract view
.subckt sky130_fd_sc_hd__a21o_2 A1 A2 B1 VGND VNB VPB VPWR X
.ends

* Black-box entry subcircuit for sky130_fd_sc_hd__a31oi_2 abstract view
.subckt sky130_fd_sc_hd__a31oi_2 A1 A2 A3 B1 VGND VNB VPB VPWR Y
.ends

* Black-box entry subcircuit for sky130_fd_sc_hd__o211ai_2 abstract view
.subckt sky130_fd_sc_hd__o211ai_2 A1 A2 B1 C1 VGND VNB VPB VPWR Y
.ends

* Black-box entry subcircuit for sky130_fd_sc_hd__a311oi_4 abstract view
.subckt sky130_fd_sc_hd__a311oi_4 A1 A2 A3 B1 C1 VGND VNB VPB VPWR Y
.ends

* Black-box entry subcircuit for sky130_fd_sc_hd__o31a_2 abstract view
.subckt sky130_fd_sc_hd__o31a_2 A1 A2 A3 B1 VGND VNB VPB VPWR X
.ends

* Black-box entry subcircuit for sky130_fd_sc_hd__a221oi_2 abstract view
.subckt sky130_fd_sc_hd__a221oi_2 A1 A2 B1 B2 C1 VGND VNB VPB VPWR Y
.ends

* Black-box entry subcircuit for sky130_fd_sc_hd__and3_2 abstract view
.subckt sky130_fd_sc_hd__and3_2 A B C VGND VNB VPB VPWR X
.ends

* Black-box entry subcircuit for sky130_fd_sc_hd__nor3_4 abstract view
.subckt sky130_fd_sc_hd__nor3_4 A B C VGND VNB VPB VPWR Y
.ends

* Black-box entry subcircuit for sky130_fd_sc_hd__a21boi_1 abstract view
.subckt sky130_fd_sc_hd__a21boi_1 A1 A2 B1_N VGND VNB VPB VPWR Y
.ends

* Black-box entry subcircuit for sky130_fd_sc_hd__o221ai_4 abstract view
.subckt sky130_fd_sc_hd__o221ai_4 A1 A2 B1 B2 C1 VGND VNB VPB VPWR Y
.ends

* Black-box entry subcircuit for sky130_fd_sc_hd__or4b_1 abstract view
.subckt sky130_fd_sc_hd__or4b_1 A B C D_N VGND VNB VPB VPWR X
.ends

* Black-box entry subcircuit for sky130_fd_sc_hd__nand3_2 abstract view
.subckt sky130_fd_sc_hd__nand3_2 A B C VGND VNB VPB VPWR Y
.ends

* Black-box entry subcircuit for sky130_fd_sc_hd__or3b_1 abstract view
.subckt sky130_fd_sc_hd__or3b_1 A B C_N VGND VNB VPB VPWR X
.ends

* Black-box entry subcircuit for sky130_fd_sc_hd__or4bb_1 abstract view
.subckt sky130_fd_sc_hd__or4bb_1 A B C_N D_N VGND VNB VPB VPWR X
.ends

* Black-box entry subcircuit for sky130_fd_sc_hd__o22ai_4 abstract view
.subckt sky130_fd_sc_hd__o22ai_4 A1 A2 B1 B2 VGND VNB VPB VPWR Y
.ends

* Black-box entry subcircuit for sky130_fd_sc_hd__mux2_2 abstract view
.subckt sky130_fd_sc_hd__mux2_2 A0 A1 S VGND VNB VPB VPWR X
.ends

* Black-box entry subcircuit for sky130_fd_sc_hd__nor3_2 abstract view
.subckt sky130_fd_sc_hd__nor3_2 A B C VGND VNB VPB VPWR Y
.ends

* Black-box entry subcircuit for sky130_fd_sc_hd__or4_2 abstract view
.subckt sky130_fd_sc_hd__or4_2 A B C D VGND VNB VPB VPWR X
.ends

* Black-box entry subcircuit for sky130_fd_sc_hd__o22ai_2 abstract view
.subckt sky130_fd_sc_hd__o22ai_2 A1 A2 B1 B2 VGND VNB VPB VPWR Y
.ends

* Black-box entry subcircuit for sky130_fd_sc_hd__dlygate4sd1_1 abstract view
.subckt sky130_fd_sc_hd__dlygate4sd1_1 A VGND VNB VPB VPWR X
.ends

* Black-box entry subcircuit for sky130_fd_sc_hd__clkdlybuf4s15_2 abstract view
.subckt sky130_fd_sc_hd__clkdlybuf4s15_2 A VGND VNB VPB VPWR X
.ends

* Black-box entry subcircuit for sky130_fd_sc_hd__a311o_2 abstract view
.subckt sky130_fd_sc_hd__a311o_2 A1 A2 A3 B1 C1 VGND VNB VPB VPWR X
.ends

* Black-box entry subcircuit for sky130_fd_sc_hd__diode_2 abstract view
.subckt sky130_fd_sc_hd__diode_2 DIODE VGND VNB VPB VPWR
.ends

* Black-box entry subcircuit for sky130_fd_sc_hd__nor4_1 abstract view
.subckt sky130_fd_sc_hd__nor4_1 A B C D VGND VNB VPB VPWR Y
.ends

* Black-box entry subcircuit for sky130_fd_sc_hd__o32a_2 abstract view
.subckt sky130_fd_sc_hd__o32a_2 A1 A2 A3 B1 B2 VGND VNB VPB VPWR X
.ends

* Black-box entry subcircuit for sky130_fd_sc_hd__or4b_2 abstract view
.subckt sky130_fd_sc_hd__or4b_2 A B C D_N VGND VNB VPB VPWR X
.ends

.subckt semi_cpu_top Result[0] Result[10] Result[11] Result[12] Result[13] Result[14]
+ Result[15] Result[16] Result[17] Result[18] Result[19] Result[1] Result[20] Result[21]
+ Result[22] Result[23] Result[24] Result[25] Result[26] Result[27] Result[28] Result[29]
+ Result[2] Result[30] Result[31] Result[3] Result[4] Result[5] Result[6] Result[7]
+ Result[8] Result[9] VGND VPWR an[0] an[1] an[2] an[3] clk control reset seg[0] seg[1]
+ seg[2] seg[3] seg[4] seg[5] seg[6]
X_3155_ _1333_ _1350_ VGND VGND VPWR VPWR _1351_ sky130_fd_sc_hd__nand2_1
X_3086_ _1263_ _1280_ _1281_ VGND VGND VPWR VPWR _1282_ sky130_fd_sc_hd__o21a_1
XTAP_TAPCELL_ROW_65_776 VGND VPWR sky130_fd_sc_hd__tapvpwrvgnd_1
XFILLER_0_76_188 VGND VGND VPWR VPWR sky130_fd_sc_hd__fill_1
X_3988_ _2121_ VGND VGND VPWR VPWR _0631_ sky130_fd_sc_hd__clkbuf_1
XFILLER_0_9_477 VGND VGND VPWR VPWR sky130_fd_sc_hd__fill_2
XFILLER_0_57_391 VGND VGND VPWR VPWR sky130_fd_sc_hd__fill_1
X_2939_ net243 VGND VGND VPWR VPWR _1175_ sky130_fd_sc_hd__clkbuf_1
XFILLER_0_60_501 VPWR VGND VPWR VGND sky130_ef_sc_hd__decap_12
XTAP_TAPCELL_ROW_20_367 VGND VPWR sky130_fd_sc_hd__tapvpwrvgnd_1
XFILLER_0_32_236 VGND VGND VPWR VPWR sky130_fd_sc_hd__fill_1
X_4609_ _2441_ VGND VGND VPWR VPWR _0039_ sky130_fd_sc_hd__inv_2
XFILLER_0_7_81 VGND VGND VPWR VPWR sky130_fd_sc_hd__decap_8
XTAP_TAPCELL_ROW_28_445 VGND VPWR sky130_fd_sc_hd__tapvpwrvgnd_1
XFILLER_0_23_225 VGND VGND VPWR VPWR sky130_fd_sc_hd__decap_3
XFILLER_0_23_247 VGND VGND VPWR VPWR sky130_fd_sc_hd__fill_1
XFILLER_0_48_26 VGND VGND VPWR VPWR sky130_fd_sc_hd__fill_2
XFILLER_0_3_39 VPWR VGND VPWR VGND sky130_ef_sc_hd__decap_12
X_4960_ _2480_ VGND VGND VPWR VPWR _2485_ sky130_fd_sc_hd__clkbuf_8
XFILLER_0_58_111 VGND VGND VPWR VPWR sky130_fd_sc_hd__fill_1
XFILLER_0_86_475 VGND VGND VPWR VPWR sky130_fd_sc_hd__fill_1
X_4891_ _2476_ VGND VGND VPWR VPWR _0286_ sky130_fd_sc_hd__inv_2
X_3911_ RF0.regs\[4\]\[11\] _2072_ _2073_ VGND VGND VPWR VPWR _2074_ sky130_fd_sc_hd__mux2_1
XTAP_TAPCELL_ROW_62_746 VGND VPWR sky130_fd_sc_hd__tapvpwrvgnd_1
X_3842_ _2010_ _2011_ VGND VGND VPWR VPWR _2012_ sky130_fd_sc_hd__xnor2_4
XFILLER_0_13_51 VGND VGND VPWR VPWR sky130_fd_sc_hd__decap_4
XFILLER_0_39_380 VPWR VGND VPWR VGND sky130_ef_sc_hd__decap_12
XFILLER_0_46_317 VGND VGND VPWR VPWR sky130_fd_sc_hd__decap_4
XFILLER_0_73_169 VPWR VGND VPWR VGND sky130_ef_sc_hd__decap_12
XFILLER_0_6_469 VGND VGND VPWR VPWR sky130_fd_sc_hd__decap_6
X_3773_ RF0.regs\[4\]\[30\] _1957_ _1953_ VGND VGND VPWR VPWR _1958_ sky130_fd_sc_hd__mux2_1
X_2724_ RF0.regs\[4\]\[31\] _0867_ _0879_ RF0.regs\[2\]\[31\] _1015_ VGND VGND VPWR
+ VPWR _1016_ sky130_fd_sc_hd__a221o_1
X_2655_ _0944_ _0946_ VGND VGND VPWR VPWR _0947_ sky130_fd_sc_hd__xor2_1
X_5374_ clknet_leaf_42_clk _0750_ _0366_ VGND VGND VPWR VPWR IM0.addr\[5\] sky130_fd_sc_hd__dfrtp_1
X_2586_ _0877_ VGND VGND VPWR VPWR _0878_ sky130_fd_sc_hd__buf_4
X_4325_ RF0.regs\[15\]\[14\] _2063_ _2290_ VGND VGND VPWR VPWR _2298_ sky130_fd_sc_hd__mux2_1
XFILLER_0_10_475 VGND VGND VPWR VPWR sky130_fd_sc_hd__fill_1
XFILLER_0_38_81 VGND VGND VPWR VPWR sky130_fd_sc_hd__decap_3
X_4256_ net87 VGND VGND VPWR VPWR _2262_ sky130_fd_sc_hd__clkbuf_1
X_3207_ _1401_ _1402_ _1220_ VGND VGND VPWR VPWR _1403_ sky130_fd_sc_hd__a21oi_1
X_4187_ RF0.regs\[10\]\[17\] _2005_ _2222_ VGND VGND VPWR VPWR _2227_ sky130_fd_sc_hd__mux2_1
XTAP_TAPCELL_ROW_78_890 VGND VPWR sky130_fd_sc_hd__tapvpwrvgnd_1
X_3138_ _1264_ _1094_ VGND VGND VPWR VPWR _1334_ sky130_fd_sc_hd__nor2_1
XTAP_TAPCELL_ROW_25_415 VGND VPWR sky130_fd_sc_hd__tapvpwrvgnd_1
XFILLER_0_49_111 VGND VGND VPWR VPWR sky130_fd_sc_hd__fill_1
X_3069_ _1264_ _0898_ VGND VGND VPWR VPWR _1265_ sky130_fd_sc_hd__nor2_1
XFILLER_0_64_125 VPWR VGND VPWR VGND sky130_ef_sc_hd__decap_12
XFILLER_0_9_285 VGND VGND VPWR VPWR sky130_fd_sc_hd__fill_2
XFILLER_0_72_180 VPWR VGND VPWR VGND sky130_ef_sc_hd__decap_12
XFILLER_0_20_206 VGND VGND VPWR VPWR sky130_fd_sc_hd__fill_1
Xhold170 RF0.regs\[6\]\[26\] VGND VGND VPWR VPWR net218 sky130_fd_sc_hd__dlygate4sd3_1
Xhold192 IM0.addr\[8\] VGND VGND VPWR VPWR net240 sky130_fd_sc_hd__dlygate4sd3_1
Xhold181 IM0.addr\[16\] VGND VGND VPWR VPWR net229 sky130_fd_sc_hd__dlygate4sd3_1
XFILLER_0_18_29 VPWR VGND VPWR VGND sky130_ef_sc_hd__decap_12
XFILLER_0_68_475 VGND VGND VPWR VPWR sky130_fd_sc_hd__fill_1
XFILLER_0_83_445 VGND VGND VPWR VPWR sky130_fd_sc_hd__decap_3
XFILLER_0_43_309 VGND VGND VPWR VPWR sky130_fd_sc_hd__fill_1
XFILLER_0_55_169 VGND VGND VPWR VPWR sky130_fd_sc_hd__fill_2
XFILLER_0_3_417 VPWR VGND VPWR VGND sky130_ef_sc_hd__decap_12
XFILLER_0_11_239 VGND VGND VPWR VPWR sky130_fd_sc_hd__fill_1
X_4110_ _2187_ VGND VGND VPWR VPWR _0576_ sky130_fd_sc_hd__clkbuf_1
X_5090_ clknet_leaf_29_clk _0466_ _0082_ VGND VGND VPWR VPWR RF0.regs\[15\]\[9\] sky130_fd_sc_hd__dfrtp_1
X_4041_ _1992_ net241 _2149_ VGND VGND VPWR VPWR _2150_ sky130_fd_sc_hd__mux2_1
XFILLER_0_75_57 VGND VGND VPWR VPWR sky130_fd_sc_hd__decap_3
XTAP_TAPCELL_ROW_75_860 VGND VPWR sky130_fd_sc_hd__tapvpwrvgnd_1
X_4943_ _2483_ VGND VGND VPWR VPWR _0331_ sky130_fd_sc_hd__inv_2
XFILLER_0_74_445 VGND VGND VPWR VPWR sky130_fd_sc_hd__decap_4
X_4874_ _2471_ VGND VGND VPWR VPWR _2475_ sky130_fd_sc_hd__clkbuf_8
X_3825_ _1719_ _1998_ _1718_ VGND VGND VPWR VPWR _1999_ sky130_fd_sc_hd__o21ai_1
XFILLER_0_74_489 VPWR VGND VPWR VGND sky130_ef_sc_hd__decap_12
XTAP_TAPCELL_ROW_30_462 VGND VPWR sky130_fd_sc_hd__tapvpwrvgnd_1
XFILLER_0_42_331 VGND VGND VPWR VPWR sky130_fd_sc_hd__decap_8
X_3756_ _1938_ _1939_ _1940_ _1941_ _0799_ VGND VGND VPWR VPWR _1942_ sky130_fd_sc_hd__a2111o_1
XFILLER_0_42_342 VGND VGND VPWR VPWR sky130_fd_sc_hd__fill_2
X_2707_ RF0.regs\[10\]\[25\] _0814_ _0829_ RF0.regs\[25\]\[25\] _0998_ VGND VGND VPWR
+ VPWR _0999_ sky130_fd_sc_hd__a221oi_4
XFILLER_0_71_3 VPWR VGND VPWR VGND sky130_ef_sc_hd__decap_12
X_3687_ RF0.regs\[7\]\[2\] net47 VGND VGND VPWR VPWR _1873_ sky130_fd_sc_hd__and2_1
X_2638_ RF0.regs\[4\]\[16\] _0839_ _0845_ RF0.regs\[12\]\[16\] VGND VGND VPWR VPWR
+ _0930_ sky130_fd_sc_hd__a22o_1
X_5357_ clknet_leaf_11_clk _0733_ _0349_ VGND VGND VPWR VPWR RF0.regs\[0\]\[20\] sky130_fd_sc_hd__dfrtp_1
X_2569_ _0857_ _0860_ VGND VGND VPWR VPWR _0861_ sky130_fd_sc_hd__and2_1
XFILLER_0_10_250 VGND VGND VPWR VPWR sky130_fd_sc_hd__fill_2
X_5288_ clknet_leaf_19_clk _0664_ _0280_ VGND VGND VPWR VPWR RF0.regs\[4\]\[15\] sky130_fd_sc_hd__dfrtp_1
X_4308_ RF0.regs\[15\]\[22\] _1988_ _2279_ VGND VGND VPWR VPWR _2289_ sky130_fd_sc_hd__mux2_1
X_4239_ _2253_ VGND VGND VPWR VPWR _0513_ sky130_fd_sc_hd__clkbuf_1
XFILLER_0_37_158 VGND VGND VPWR VPWR sky130_fd_sc_hd__fill_2
XFILLER_0_65_445 VGND VGND VPWR VPWR sky130_fd_sc_hd__decap_3
XFILLER_0_18_394 VPWR VGND VPWR VGND sky130_ef_sc_hd__decap_12
XFILLER_0_33_353 VGND VGND VPWR VPWR sky130_fd_sc_hd__decap_4
XFILLER_0_33_364 VGND VGND VPWR VPWR sky130_fd_sc_hd__decap_4
XFILLER_0_33_375 VGND VGND VPWR VPWR sky130_fd_sc_hd__decap_4
XFILLER_0_45_16 VGND VGND VPWR VPWR sky130_fd_sc_hd__decap_3
XFILLER_0_45_27 VGND VGND VPWR VPWR sky130_fd_sc_hd__fill_1
XTAP_TAPCELL_ROW_72_841 VGND VPWR sky130_fd_sc_hd__tapvpwrvgnd_1
XFILLER_0_0_29 VPWR VGND VPWR VGND sky130_ef_sc_hd__decap_12
XTAP_TAPCELL_ROW_44_587 VGND VPWR sky130_fd_sc_hd__tapvpwrvgnd_1
X_4590_ _2439_ VGND VGND VPWR VPWR _0022_ sky130_fd_sc_hd__inv_2
XFILLER_0_9_27 VPWR VGND VPWR VGND sky130_ef_sc_hd__decap_12
X_3610_ _1796_ _1797_ _1799_ _1217_ RF0.regs\[0\]\[10\] VGND VGND VPWR VPWR _1800_
+ sky130_fd_sc_hd__o32a_1
X_3541_ RF0.regs\[4\]\[15\] _1240_ _1232_ RF0.regs\[6\]\[15\] VGND VGND VPWR VPWR
+ _1733_ sky130_fd_sc_hd__a22o_1
XFILLER_0_3_225 VGND VGND VPWR VPWR sky130_fd_sc_hd__decap_6
XFILLER_0_24_331 VGND VGND VPWR VPWR sky130_fd_sc_hd__fill_2
XFILLER_0_10_41 VPWR VGND VPWR VGND sky130_ef_sc_hd__decap_12
X_3472_ RF0.regs\[7\]\[21\] _1245_ VGND VGND VPWR VPWR _1666_ sky130_fd_sc_hd__and2_1
XFILLER_0_10_85 VGND VGND VPWR VPWR sky130_fd_sc_hd__fill_1
X_5211_ clknet_leaf_35_clk _0587_ _0203_ VGND VGND VPWR VPWR RF0.regs\[6\]\[2\] sky130_fd_sc_hd__dfrtp_1
X_5142_ clknet_leaf_0_clk _0518_ _0134_ VGND VGND VPWR VPWR RF0.regs\[12\]\[29\] sky130_fd_sc_hd__dfrtp_1
X_5073_ clknet_leaf_7_clk _0449_ _0065_ VGND VGND VPWR VPWR RF0.regs\[20\]\[24\] sky130_fd_sc_hd__dfrtp_1
X_4024_ _1962_ RF0.regs\[6\]\[29\] _2138_ VGND VGND VPWR VPWR _2141_ sky130_fd_sc_hd__mux2_1
XFILLER_0_47_456 VGND VGND VPWR VPWR sky130_fd_sc_hd__decap_8
X_4926_ _2481_ VGND VGND VPWR VPWR _0316_ sky130_fd_sc_hd__inv_2
X_4857_ _2473_ VGND VGND VPWR VPWR _0255_ sky130_fd_sc_hd__inv_2
X_3808_ _1983_ _1985_ VGND VGND VPWR VPWR _1986_ sky130_fd_sc_hd__xnor2_2
XFILLER_0_62_459 VGND VGND VPWR VPWR sky130_fd_sc_hd__decap_3
XFILLER_0_27_191 VGND VGND VPWR VPWR sky130_fd_sc_hd__decap_3
X_4788_ _2466_ VGND VGND VPWR VPWR _0193_ sky130_fd_sc_hd__inv_2
X_3739_ _1690_ _1731_ _1689_ VGND VGND VPWR VPWR _1925_ sky130_fd_sc_hd__a21o_1
X_5409_ clknet_leaf_30_clk net32 VGND VGND VPWR VPWR disp.digits\[8\] sky130_fd_sc_hd__dfxtp_1
XTAP_TAPCELL_ROW_86_966 VGND VPWR sky130_fd_sc_hd__tapvpwrvgnd_1
XFILLER_0_38_456 VGND VGND VPWR VPWR sky130_fd_sc_hd__decap_8
XTAP_TAPCELL_ROW_41_557 VGND VPWR sky130_fd_sc_hd__tapvpwrvgnd_1
XFILLER_0_65_253 VPWR VGND VPWR VGND sky130_ef_sc_hd__decap_12
XFILLER_0_33_150 VPWR VGND VPWR VGND sky130_ef_sc_hd__decap_12
XFILLER_0_21_367 VPWR VGND VPWR VGND sky130_ef_sc_hd__decap_12
XFILLER_0_56_37 VGND VGND VPWR VPWR sky130_fd_sc_hd__fill_2
XFILLER_0_56_48 VGND VGND VPWR VPWR sky130_fd_sc_hd__decap_8
X_2972_ _1191_ VGND VGND VPWR VPWR _0704_ sky130_fd_sc_hd__clkbuf_1
XFILLER_0_29_489 VGND VGND VPWR VPWR sky130_fd_sc_hd__decap_8
X_4711_ _2451_ VGND VGND VPWR VPWR _2456_ sky130_fd_sc_hd__clkbuf_8
XFILLER_0_56_253 VGND VGND VPWR VPWR sky130_fd_sc_hd__decap_4
XFILLER_0_4_501 VPWR VGND VPWR VGND sky130_ef_sc_hd__decap_12
X_4642_ _2445_ VGND VGND VPWR VPWR _0068_ sky130_fd_sc_hd__inv_2
XFILLER_0_71_256 VGND VGND VPWR VPWR sky130_fd_sc_hd__fill_1
XFILLER_0_21_51 VGND VGND VPWR VPWR sky130_fd_sc_hd__decap_4
X_4573_ _2435_ VGND VGND VPWR VPWR _2436_ sky130_fd_sc_hd__buf_2
XFILLER_0_24_172 VGND VGND VPWR VPWR sky130_fd_sc_hd__decap_3
X_3524_ net11 _1715_ VGND VGND VPWR VPWR _1716_ sky130_fd_sc_hd__or2_1
X_3455_ _1648_ _0798_ _1632_ VGND VGND VPWR VPWR _1649_ sky130_fd_sc_hd__or3b_4
X_3386_ RF0.regs\[7\]\[28\] _1245_ VGND VGND VPWR VPWR _1580_ sky130_fd_sc_hd__and2_1
XTAP_TAPCELL_ROW_4_227 VGND VPWR sky130_fd_sc_hd__tapvpwrvgnd_1
XFILLER_0_34_3 VGND VGND VPWR VPWR sky130_fd_sc_hd__decap_6
X_5125_ clknet_leaf_25_clk _0501_ _0117_ VGND VGND VPWR VPWR RF0.regs\[12\]\[12\]
+ sky130_fd_sc_hd__dfrtp_1
XFILLER_0_79_301 VGND VGND VPWR VPWR sky130_fd_sc_hd__fill_1
X_5056_ clknet_leaf_29_clk _0432_ _0048_ VGND VGND VPWR VPWR RF0.regs\[20\]\[7\] sky130_fd_sc_hd__dfrtp_1
X_4007_ _2131_ VGND VGND VPWR VPWR _0622_ sky130_fd_sc_hd__clkbuf_1
XTAP_TAPCELL_ROW_83_936 VGND VPWR sky130_fd_sc_hd__tapvpwrvgnd_1
XFILLER_0_79_356 VGND VGND VPWR VPWR sky130_fd_sc_hd__decap_8
XFILLER_0_79_378 VGND VGND VPWR VPWR sky130_fd_sc_hd__fill_1
XFILLER_0_47_231 VGND VGND VPWR VPWR sky130_fd_sc_hd__fill_1
X_4909_ _2479_ VGND VGND VPWR VPWR _0301_ sky130_fd_sc_hd__inv_2
XFILLER_0_62_267 VGND VGND VPWR VPWR sky130_fd_sc_hd__decap_3
XFILLER_0_30_197 VGND VGND VPWR VPWR sky130_fd_sc_hd__fill_2
Xhold41 RF0.regs\[2\]\[18\] VGND VGND VPWR VPWR net89 sky130_fd_sc_hd__dlygate4sd3_1
Xhold30 RF0.regs\[7\]\[28\] VGND VGND VPWR VPWR net78 sky130_fd_sc_hd__dlygate4sd3_1
Xhold63 RF0.regs\[7\]\[6\] VGND VGND VPWR VPWR net111 sky130_fd_sc_hd__dlygate4sd3_1
XFILLER_0_26_29 VGND VGND VPWR VPWR sky130_fd_sc_hd__decap_6
Xhold52 RF0.regs\[0\]\[9\] VGND VGND VPWR VPWR net100 sky130_fd_sc_hd__dlygate4sd3_1
Xhold74 RF0.regs\[0\]\[27\] VGND VGND VPWR VPWR net122 sky130_fd_sc_hd__dlygate4sd3_1
Xhold85 RF0.regs\[0\]\[20\] VGND VGND VPWR VPWR net133 sky130_fd_sc_hd__dlygate4sd3_1
XTAP_TAPCELL_ROW_46_605 VGND VPWR sky130_fd_sc_hd__tapvpwrvgnd_1
Xhold96 RF0.regs\[7\]\[26\] VGND VGND VPWR VPWR net144 sky130_fd_sc_hd__dlygate4sd3_1
XFILLER_0_38_220 VGND VGND VPWR VPWR sky130_fd_sc_hd__decap_4
XFILLER_0_38_231 VGND VGND VPWR VPWR sky130_fd_sc_hd__fill_2
XTAP_TAPCELL_ROW_54_671 VGND VPWR sky130_fd_sc_hd__tapvpwrvgnd_1
XFILLER_0_38_253 VPWR VGND VPWR VGND sky130_ef_sc_hd__decap_12
XFILLER_0_34_481 VGND VGND VPWR VPWR sky130_fd_sc_hd__fill_1
XFILLER_0_34_492 VGND VGND VPWR VPWR sky130_fd_sc_hd__fill_1
XFILLER_0_21_164 VGND VGND VPWR VPWR sky130_fd_sc_hd__decap_4
X_3240_ _1042_ _1434_ VGND VGND VPWR VPWR _1436_ sky130_fd_sc_hd__and2_1
X_3171_ _1365_ _1366_ _1300_ VGND VGND VPWR VPWR _1367_ sky130_fd_sc_hd__mux2_4
XFILLER_0_83_57 VPWR VGND VPWR VGND sky130_ef_sc_hd__decap_12
XTAP_TAPCELL_ROW_80_906 VGND VPWR sky130_fd_sc_hd__tapvpwrvgnd_1
XTAP_TAPCELL_ROW_17_340 VGND VPWR sky130_fd_sc_hd__tapvpwrvgnd_1
XFILLER_0_84_392 VGND VGND VPWR VPWR sky130_fd_sc_hd__decap_4
X_2955_ net83 VGND VGND VPWR VPWR _1183_ sky130_fd_sc_hd__clkbuf_1
XFILLER_0_32_83 VGND VGND VPWR VPWR sky130_fd_sc_hd__fill_1
XFILLER_0_44_223 VGND VGND VPWR VPWR sky130_fd_sc_hd__decap_8
X_2886_ _1108_ IM0.addr\[1\] _1147_ VGND VGND VPWR VPWR _0746_ sky130_fd_sc_hd__a21o_1
X_4625_ _2444_ VGND VGND VPWR VPWR _0052_ sky130_fd_sc_hd__inv_2
X_4556_ _2427_ VGND VGND VPWR VPWR net16 sky130_fd_sc_hd__buf_1
XFILLER_0_40_451 VPWR VGND VPWR VGND sky130_ef_sc_hd__decap_12
X_3507_ RF0.regs\[10\]\[16\] _0813_ _1222_ RF0.regs\[25\]\[16\] VGND VGND VPWR VPWR
+ _1700_ sky130_fd_sc_hd__a22o_1
X_4487_ _2382_ VGND VGND VPWR VPWR _0394_ sky130_fd_sc_hd__clkbuf_1
X_3438_ _1631_ _1523_ _1518_ _1509_ VGND VGND VPWR VPWR _1632_ sky130_fd_sc_hd__a211o_1
X_3369_ _1561_ _1563_ VGND VGND VPWR VPWR _1564_ sky130_fd_sc_hd__and2_1
X_5108_ clknet_leaf_0_clk _0484_ _0100_ VGND VGND VPWR VPWR RF0.regs\[15\]\[27\] sky130_fd_sc_hd__dfrtp_1
X_5039_ clknet_leaf_8_clk _0415_ _0031_ VGND VGND VPWR VPWR RF0.regs\[25\]\[22\] sky130_fd_sc_hd__dfrtp_2
XFILLER_0_79_164 VGND VGND VPWR VPWR sky130_fd_sc_hd__decap_4
XFILLER_0_79_186 VGND VGND VPWR VPWR sky130_fd_sc_hd__fill_2
XFILLER_0_35_223 VGND VGND VPWR VPWR sky130_fd_sc_hd__fill_1
XTAP_TAPCELL_ROW_51_652 VGND VPWR sky130_fd_sc_hd__tapvpwrvgnd_1
XTAP_TAPCELL_ROW_23_398 VGND VPWR sky130_fd_sc_hd__tapvpwrvgnd_1
XFILLER_0_50_248 VGND VGND VPWR VPWR sky130_fd_sc_hd__decap_4
Xoutput42 net42 VGND VGND VPWR VPWR seg[4] sky130_fd_sc_hd__buf_2
Xoutput31 net31 VGND VGND VPWR VPWR Result[7] sky130_fd_sc_hd__buf_2
XFILLER_0_31_473 VGND VGND VPWR VPWR sky130_fd_sc_hd__decap_4
Xoutput20 net20 VGND VGND VPWR VPWR Result[26] sky130_fd_sc_hd__buf_2
Xoutput7 net7 VGND VGND VPWR VPWR Result[14] sky130_fd_sc_hd__buf_2
XFILLER_0_85_167 VGND VGND VPWR VPWR sky130_fd_sc_hd__fill_1
XFILLER_0_85_145 VGND VGND VPWR VPWR sky130_fd_sc_hd__fill_2
XFILLER_0_26_201 VGND VGND VPWR VPWR sky130_fd_sc_hd__fill_1
X_2740_ _1023_ _1025_ _1028_ _1030_ _1031_ VGND VGND VPWR VPWR _1032_ sky130_fd_sc_hd__a221o_1
XFILLER_0_81_384 VGND VGND VPWR VPWR sky130_fd_sc_hd__decap_8
XFILLER_0_14_418 VGND VGND VPWR VPWR sky130_fd_sc_hd__fill_2
X_2671_ RF0.regs\[15\]\[27\] _0855_ _0879_ RF0.regs\[2\]\[27\] _0962_ VGND VGND VPWR
+ VPWR _0963_ sky130_fd_sc_hd__a221o_1
X_4410_ _2342_ VGND VGND VPWR VPWR _0431_ sky130_fd_sc_hd__clkbuf_1
XFILLER_0_1_301 VPWR VGND VPWR VGND sky130_ef_sc_hd__decap_12
X_5390_ clknet_leaf_43_clk _0766_ _0382_ VGND VGND VPWR VPWR IM0.addr\[21\] sky130_fd_sc_hd__dfrtp_1
X_4341_ _2306_ VGND VGND VPWR VPWR _0464_ sky130_fd_sc_hd__clkbuf_1
X_4272_ net119 VGND VGND VPWR VPWR _2270_ sky130_fd_sc_hd__clkbuf_1
X_3223_ _1418_ _1391_ VGND VGND VPWR VPWR _1419_ sky130_fd_sc_hd__nor2_1
X_3154_ _1277_ _1332_ _1329_ VGND VGND VPWR VPWR _1350_ sky130_fd_sc_hd__a21o_1
X_3085_ _0800_ _1263_ VGND VGND VPWR VPWR _1281_ sky130_fd_sc_hd__nand2_1
XFILLER_0_49_337 VGND VGND VPWR VPWR sky130_fd_sc_hd__fill_2
XTAP_TAPCELL_ROW_65_777 VGND VPWR sky130_fd_sc_hd__tapvpwrvgnd_1
XFILLER_0_64_307 VGND VGND VPWR VPWR sky130_fd_sc_hd__fill_1
X_3987_ RF0.regs\[5\]\[14\] _2063_ _2113_ VGND VGND VPWR VPWR _2121_ sky130_fd_sc_hd__mux2_1
XFILLER_0_17_201 VGND VGND VPWR VPWR sky130_fd_sc_hd__decap_4
XFILLER_0_17_234 VGND VGND VPWR VPWR sky130_fd_sc_hd__decap_3
X_2938_ _1174_ VGND VGND VPWR VPWR _0721_ sky130_fd_sc_hd__clkbuf_1
XFILLER_0_72_351 VGND VGND VPWR VPWR sky130_fd_sc_hd__decap_4
XFILLER_0_60_513 VGND VGND VPWR VPWR sky130_fd_sc_hd__decap_4
X_2869_ _1117_ net213 VGND VGND VPWR VPWR _1135_ sky130_fd_sc_hd__and2_1
XTAP_TAPCELL_ROW_20_368 VGND VPWR sky130_fd_sc_hd__tapvpwrvgnd_1
XFILLER_0_4_194 VGND VGND VPWR VPWR sky130_fd_sc_hd__fill_2
X_4608_ _2441_ VGND VGND VPWR VPWR _0038_ sky130_fd_sc_hd__inv_2
X_4539_ _1149_ _1878_ VGND VGND VPWR VPWR _2421_ sky130_fd_sc_hd__and2_1
XFILLER_0_40_270 VGND VGND VPWR VPWR sky130_fd_sc_hd__fill_2
XFILLER_0_55_307 VGND VGND VPWR VPWR sky130_fd_sc_hd__decap_3
XFILLER_0_67_167 VGND VGND VPWR VPWR sky130_fd_sc_hd__fill_1
Xrebuffer8 _1550_ VGND VGND VPWR VPWR net56 sky130_fd_sc_hd__clkbuf_2
XFILLER_0_64_15 VGND VGND VPWR VPWR sky130_fd_sc_hd__decap_8
XFILLER_0_64_26 VGND VGND VPWR VPWR sky130_fd_sc_hd__fill_2
XFILLER_0_86_421 VPWR VGND VPWR VGND sky130_ef_sc_hd__decap_12
X_4890_ _2476_ VGND VGND VPWR VPWR _0285_ sky130_fd_sc_hd__inv_2
X_3910_ _1241_ VGND VGND VPWR VPWR _2073_ sky130_fd_sc_hd__buf_4
XTAP_TAPCELL_ROW_62_747 VGND VPWR sky130_fd_sc_hd__tapvpwrvgnd_1
X_3841_ _1759_ _1769_ _1921_ _1758_ VGND VGND VPWR VPWR _2011_ sky130_fd_sc_hd__o31ai_4
X_3772_ _1955_ _1956_ VGND VGND VPWR VPWR _1957_ sky130_fd_sc_hd__xor2_2
X_2723_ RF0.regs\[5\]\[31\] _0876_ _0855_ RF0.regs\[15\]\[31\] _1014_ VGND VGND VPWR
+ VPWR _1015_ sky130_fd_sc_hd__a221o_1
XFILLER_0_54_362 VGND VGND VPWR VPWR sky130_fd_sc_hd__fill_2
XFILLER_0_14_237 VGND VGND VPWR VPWR sky130_fd_sc_hd__decap_3
XFILLER_0_14_248 VGND VGND VPWR VPWR sky130_fd_sc_hd__decap_4
X_2654_ RF0.regs\[10\]\[6\] _0809_ _0827_ RF0.regs\[25\]\[6\] _0945_ VGND VGND VPWR
+ VPWR _0946_ sky130_fd_sc_hd__a221o_2
X_5373_ clknet_leaf_42_clk _0749_ _0365_ VGND VGND VPWR VPWR IM0.addr\[4\] sky130_fd_sc_hd__dfrtp_1
X_2585_ _0849_ _0870_ _0793_ _0787_ VGND VGND VPWR VPWR _0877_ sky130_fd_sc_hd__and4bb_4
X_4324_ _2297_ VGND VGND VPWR VPWR _0472_ sky130_fd_sc_hd__clkbuf_1
X_4255_ _2261_ VGND VGND VPWR VPWR _0505_ sky130_fd_sc_hd__clkbuf_1
X_3206_ _1278_ _1282_ _1286_ VGND VGND VPWR VPWR _1402_ sky130_fd_sc_hd__o21ai_1
X_4186_ _2226_ VGND VGND VPWR VPWR _0539_ sky130_fd_sc_hd__clkbuf_1
XTAP_TAPCELL_ROW_78_891 VGND VPWR sky130_fd_sc_hd__tapvpwrvgnd_1
X_3137_ _1329_ _1332_ VGND VGND VPWR VPWR _1333_ sky130_fd_sc_hd__nand2_1
XFILLER_0_77_432 VGND VGND VPWR VPWR sky130_fd_sc_hd__decap_8
X_3068_ _1263_ VGND VGND VPWR VPWR _1264_ sky130_fd_sc_hd__buf_4
XTAP_TAPCELL_ROW_25_416 VGND VPWR sky130_fd_sc_hd__tapvpwrvgnd_1
XFILLER_0_49_167 VGND VGND VPWR VPWR sky130_fd_sc_hd__fill_1
XFILLER_0_64_137 VGND VGND VPWR VPWR sky130_fd_sc_hd__decap_3
XTAP_TAPCELL_ROW_33_482 VGND VPWR sky130_fd_sc_hd__tapvpwrvgnd_1
XFILLER_0_72_192 VGND VGND VPWR VPWR sky130_fd_sc_hd__decap_4
XFILLER_0_13_270 VGND VGND VPWR VPWR sky130_fd_sc_hd__decap_8
Xhold160 RF0.regs\[20\]\[5\] VGND VGND VPWR VPWR net208 sky130_fd_sc_hd__dlygate4sd3_1
Xhold171 RF0.regs\[20\]\[7\] VGND VGND VPWR VPWR net219 sky130_fd_sc_hd__dlygate4sd3_1
Xhold193 RF0.regs\[6\]\[21\] VGND VGND VPWR VPWR net241 sky130_fd_sc_hd__dlygate4sd3_1
Xhold182 RF0.regs\[20\]\[31\] VGND VGND VPWR VPWR net230 sky130_fd_sc_hd__dlygate4sd3_1
XFILLER_0_68_421 VGND VGND VPWR VPWR sky130_fd_sc_hd__decap_3
XFILLER_0_83_413 VPWR VGND VPWR VGND sky130_ef_sc_hd__decap_12
XFILLER_0_51_321 VPWR VGND VPWR VGND sky130_ef_sc_hd__decap_12
XFILLER_0_63_181 VGND VGND VPWR VPWR sky130_fd_sc_hd__fill_2
XFILLER_0_3_429 VPWR VGND VPWR VGND sky130_ef_sc_hd__decap_12
XFILLER_0_51_343 VGND VGND VPWR VPWR sky130_fd_sc_hd__decap_6
XFILLER_0_59_48 VGND VGND VPWR VPWR sky130_fd_sc_hd__decap_8
X_4040_ _2137_ VGND VGND VPWR VPWR _2149_ sky130_fd_sc_hd__buf_4
XTAP_TAPCELL_ROW_75_861 VGND VPWR sky130_fd_sc_hd__tapvpwrvgnd_1
XFILLER_0_86_251 VGND VGND VPWR VPWR sky130_fd_sc_hd__fill_1
X_4942_ _2483_ VGND VGND VPWR VPWR _0330_ sky130_fd_sc_hd__inv_2
XFILLER_0_19_307 VGND VGND VPWR VPWR sky130_fd_sc_hd__fill_2
X_4873_ _2474_ VGND VGND VPWR VPWR _0270_ sky130_fd_sc_hd__inv_2
X_3824_ _1691_ net45 _1925_ VGND VGND VPWR VPWR _1998_ sky130_fd_sc_hd__a21boi_2
XFILLER_0_27_384 VGND VGND VPWR VPWR sky130_fd_sc_hd__decap_8
XTAP_TAPCELL_ROW_30_463 VGND VPWR sky130_fd_sc_hd__tapvpwrvgnd_1
XFILLER_0_40_72 VGND VGND VPWR VPWR sky130_fd_sc_hd__decap_4
X_3755_ _1603_ _1604_ VGND VGND VPWR VPWR _1941_ sky130_fd_sc_hd__nand2_1
X_3686_ RF0.regs\[20\]\[2\] _1220_ _1226_ RF0.regs\[15\]\[2\] _1871_ VGND VGND VPWR
+ VPWR _1872_ sky130_fd_sc_hd__a221o_1
XFILLER_0_42_365 VGND VGND VPWR VPWR sky130_fd_sc_hd__decap_4
X_2706_ RF0.regs\[4\]\[25\] _0838_ _0844_ RF0.regs\[12\]\[25\] VGND VGND VPWR VPWR
+ _0998_ sky130_fd_sc_hd__a22o_1
XPHY_EDGE_ROW_12_Right_12 VGND VGND VPWR VPWR sky130_fd_sc_hd__decap_3
XFILLER_0_30_516 VGND VGND VPWR VPWR sky130_fd_sc_hd__fill_1
X_2637_ RF0.regs\[2\]\[16\] _0878_ _0927_ _0928_ VGND VGND VPWR VPWR _0929_ sky130_fd_sc_hd__a211o_1
XFILLER_0_64_3 VPWR VGND VPWR VGND sky130_ef_sc_hd__decap_12
X_5356_ clknet_leaf_11_clk _0732_ _0348_ VGND VGND VPWR VPWR RF0.regs\[0\]\[19\] sky130_fd_sc_hd__dfrtp_1
XFILLER_0_10_240 VGND VGND VPWR VPWR sky130_fd_sc_hd__fill_1
X_2568_ _0821_ _0859_ VGND VGND VPWR VPWR _0860_ sky130_fd_sc_hd__nor2_4
X_4307_ _2288_ VGND VGND VPWR VPWR _0480_ sky130_fd_sc_hd__clkbuf_1
X_2499_ IM0.addr\[2\] IM0.addr\[1\] IM0.addr\[3\] VGND VGND VPWR VPWR _0791_ sky130_fd_sc_hd__o21a_1
X_5287_ clknet_leaf_22_clk _0663_ _0279_ VGND VGND VPWR VPWR RF0.regs\[4\]\[14\] sky130_fd_sc_hd__dfrtp_4
X_4238_ net199 VGND VGND VPWR VPWR _2253_ sky130_fd_sc_hd__clkbuf_1
XFILLER_0_4_83 VGND VGND VPWR VPWR sky130_fd_sc_hd__fill_1
XTAP_TAPCELL_ROW_38_530 VGND VPWR sky130_fd_sc_hd__tapvpwrvgnd_1
X_4169_ _2217_ VGND VGND VPWR VPWR _0547_ sky130_fd_sc_hd__clkbuf_1
XPHY_EDGE_ROW_21_Right_21 VGND VGND VPWR VPWR sky130_fd_sc_hd__decap_3
XFILLER_0_65_402 VPWR VGND VPWR VGND sky130_ef_sc_hd__decap_12
XFILLER_0_37_137 VGND VGND VPWR VPWR sky130_fd_sc_hd__fill_1
XFILLER_0_37_148 VGND VGND VPWR VPWR sky130_fd_sc_hd__fill_1
XFILLER_0_65_435 VGND VGND VPWR VPWR sky130_fd_sc_hd__fill_2
XFILLER_0_65_457 VGND VGND VPWR VPWR sky130_fd_sc_hd__fill_1
XFILLER_0_80_405 VPWR VGND VPWR VGND sky130_ef_sc_hd__decap_12
XFILLER_0_45_181 VGND VGND VPWR VPWR sky130_fd_sc_hd__decap_4
XFILLER_0_52_129 VGND VGND VPWR VPWR sky130_fd_sc_hd__decap_8
XPHY_EDGE_ROW_30_Right_30 VGND VGND VPWR VPWR sky130_fd_sc_hd__decap_3
XFILLER_0_60_195 VGND VGND VPWR VPWR sky130_fd_sc_hd__fill_1
XFILLER_0_56_402 VGND VGND VPWR VPWR sky130_fd_sc_hd__decap_8
XFILLER_0_28_137 VGND VGND VPWR VPWR sky130_fd_sc_hd__decap_3
XTAP_TAPCELL_ROW_44_588 VGND VPWR sky130_fd_sc_hd__tapvpwrvgnd_1
XFILLER_0_71_416 VGND VGND VPWR VPWR sky130_fd_sc_hd__decap_8
XFILLER_0_9_39 VPWR VGND VPWR VGND sky130_ef_sc_hd__decap_12
X_3540_ _1730_ _1731_ VGND VGND VPWR VPWR _1732_ sky130_fd_sc_hd__nand2_1
XFILLER_0_10_53 VPWR VGND VPWR VGND sky130_ef_sc_hd__decap_12
XFILLER_0_24_365 VGND VGND VPWR VPWR sky130_fd_sc_hd__decap_6
X_3471_ RF0.regs\[6\]\[21\] _1233_ _1229_ RF0.regs\[15\]\[21\] _1664_ VGND VGND VPWR
+ VPWR _1665_ sky130_fd_sc_hd__a221o_1
X_5210_ clknet_leaf_40_clk _0586_ _0202_ VGND VGND VPWR VPWR RF0.regs\[6\]\[1\] sky130_fd_sc_hd__dfrtp_1
XFILLER_0_24_398 VGND VGND VPWR VPWR sky130_fd_sc_hd__decap_6
X_5141_ clknet_leaf_0_clk _0517_ _0133_ VGND VGND VPWR VPWR RF0.regs\[12\]\[28\] sky130_fd_sc_hd__dfrtp_1
X_5072_ clknet_leaf_8_clk _0448_ _0064_ VGND VGND VPWR VPWR RF0.regs\[20\]\[23\] sky130_fd_sc_hd__dfrtp_1
XFILLER_0_19_51 VGND VGND VPWR VPWR sky130_fd_sc_hd__fill_2
X_4023_ _2140_ VGND VGND VPWR VPWR _0615_ sky130_fd_sc_hd__clkbuf_1
XFILLER_0_79_505 VPWR VGND VPWR VGND sky130_ef_sc_hd__decap_12
XTAP_TAPCELL_ROW_35_500 VGND VPWR sky130_fd_sc_hd__tapvpwrvgnd_1
XFILLER_0_47_424 VPWR VGND VPWR VGND sky130_ef_sc_hd__decap_12
XFILLER_0_47_446 VGND VGND VPWR VPWR sky130_fd_sc_hd__fill_2
X_4925_ _2481_ VGND VGND VPWR VPWR _0315_ sky130_fd_sc_hd__inv_2
X_4856_ _2473_ VGND VGND VPWR VPWR _0254_ sky130_fd_sc_hd__inv_2
X_3807_ _1650_ _1984_ _1931_ VGND VGND VPWR VPWR _1985_ sky130_fd_sc_hd__o21ai_1
X_4787_ _2466_ VGND VGND VPWR VPWR _0192_ sky130_fd_sc_hd__inv_2
XFILLER_0_15_343 VGND VGND VPWR VPWR sky130_fd_sc_hd__fill_1
X_3738_ _1732_ _1747_ _1923_ VGND VGND VPWR VPWR _1924_ sky130_fd_sc_hd__nor3_1
XFILLER_0_70_482 VGND VGND VPWR VPWR sky130_fd_sc_hd__decap_6
XFILLER_0_15_376 VGND VGND VPWR VPWR sky130_fd_sc_hd__decap_8
X_3669_ RF0.regs\[6\]\[4\] _1231_ _1227_ RF0.regs\[15\]\[4\] _1854_ VGND VGND VPWR
+ VPWR _1855_ sky130_fd_sc_hd__a221o_1
X_5408_ clknet_leaf_31_clk net31 VGND VGND VPWR VPWR disp.digits\[7\] sky130_fd_sc_hd__dfxtp_1
X_5339_ clknet_leaf_35_clk _0715_ _0331_ VGND VGND VPWR VPWR RF0.regs\[0\]\[2\] sky130_fd_sc_hd__dfrtp_1
XTAP_TAPCELL_ROW_86_967 VGND VPWR sky130_fd_sc_hd__tapvpwrvgnd_1
XFILLER_0_65_265 VGND VGND VPWR VPWR sky130_fd_sc_hd__decap_4
XTAP_TAPCELL_ROW_41_558 VGND VPWR sky130_fd_sc_hd__tapvpwrvgnd_1
XFILLER_0_33_162 VGND VGND VPWR VPWR sky130_fd_sc_hd__decap_6
XFILLER_0_21_335 VGND VGND VPWR VPWR sky130_fd_sc_hd__fill_1
XFILLER_0_72_15 VPWR VGND VPWR VGND sky130_ef_sc_hd__decap_12
XFILLER_0_72_37 VGND VGND VPWR VPWR sky130_fd_sc_hd__fill_2
XFILLER_0_29_402 VGND VGND VPWR VPWR sky130_fd_sc_hd__decap_3
XFILLER_0_29_446 VGND VGND VPWR VPWR sky130_fd_sc_hd__fill_2
X_2971_ net222 VGND VGND VPWR VPWR _1191_ sky130_fd_sc_hd__clkbuf_1
XFILLER_0_56_265 VGND VGND VPWR VPWR sky130_fd_sc_hd__fill_1
X_4710_ _2455_ VGND VGND VPWR VPWR _0126_ sky130_fd_sc_hd__inv_2
XFILLER_0_16_129 VGND VGND VPWR VPWR sky130_fd_sc_hd__fill_2
X_4641_ _2445_ VGND VGND VPWR VPWR _0067_ sky130_fd_sc_hd__inv_2
XFILLER_0_4_513 VGND VGND VPWR VPWR sky130_fd_sc_hd__decap_4
XTAP_TAPCELL_ROW_12_293 VGND VPWR sky130_fd_sc_hd__tapvpwrvgnd_1
X_4572_ reset VGND VGND VPWR VPWR _2435_ sky130_fd_sc_hd__buf_2
X_3523_ _1711_ _1712_ _1714_ _1217_ RF0.regs\[0\]\[18\] VGND VGND VPWR VPWR _1715_
+ sky130_fd_sc_hd__o32a_1
X_3454_ _1631_ _1518_ _1524_ _1509_ VGND VGND VPWR VPWR _1648_ sky130_fd_sc_hd__o211a_1
X_3385_ RF0.regs\[6\]\[28\] _1233_ _1229_ RF0.regs\[15\]\[28\] _1578_ VGND VGND VPWR
+ VPWR _1579_ sky130_fd_sc_hd__a221o_1
XTAP_TAPCELL_ROW_4_228 VGND VPWR sky130_fd_sc_hd__tapvpwrvgnd_1
X_5124_ clknet_leaf_15_clk _0500_ _0116_ VGND VGND VPWR VPWR RF0.regs\[12\]\[11\]
+ sky130_fd_sc_hd__dfrtp_1
X_5055_ clknet_leaf_32_clk _0431_ _0047_ VGND VGND VPWR VPWR RF0.regs\[20\]\[6\] sky130_fd_sc_hd__dfrtp_1
X_4006_ RF0.regs\[5\]\[5\] _2090_ _2124_ VGND VGND VPWR VPWR _2131_ sky130_fd_sc_hd__mux2_1
XFILLER_0_27_3 VPWR VGND VPWR VGND sky130_ef_sc_hd__decap_12
XTAP_TAPCELL_ROW_83_937 VGND VPWR sky130_fd_sc_hd__tapvpwrvgnd_1
XFILLER_0_79_335 VGND VGND VPWR VPWR sky130_fd_sc_hd__fill_1
XFILLER_0_1_51 VGND VGND VPWR VPWR sky130_fd_sc_hd__decap_4
XFILLER_0_47_221 VGND VGND VPWR VPWR sky130_fd_sc_hd__decap_3
X_4908_ _2479_ VGND VGND VPWR VPWR _0300_ sky130_fd_sc_hd__inv_2
X_4839_ _2470_ VGND VGND VPWR VPWR _0240_ sky130_fd_sc_hd__inv_2
XFILLER_0_35_449 VGND VGND VPWR VPWR sky130_fd_sc_hd__fill_2
Xhold20 disp.digit_select\[0\] VGND VGND VPWR VPWR net68 sky130_fd_sc_hd__dlygate4sd3_1
Xhold31 RF0.regs\[2\]\[1\] VGND VGND VPWR VPWR net79 sky130_fd_sc_hd__dlygate4sd3_1
Xhold42 RF0.regs\[7\]\[2\] VGND VGND VPWR VPWR net90 sky130_fd_sc_hd__dlygate4sd3_1
Xhold64 RF0.regs\[2\]\[10\] VGND VGND VPWR VPWR net112 sky130_fd_sc_hd__dlygate4sd3_1
Xhold53 RF0.regs\[0\]\[10\] VGND VGND VPWR VPWR net101 sky130_fd_sc_hd__dlygate4sd3_1
Xhold86 RF0.regs\[0\]\[23\] VGND VGND VPWR VPWR net134 sky130_fd_sc_hd__dlygate4sd3_1
Xhold75 RF0.regs\[2\]\[6\] VGND VGND VPWR VPWR net123 sky130_fd_sc_hd__dlygate4sd3_1
Xhold97 RF0.regs\[12\]\[28\] VGND VGND VPWR VPWR net145 sky130_fd_sc_hd__dlygate4sd3_1
XTAP_TAPCELL_ROW_46_606 VGND VPWR sky130_fd_sc_hd__tapvpwrvgnd_1
XFILLER_0_42_29 VGND VGND VPWR VPWR sky130_fd_sc_hd__fill_2
XTAP_TAPCELL_ROW_54_672 VGND VPWR sky130_fd_sc_hd__tapvpwrvgnd_1
XFILLER_0_53_279 VGND VGND VPWR VPWR sky130_fd_sc_hd__fill_1
XFILLER_0_1_505 VPWR VGND VPWR VGND sky130_ef_sc_hd__decap_12
XFILLER_0_6_29 VPWR VGND VPWR VGND sky130_ef_sc_hd__decap_12
X_3170_ _1220_ _1302_ VGND VGND VPWR VPWR _1366_ sky130_fd_sc_hd__or2_1
XFILLER_0_83_69 VPWR VGND VPWR VGND sky130_ef_sc_hd__decap_12
XFILLER_0_16_41 VPWR VGND VPWR VGND sky130_ef_sc_hd__decap_12
XTAP_TAPCELL_ROW_80_907 VGND VPWR sky130_fd_sc_hd__tapvpwrvgnd_1
XFILLER_0_16_85 VPWR VGND VPWR VGND sky130_ef_sc_hd__decap_12
XFILLER_0_76_349 VGND VGND VPWR VPWR sky130_fd_sc_hd__decap_8
XTAP_TAPCELL_ROW_17_341 VGND VPWR sky130_fd_sc_hd__tapvpwrvgnd_1
X_2954_ _1182_ VGND VGND VPWR VPWR _0713_ sky130_fd_sc_hd__clkbuf_1
X_2885_ net1 _0805_ _1102_ _1146_ VGND VGND VPWR VPWR _1147_ sky130_fd_sc_hd__and4_1
XFILLER_0_44_257 VGND VGND VPWR VPWR sky130_fd_sc_hd__fill_1
XPHY_EDGE_ROW_6_Right_6 VGND VGND VPWR VPWR sky130_fd_sc_hd__decap_3
X_4624_ _2444_ VGND VGND VPWR VPWR _0051_ sky130_fd_sc_hd__inv_2
XFILLER_0_4_365 VPWR VGND VPWR VGND sky130_ef_sc_hd__decap_12
X_4555_ _1648_ _1148_ _1632_ VGND VGND VPWR VPWR _2427_ sky130_fd_sc_hd__and3b_1
XFILLER_0_12_132 VGND VGND VPWR VPWR sky130_fd_sc_hd__decap_8
XFILLER_0_40_463 VGND VGND VPWR VPWR sky130_fd_sc_hd__decap_4
X_3506_ _1698_ _1499_ VGND VGND VPWR VPWR _1699_ sky130_fd_sc_hd__or2_1
X_4486_ RF0.regs\[25\]\[1\] _2099_ _0817_ VGND VGND VPWR VPWR _2382_ sky130_fd_sc_hd__mux2_1
X_3437_ _1501_ _1512_ VGND VGND VPWR VPWR _1631_ sky130_fd_sc_hd__or2_1
X_3368_ _1148_ _1550_ _1562_ VGND VGND VPWR VPWR _1563_ sky130_fd_sc_hd__nand3_1
X_5107_ clknet_leaf_6_clk _0483_ _0099_ VGND VGND VPWR VPWR RF0.regs\[15\]\[26\] sky130_fd_sc_hd__dfrtp_1
X_3299_ _1494_ _1485_ VGND VGND VPWR VPWR _1495_ sky130_fd_sc_hd__nand2_1
XFILLER_0_79_143 VGND VGND VPWR VPWR sky130_fd_sc_hd__fill_1
X_5038_ clknet_leaf_13_clk _0414_ _0030_ VGND VGND VPWR VPWR RF0.regs\[25\]\[21\]
+ sky130_fd_sc_hd__dfrtp_2
XTAP_TAPCELL_ROW_68_797 VGND VPWR sky130_fd_sc_hd__tapvpwrvgnd_1
XTAP_TAPCELL_ROW_23_399 VGND VPWR sky130_fd_sc_hd__tapvpwrvgnd_1
XFILLER_0_50_205 VGND VGND VPWR VPWR sky130_fd_sc_hd__fill_2
Xoutput10 net10 VGND VGND VPWR VPWR Result[17] sky130_fd_sc_hd__clkbuf_4
Xoutput43 net43 VGND VGND VPWR VPWR seg[5] sky130_fd_sc_hd__buf_2
Xoutput32 net32 VGND VGND VPWR VPWR Result[8] sky130_fd_sc_hd__buf_2
Xoutput21 net21 VGND VGND VPWR VPWR Result[27] sky130_fd_sc_hd__buf_2
Xoutput8 net8 VGND VGND VPWR VPWR Result[15] sky130_fd_sc_hd__buf_2
XTAP_TAPCELL_ROW_59_720 VGND VPWR sky130_fd_sc_hd__tapvpwrvgnd_1
XFILLER_0_85_113 VPWR VGND VPWR VGND sky130_ef_sc_hd__decap_12
XTAP_TAPCELL_ROW_14_311 VGND VPWR sky130_fd_sc_hd__tapvpwrvgnd_1
XFILLER_0_81_330 VGND VGND VPWR VPWR sky130_fd_sc_hd__decap_3
XFILLER_0_26_235 VGND VGND VPWR VPWR sky130_fd_sc_hd__decap_8
XPHY_EDGE_ROW_59_Right_59 VGND VGND VPWR VPWR sky130_fd_sc_hd__decap_3
XFILLER_0_81_352 VGND VGND VPWR VPWR sky130_fd_sc_hd__fill_1
X_2670_ RF0.regs\[5\]\[27\] _0961_ net54 VGND VGND VPWR VPWR _0962_ sky130_fd_sc_hd__and3_1
XFILLER_0_1_313 VPWR VGND VPWR VGND sky130_ef_sc_hd__decap_12
X_4340_ RF0.regs\[15\]\[7\] _2086_ _2301_ VGND VGND VPWR VPWR _2306_ sky130_fd_sc_hd__mux2_1
X_4271_ _2269_ VGND VGND VPWR VPWR _0497_ sky130_fd_sc_hd__clkbuf_1
X_3222_ _1340_ _1384_ _1416_ VGND VGND VPWR VPWR _1418_ sky130_fd_sc_hd__o21a_1
XPHY_EDGE_ROW_68_Right_68 VGND VGND VPWR VPWR sky130_fd_sc_hd__decap_3
X_3153_ RF0.regs\[4\]\[27\] _0838_ _1138_ RF0.regs\[12\]\[27\] _1348_ VGND VGND VPWR
+ VPWR _1349_ sky130_fd_sc_hd__a221o_1
X_3084_ RF0.regs\[4\]\[0\] _0862_ _0954_ _0955_ _1279_ VGND VGND VPWR VPWR _1280_
+ sky130_fd_sc_hd__a2111o_1
XTAP_TAPCELL_ROW_65_778 VGND VPWR sky130_fd_sc_hd__tapvpwrvgnd_1
XFILLER_0_76_146 VGND VGND VPWR VPWR sky130_fd_sc_hd__decap_8
XPHY_EDGE_ROW_77_Right_77 VGND VGND VPWR VPWR sky130_fd_sc_hd__decap_3
X_3986_ _2120_ VGND VGND VPWR VPWR _0632_ sky130_fd_sc_hd__clkbuf_1
XFILLER_0_9_446 VGND VGND VPWR VPWR sky130_fd_sc_hd__fill_2
X_2937_ net140 VGND VGND VPWR VPWR _1174_ sky130_fd_sc_hd__clkbuf_1
XFILLER_0_72_374 VGND VGND VPWR VPWR sky130_fd_sc_hd__decap_4
XFILLER_0_17_279 VGND VGND VPWR VPWR sky130_fd_sc_hd__fill_1
X_2868_ _1134_ VGND VGND VPWR VPWR _0751_ sky130_fd_sc_hd__clkbuf_1
XTAP_TAPCELL_ROW_20_369 VGND VPWR sky130_fd_sc_hd__tapvpwrvgnd_1
X_4607_ _2441_ VGND VGND VPWR VPWR _0037_ sky130_fd_sc_hd__inv_2
X_2799_ _1059_ _1061_ _1087_ _1089_ _1090_ VGND VGND VPWR VPWR _1091_ sky130_fd_sc_hd__o221a_1
X_4538_ _2419_ _2420_ VGND VGND VPWR VPWR _0006_ sky130_fd_sc_hd__nand2_1
X_4469_ _2373_ VGND VGND VPWR VPWR _0403_ sky130_fd_sc_hd__clkbuf_1
XPHY_EDGE_ROW_86_Right_86 VGND VGND VPWR VPWR sky130_fd_sc_hd__decap_3
XFILLER_0_68_91 VGND VGND VPWR VPWR sky130_fd_sc_hd__decap_3
XFILLER_0_67_113 VGND VGND VPWR VPWR sky130_fd_sc_hd__fill_1
XFILLER_0_48_382 VPWR VGND VPWR VGND sky130_ef_sc_hd__decap_12
XFILLER_0_23_205 VGND VGND VPWR VPWR sky130_fd_sc_hd__fill_2
Xrebuffer9 _1545_ VGND VGND VPWR VPWR net57 sky130_fd_sc_hd__dlymetal6s4s_1
XFILLER_0_63_385 VGND VGND VPWR VPWR sky130_fd_sc_hd__fill_1
XFILLER_0_63_396 VGND VGND VPWR VPWR sky130_fd_sc_hd__fill_1
XFILLER_0_16_290 VPWR VGND VPWR VGND sky130_ef_sc_hd__decap_12
XFILLER_0_48_17 VGND VGND VPWR VPWR sky130_fd_sc_hd__decap_6
XFILLER_0_86_433 VPWR VGND VPWR VGND sky130_ef_sc_hd__decap_12
XFILLER_0_80_15 VPWR VGND VPWR VGND sky130_ef_sc_hd__decap_12
XTAP_TAPCELL_ROW_62_748 VGND VPWR sky130_fd_sc_hd__tapvpwrvgnd_1
XFILLER_0_86_477 VPWR VGND VPWR VGND sky130_ef_sc_hd__decap_12
XFILLER_0_73_116 VPWR VGND VPWR VGND sky130_ef_sc_hd__decap_12
X_3840_ _1746_ _1922_ VGND VGND VPWR VPWR _2010_ sky130_fd_sc_hd__nand2_2
X_3771_ _1573_ _1949_ VGND VGND VPWR VPWR _1956_ sky130_fd_sc_hd__nor2_1
XFILLER_0_39_393 VGND VGND VPWR VPWR sky130_fd_sc_hd__fill_2
XFILLER_0_6_438 VGND VGND VPWR VPWR sky130_fd_sc_hd__fill_1
X_2722_ RF0.regs\[10\]\[31\] _0887_ VGND VGND VPWR VPWR _1014_ sky130_fd_sc_hd__and2_1
XFILLER_0_54_396 VPWR VGND VPWR VGND sky130_ef_sc_hd__decap_12
X_2653_ RF0.regs\[4\]\[6\] _0835_ _0842_ RF0.regs\[12\]\[6\] VGND VGND VPWR VPWR _0945_
+ sky130_fd_sc_hd__a22o_1
X_5372_ clknet_leaf_43_clk _0748_ _0364_ VGND VGND VPWR VPWR IM0.addr\[3\] sky130_fd_sc_hd__dfrtp_1
XFILLER_0_22_260 VGND VGND VPWR VPWR sky130_fd_sc_hd__decap_8
X_2584_ _0875_ VGND VGND VPWR VPWR _0876_ sky130_fd_sc_hd__clkbuf_4
X_4323_ RF0.regs\[15\]\[15\] _2012_ _2290_ VGND VGND VPWR VPWR _2297_ sky130_fd_sc_hd__mux2_1
XFILLER_0_22_293 VPWR VGND VPWR VGND sky130_ef_sc_hd__decap_12
XFILLER_0_10_477 VGND VGND VPWR VPWR sky130_fd_sc_hd__decap_6
XFILLER_0_38_72 VGND VGND VPWR VPWR sky130_fd_sc_hd__fill_2
X_4254_ RF0.regs\[12\]\[16\] VGND VGND VPWR VPWR _2261_ sky130_fd_sc_hd__clkbuf_1
X_3205_ _1278_ _1282_ _1286_ VGND VGND VPWR VPWR _1401_ sky130_fd_sc_hd__or3_1
X_4185_ RF0.regs\[10\]\[18\] _2002_ _2222_ VGND VGND VPWR VPWR _2226_ sky130_fd_sc_hd__mux2_1
X_3136_ _1258_ _1331_ VGND VGND VPWR VPWR _1332_ sky130_fd_sc_hd__nand2_1
XTAP_TAPCELL_ROW_78_892 VGND VPWR sky130_fd_sc_hd__tapvpwrvgnd_1
X_3067_ _1262_ VGND VGND VPWR VPWR _1263_ sky130_fd_sc_hd__clkbuf_4
XFILLER_0_54_60 VGND VGND VPWR VPWR sky130_fd_sc_hd__decap_8
XTAP_TAPCELL_ROW_25_417 VGND VPWR sky130_fd_sc_hd__tapvpwrvgnd_1
XFILLER_0_9_243 VGND VGND VPWR VPWR sky130_fd_sc_hd__decap_6
XFILLER_0_9_221 VGND VGND VPWR VPWR sky130_fd_sc_hd__decap_3
XFILLER_0_9_210 VGND VGND VPWR VPWR sky130_fd_sc_hd__decap_8
XFILLER_0_37_308 VPWR VGND VPWR VGND sky130_ef_sc_hd__decap_12
XFILLER_0_64_105 VGND VGND VPWR VPWR sky130_fd_sc_hd__decap_8
XFILLER_0_9_265 VGND VGND VPWR VPWR sky130_fd_sc_hd__decap_3
XFILLER_0_64_149 VGND VGND VPWR VPWR sky130_fd_sc_hd__fill_2
X_3969_ _2111_ VGND VGND VPWR VPWR _0640_ sky130_fd_sc_hd__clkbuf_1
XTAP_TAPCELL_ROW_33_483 VGND VPWR sky130_fd_sc_hd__tapvpwrvgnd_1
XFILLER_0_60_322 VGND VGND VPWR VPWR sky130_fd_sc_hd__fill_1
Xhold150 RF0.regs\[2\]\[3\] VGND VGND VPWR VPWR net198 sky130_fd_sc_hd__dlygate4sd3_1
Xhold161 RF0.regs\[12\]\[9\] VGND VGND VPWR VPWR net209 sky130_fd_sc_hd__dlygate4sd3_1
Xhold194 RF0.regs\[6\]\[23\] VGND VGND VPWR VPWR net242 sky130_fd_sc_hd__dlygate4sd3_1
Xhold172 IM0.addr\[11\] VGND VGND VPWR VPWR net220 sky130_fd_sc_hd__dlygate4sd3_1
Xhold183 RF0.regs\[12\]\[23\] VGND VGND VPWR VPWR net231 sky130_fd_sc_hd__dlygate4sd3_1
XFILLER_0_83_425 VPWR VGND VPWR VGND sky130_ef_sc_hd__decap_12
XFILLER_0_68_477 VGND VGND VPWR VPWR sky130_fd_sc_hd__fill_2
XFILLER_0_36_341 VGND VGND VPWR VPWR sky130_fd_sc_hd__decap_8
XFILLER_0_36_363 VGND VGND VPWR VPWR sky130_fd_sc_hd__fill_1
XFILLER_0_51_333 VGND VGND VPWR VPWR sky130_fd_sc_hd__decap_3
XFILLER_0_51_399 VGND VGND VPWR VPWR sky130_fd_sc_hd__fill_2
XFILLER_0_75_15 VPWR VGND VPWR VGND sky130_ef_sc_hd__decap_12
XTAP_TAPCELL_ROW_75_862 VGND VPWR sky130_fd_sc_hd__tapvpwrvgnd_1
X_4941_ _2483_ VGND VGND VPWR VPWR _0329_ sky130_fd_sc_hd__inv_2
X_4872_ _2474_ VGND VGND VPWR VPWR _0269_ sky130_fd_sc_hd__inv_2
XFILLER_0_46_116 VPWR VGND VPWR VGND sky130_ef_sc_hd__decap_12
XFILLER_0_59_477 VGND VGND VPWR VPWR sky130_fd_sc_hd__decap_6
X_3823_ _1997_ VGND VGND VPWR VPWR _0669_ sky130_fd_sc_hd__clkbuf_1
XFILLER_0_39_190 VGND VGND VPWR VPWR sky130_fd_sc_hd__decap_4
X_3754_ _1602_ VGND VGND VPWR VPWR _1940_ sky130_fd_sc_hd__inv_2
X_3685_ RF0.regs\[5\]\[2\] _0901_ _0860_ VGND VGND VPWR VPWR _1871_ sky130_fd_sc_hd__and3_1
X_2705_ RF0.regs\[2\]\[25\] _0880_ _0995_ _0996_ VGND VGND VPWR VPWR _0997_ sky130_fd_sc_hd__a211o_1
X_2636_ RF0.regs\[10\]\[16\] _0883_ _0863_ RF0.regs\[4\]\[16\] VGND VGND VPWR VPWR
+ _0928_ sky130_fd_sc_hd__a22o_1
X_5355_ clknet_leaf_12_clk _0731_ _0347_ VGND VGND VPWR VPWR RF0.regs\[0\]\[18\] sky130_fd_sc_hd__dfrtp_1
X_2567_ _0819_ _0858_ VGND VGND VPWR VPWR _0859_ sky130_fd_sc_hd__nand2_1
X_4306_ RF0.regs\[15\]\[23\] _1986_ _2279_ VGND VGND VPWR VPWR _2288_ sky130_fd_sc_hd__mux2_1
X_5286_ clknet_leaf_20_clk _0662_ _0278_ VGND VGND VPWR VPWR RF0.regs\[4\]\[13\] sky130_fd_sc_hd__dfrtp_2
X_2498_ IM0.addr\[7\] IM0.addr\[6\] IM0.addr\[5\] IM0.addr\[4\] VGND VGND VPWR VPWR
+ _0790_ sky130_fd_sc_hd__or4_4
X_4237_ _2252_ VGND VGND VPWR VPWR _0514_ sky130_fd_sc_hd__clkbuf_1
XTAP_TAPCELL_ROW_38_531 VGND VPWR sky130_fd_sc_hd__tapvpwrvgnd_1
X_4168_ RF0.regs\[10\]\[26\] _1975_ _2211_ VGND VGND VPWR VPWR _2217_ sky130_fd_sc_hd__mux2_1
X_4099_ net78 VGND VGND VPWR VPWR _2182_ sky130_fd_sc_hd__clkbuf_1
X_3119_ _1313_ _1314_ _1258_ VGND VGND VPWR VPWR _1315_ sky130_fd_sc_hd__o21a_1
XFILLER_0_77_241 VPWR VGND VPWR VGND sky130_ef_sc_hd__decap_12
XFILLER_0_80_417 VGND VGND VPWR VPWR sky130_fd_sc_hd__decap_3
XFILLER_0_73_480 VPWR VGND VPWR VGND sky130_ef_sc_hd__decap_12
XFILLER_0_60_141 VGND VGND VPWR VPWR sky130_fd_sc_hd__fill_1
XFILLER_0_33_399 VGND VGND VPWR VPWR sky130_fd_sc_hd__fill_2
XPHY_EDGE_ROW_14_Left_102 VGND VGND VPWR VPWR sky130_fd_sc_hd__decap_3
XTAP_TAPCELL_ROW_44_589 VGND VPWR sky130_fd_sc_hd__tapvpwrvgnd_1
XFILLER_0_43_108 VGND VGND VPWR VPWR sky130_fd_sc_hd__fill_1
XFILLER_0_51_130 VPWR VGND VPWR VGND sky130_ef_sc_hd__decap_12
XPHY_EDGE_ROW_23_Left_111 VGND VGND VPWR VPWR sky130_fd_sc_hd__decap_3
X_3470_ RF0.regs\[5\]\[21\] _0961_ _1139_ VGND VGND VPWR VPWR _1664_ sky130_fd_sc_hd__and3_1
XFILLER_0_10_65 VPWR VGND VPWR VGND sky130_ef_sc_hd__decap_12
XFILLER_0_51_185 VGND VGND VPWR VPWR sky130_fd_sc_hd__decap_4
XFILLER_0_51_196 VGND VGND VPWR VPWR sky130_fd_sc_hd__decap_4
X_5140_ clknet_leaf_3_clk _0516_ _0132_ VGND VGND VPWR VPWR RF0.regs\[12\]\[27\] sky130_fd_sc_hd__dfrtp_1
X_5071_ clknet_leaf_10_clk _0447_ _0063_ VGND VGND VPWR VPWR RF0.regs\[20\]\[22\]
+ sky130_fd_sc_hd__dfrtp_1
X_4022_ _1957_ net224 _2138_ VGND VGND VPWR VPWR _2140_ sky130_fd_sc_hd__mux2_1
XFILLER_0_29_7 VGND VGND VPWR VPWR sky130_fd_sc_hd__fill_1
XPHY_EDGE_ROW_32_Left_120 VGND VGND VPWR VPWR sky130_fd_sc_hd__decap_3
XFILLER_0_35_40 VPWR VGND VPWR VGND sky130_ef_sc_hd__decap_12
XTAP_TAPCELL_ROW_35_501 VGND VPWR sky130_fd_sc_hd__tapvpwrvgnd_1
X_4924_ _2481_ VGND VGND VPWR VPWR _0314_ sky130_fd_sc_hd__inv_2
XFILLER_0_47_436 VGND VGND VPWR VPWR sky130_fd_sc_hd__decap_4
X_4855_ _2473_ VGND VGND VPWR VPWR _0253_ sky130_fd_sc_hd__inv_2
X_4786_ _2466_ VGND VGND VPWR VPWR _0191_ sky130_fd_sc_hd__inv_2
X_3806_ _1663_ _1674_ _1928_ _1930_ VGND VGND VPWR VPWR _1984_ sky130_fd_sc_hd__o31a_1
XFILLER_0_62_428 VGND VGND VPWR VPWR sky130_fd_sc_hd__fill_2
X_3737_ _1759_ _1769_ _1921_ _1922_ _1758_ VGND VGND VPWR VPWR _1923_ sky130_fd_sc_hd__o311a_1
XFILLER_0_15_388 VGND VGND VPWR VPWR sky130_fd_sc_hd__fill_1
X_3668_ RF0.regs\[4\]\[4\] _1238_ VGND VGND VPWR VPWR _1854_ sky130_fd_sc_hd__and2_1
XFILLER_0_30_347 VGND VGND VPWR VPWR sky130_fd_sc_hd__fill_2
X_5407_ clknet_leaf_31_clk net30 VGND VGND VPWR VPWR disp.digits\[6\] sky130_fd_sc_hd__dfxtp_1
X_2619_ RF0.regs\[4\]\[7\] _0862_ _0877_ RF0.regs\[2\]\[7\] _0910_ VGND VGND VPWR
+ VPWR _0911_ sky130_fd_sc_hd__a221o_1
X_3599_ _1789_ _1434_ _1450_ _1447_ VGND VGND VPWR VPWR _1790_ sky130_fd_sc_hd__a22o_1
XTAP_TAPCELL_ROW_7_248 VGND VPWR sky130_fd_sc_hd__tapvpwrvgnd_1
X_5338_ clknet_leaf_41_clk _0714_ _0330_ VGND VGND VPWR VPWR RF0.regs\[0\]\[1\] sky130_fd_sc_hd__dfrtp_1
X_5269_ clknet_leaf_1_clk _0645_ _0261_ VGND VGND VPWR VPWR RF0.regs\[5\]\[28\] sky130_fd_sc_hd__dfrtp_1
XFILLER_0_25_119 VGND VGND VPWR VPWR sky130_fd_sc_hd__fill_2
XTAP_TAPCELL_ROW_41_559 VGND VPWR sky130_fd_sc_hd__tapvpwrvgnd_1
XFILLER_0_21_303 VGND VGND VPWR VPWR sky130_fd_sc_hd__decap_8
XFILLER_0_61_461 VGND VGND VPWR VPWR sky130_fd_sc_hd__decap_4
XTAP_TAPCELL_ROW_49_626 VGND VPWR sky130_fd_sc_hd__tapvpwrvgnd_1
XFILLER_0_72_27 VGND VGND VPWR VPWR sky130_fd_sc_hd__fill_1
XFILLER_0_29_436 VGND VGND VPWR VPWR sky130_fd_sc_hd__fill_2
X_2970_ _1190_ VGND VGND VPWR VPWR _0705_ sky130_fd_sc_hd__clkbuf_1
X_4640_ _2445_ VGND VGND VPWR VPWR _0066_ sky130_fd_sc_hd__inv_2
XTAP_TAPCELL_ROW_12_294 VGND VPWR sky130_fd_sc_hd__tapvpwrvgnd_1
XFILLER_0_24_152 VGND VGND VPWR VPWR sky130_fd_sc_hd__decap_3
X_4571_ _2434_ VGND VGND VPWR VPWR _0008_ sky130_fd_sc_hd__clkbuf_1
X_3522_ RF0.regs\[5\]\[18\] _0866_ _1228_ RF0.regs\[15\]\[18\] _1713_ VGND VGND VPWR
+ VPWR _1714_ sky130_fd_sc_hd__a221o_1
X_3453_ RF0.regs\[0\]\[22\] _1218_ _1646_ VGND VGND VPWR VPWR _1647_ sky130_fd_sc_hd__o21ai_2
X_3384_ RF0.regs\[5\]\[28\] _0961_ _1139_ VGND VGND VPWR VPWR _1578_ sky130_fd_sc_hd__and3_1
X_5123_ clknet_leaf_26_clk _0499_ _0115_ VGND VGND VPWR VPWR RF0.regs\[12\]\[10\]
+ sky130_fd_sc_hd__dfrtp_1
XTAP_TAPCELL_ROW_4_229 VGND VPWR sky130_fd_sc_hd__tapvpwrvgnd_1
X_5054_ clknet_leaf_33_clk _0430_ _0046_ VGND VGND VPWR VPWR RF0.regs\[20\]\[5\] sky130_fd_sc_hd__dfrtp_1
X_4005_ _2130_ VGND VGND VPWR VPWR _0623_ sky130_fd_sc_hd__clkbuf_1
XFILLER_0_46_83 VGND VGND VPWR VPWR sky130_fd_sc_hd__fill_1
XTAP_TAPCELL_ROW_83_938 VGND VPWR sky130_fd_sc_hd__tapvpwrvgnd_1
X_4907_ _2479_ VGND VGND VPWR VPWR _0299_ sky130_fd_sc_hd__inv_2
X_4838_ _2470_ VGND VGND VPWR VPWR _0239_ sky130_fd_sc_hd__inv_2
XFILLER_0_35_428 VGND VGND VPWR VPWR sky130_fd_sc_hd__decap_6
XFILLER_0_62_247 VGND VGND VPWR VPWR sky130_fd_sc_hd__decap_4
X_4769_ _2464_ VGND VGND VPWR VPWR _0176_ sky130_fd_sc_hd__inv_2
Xhold32 RF0.regs\[7\]\[13\] VGND VGND VPWR VPWR net80 sky130_fd_sc_hd__dlygate4sd3_1
Xhold21 disp.digit_select\[1\] VGND VGND VPWR VPWR net69 sky130_fd_sc_hd__dlygate4sd3_1
Xhold65 RF0.regs\[7\]\[21\] VGND VGND VPWR VPWR net113 sky130_fd_sc_hd__dlygate4sd3_1
Xhold54 RF0.regs\[0\]\[14\] VGND VGND VPWR VPWR net102 sky130_fd_sc_hd__dlygate4sd3_1
Xhold43 RF0.regs\[7\]\[30\] VGND VGND VPWR VPWR net91 sky130_fd_sc_hd__dlygate4sd3_1
Xhold76 RF0.regs\[7\]\[19\] VGND VGND VPWR VPWR net124 sky130_fd_sc_hd__dlygate4sd3_1
Xhold98 RF0.regs\[12\]\[26\] VGND VGND VPWR VPWR net146 sky130_fd_sc_hd__dlygate4sd3_1
XTAP_TAPCELL_ROW_46_607 VGND VPWR sky130_fd_sc_hd__tapvpwrvgnd_1
Xhold87 RF0.regs\[7\]\[25\] VGND VGND VPWR VPWR net135 sky130_fd_sc_hd__dlygate4sd3_1
XFILLER_0_85_317 VGND VGND VPWR VPWR sky130_fd_sc_hd__fill_1
XTAP_TAPCELL_ROW_54_673 VGND VPWR sky130_fd_sc_hd__tapvpwrvgnd_1
XPHY_EDGE_ROW_7_Left_95 VGND VGND VPWR VPWR sky130_fd_sc_hd__decap_3
XFILLER_0_53_225 VPWR VGND VPWR VGND sky130_ef_sc_hd__decap_12
XFILLER_0_34_450 VGND VGND VPWR VPWR sky130_fd_sc_hd__fill_2
XFILLER_0_34_472 VGND VGND VPWR VPWR sky130_fd_sc_hd__decap_4
XFILLER_0_21_122 VPWR VGND VPWR VGND sky130_ef_sc_hd__decap_12
XFILLER_0_61_291 VGND VGND VPWR VPWR sky130_fd_sc_hd__fill_1
XFILLER_0_21_177 VGND VGND VPWR VPWR sky130_fd_sc_hd__fill_1
XFILLER_0_83_15 VPWR VGND VPWR VGND sky130_ef_sc_hd__decap_12
XFILLER_0_16_53 VPWR VGND VPWR VGND sky130_ef_sc_hd__decap_12
XTAP_TAPCELL_ROW_80_908 VGND VPWR sky130_fd_sc_hd__tapvpwrvgnd_1
XFILLER_0_69_380 VGND VGND VPWR VPWR sky130_fd_sc_hd__decap_4
XTAP_TAPCELL_ROW_17_342 VGND VPWR sky130_fd_sc_hd__tapvpwrvgnd_1
XFILLER_0_16_97 VGND VGND VPWR VPWR sky130_fd_sc_hd__fill_1
X_2953_ net132 VGND VGND VPWR VPWR _1182_ sky130_fd_sc_hd__clkbuf_1
XFILLER_0_29_233 VGND VGND VPWR VPWR sky130_fd_sc_hd__decap_4
XFILLER_0_84_361 VGND VGND VPWR VPWR sky130_fd_sc_hd__decap_3
XFILLER_0_72_501 VPWR VGND VPWR VGND sky130_ef_sc_hd__decap_12
X_2884_ _0858_ _1145_ VGND VGND VPWR VPWR _1146_ sky130_fd_sc_hd__nor2_1
XFILLER_0_4_333 VPWR VGND VPWR VGND sky130_ef_sc_hd__decap_12
X_4623_ _2444_ VGND VGND VPWR VPWR _0050_ sky130_fd_sc_hd__inv_2
XFILLER_0_52_280 VGND VGND VPWR VPWR sky130_fd_sc_hd__decap_4
X_4554_ _2426_ VGND VGND VPWR VPWR net14 sky130_fd_sc_hd__clkbuf_1
XFILLER_0_4_377 VPWR VGND VPWR VGND sky130_ef_sc_hd__decap_12
X_3505_ _1477_ _1479_ VGND VGND VPWR VPWR _1698_ sky130_fd_sc_hd__and2_1
X_4485_ _2381_ VGND VGND VPWR VPWR _0395_ sky130_fd_sc_hd__clkbuf_1
XFILLER_0_12_155 VGND VGND VPWR VPWR sky130_fd_sc_hd__fill_2
X_3436_ _1506_ _1508_ VGND VGND VPWR VPWR _1630_ sky130_fd_sc_hd__nand2_1
X_3367_ _1345_ _1548_ _1549_ VGND VGND VPWR VPWR _1562_ sky130_fd_sc_hd__nand3_1
X_5106_ clknet_leaf_9_clk _0482_ _0098_ VGND VGND VPWR VPWR RF0.regs\[15\]\[25\] sky130_fd_sc_hd__dfrtp_2
X_5037_ clknet_leaf_13_clk _0413_ _0029_ VGND VGND VPWR VPWR RF0.regs\[25\]\[20\]
+ sky130_fd_sc_hd__dfrtp_2
X_3298_ RF0.regs\[4\]\[17\] _0837_ _1138_ RF0.regs\[12\]\[17\] _1493_ VGND VGND VPWR
+ VPWR _1494_ sky130_fd_sc_hd__a221o_1
XFILLER_0_79_111 VGND VGND VPWR VPWR sky130_fd_sc_hd__fill_1
XTAP_TAPCELL_ROW_68_798 VGND VPWR sky130_fd_sc_hd__tapvpwrvgnd_1
XFILLER_0_23_409 VGND VGND VPWR VPWR sky130_fd_sc_hd__decap_4
XFILLER_0_31_442 VGND VGND VPWR VPWR sky130_fd_sc_hd__decap_6
Xoutput9 net9 VGND VGND VPWR VPWR Result[16] sky130_fd_sc_hd__clkbuf_4
Xoutput11 net11 VGND VGND VPWR VPWR Result[18] sky130_fd_sc_hd__clkbuf_4
Xoutput22 net22 VGND VGND VPWR VPWR Result[28] sky130_fd_sc_hd__buf_2
Xoutput33 net33 VGND VGND VPWR VPWR Result[9] sky130_fd_sc_hd__buf_2
Xoutput44 net44 VGND VGND VPWR VPWR seg[6] sky130_fd_sc_hd__buf_2
XFILLER_0_9_3 VPWR VGND VPWR VGND sky130_ef_sc_hd__decap_12
XTAP_TAPCELL_ROW_59_721 VGND VPWR sky130_fd_sc_hd__tapvpwrvgnd_1
XFILLER_0_85_125 VPWR VGND VPWR VGND sky130_ef_sc_hd__decap_12
XFILLER_0_58_339 VGND VGND VPWR VPWR sky130_fd_sc_hd__fill_1
XTAP_TAPCELL_ROW_14_312 VGND VPWR sky130_fd_sc_hd__tapvpwrvgnd_1
XFILLER_0_85_169 VGND VGND VPWR VPWR sky130_fd_sc_hd__fill_1
XFILLER_0_14_409 VGND VGND VPWR VPWR sky130_fd_sc_hd__decap_6
XFILLER_0_78_15 VPWR VGND VPWR VGND sky130_ef_sc_hd__decap_12
XFILLER_0_1_325 VGND VGND VPWR VPWR sky130_fd_sc_hd__decap_4
XFILLER_0_22_475 VGND VGND VPWR VPWR sky130_fd_sc_hd__fill_1
X_4270_ net186 VGND VGND VPWR VPWR _2269_ sky130_fd_sc_hd__clkbuf_1
X_3221_ _1416_ _1385_ VGND VGND VPWR VPWR _1417_ sky130_fd_sc_hd__xnor2_1
X_3152_ RF0.regs\[10\]\[27\] _0815_ _1223_ RF0.regs\[25\]\[27\] VGND VGND VPWR VPWR
+ _1348_ sky130_fd_sc_hd__a22o_1
XFILLER_0_27_85 VGND VGND VPWR VPWR sky130_fd_sc_hd__decap_4
X_3083_ RF0.regs\[2\]\[0\] _1236_ _0852_ RF0.regs\[15\]\[0\] VGND VGND VPWR VPWR _1279_
+ sky130_fd_sc_hd__a22o_1
X_3985_ RF0.regs\[5\]\[15\] _2012_ _2113_ VGND VGND VPWR VPWR _2120_ sky130_fd_sc_hd__mux2_1
XFILLER_0_9_469 VGND VGND VPWR VPWR sky130_fd_sc_hd__decap_8
X_2936_ _1173_ VGND VGND VPWR VPWR _0722_ sky130_fd_sc_hd__clkbuf_1
X_2867_ _1117_ net238 VGND VGND VPWR VPWR _1134_ sky130_fd_sc_hd__and2_1
XFILLER_0_87_3 VPWR VGND VPWR VGND sky130_ef_sc_hd__decap_12
X_4606_ _2437_ VGND VGND VPWR VPWR _2441_ sky130_fd_sc_hd__buf_2
XFILLER_0_13_420 VGND VGND VPWR VPWR sky130_fd_sc_hd__fill_1
X_2798_ _1089_ _1087_ _1068_ _1066_ VGND VGND VPWR VPWR _1090_ sky130_fd_sc_hd__o2bb2a_1
X_4537_ _2412_ _2416_ _2404_ VGND VGND VPWR VPWR _2420_ sky130_fd_sc_hd__o21ai_1
XFILLER_0_13_475 VGND VGND VPWR VPWR sky130_fd_sc_hd__fill_1
XFILLER_0_7_51 VGND VGND VPWR VPWR sky130_fd_sc_hd__decap_4
X_4468_ RF0.regs\[25\]\[10\] _2077_ _2371_ VGND VGND VPWR VPWR _2373_ sky130_fd_sc_hd__mux2_1
X_3419_ RF0.regs\[4\]\[25\] _1240_ _1245_ RF0.regs\[7\]\[25\] _1612_ VGND VGND VPWR
+ VPWR _1613_ sky130_fd_sc_hd__a221o_1
X_4399_ net189 _2072_ _2336_ VGND VGND VPWR VPWR _2337_ sky130_fd_sc_hd__mux2_1
XTAP_TAPCELL_ROW_28_437 VGND VPWR sky130_fd_sc_hd__tapvpwrvgnd_1
XFILLER_0_82_106 VGND VGND VPWR VPWR sky130_fd_sc_hd__fill_2
XFILLER_0_48_361 VGND VGND VPWR VPWR sky130_fd_sc_hd__decap_3
XFILLER_0_82_128 VGND VGND VPWR VPWR sky130_fd_sc_hd__fill_1
XFILLER_0_48_394 VGND VGND VPWR VPWR sky130_fd_sc_hd__fill_1
XFILLER_0_51_515 VGND VGND VPWR VPWR sky130_fd_sc_hd__fill_2
XFILLER_0_48_29 VGND VGND VPWR VPWR sky130_fd_sc_hd__fill_1
XPHY_EDGE_ROW_79_Left_167 VGND VGND VPWR VPWR sky130_fd_sc_hd__decap_3
XFILLER_0_86_401 VPWR VGND VPWR VGND sky130_ef_sc_hd__decap_12
XFILLER_0_86_445 VPWR VGND VPWR VGND sky130_ef_sc_hd__decap_12
XFILLER_0_80_27 VGND VGND VPWR VPWR sky130_fd_sc_hd__fill_1
XTAP_TAPCELL_ROW_62_749 VGND VPWR sky130_fd_sc_hd__tapvpwrvgnd_1
XFILLER_0_86_489 VPWR VGND VPWR VGND sky130_ef_sc_hd__decap_12
XFILLER_0_73_128 VGND VGND VPWR VPWR sky130_fd_sc_hd__decap_6
X_3770_ _1564_ _1950_ VGND VGND VPWR VPWR _1955_ sky130_fd_sc_hd__and2b_1
X_2721_ RF0.regs\[10\]\[31\] _0816_ _0830_ RF0.regs\[25\]\[31\] _1012_ VGND VGND VPWR
+ VPWR _1013_ sky130_fd_sc_hd__a221o_2
X_2652_ RF0.regs\[2\]\[6\] _0877_ _0942_ _0943_ VGND VGND VPWR VPWR _0944_ sky130_fd_sc_hd__a211o_1
X_5371_ clknet_leaf_42_clk _0747_ _0363_ VGND VGND VPWR VPWR IM0.addr\[2\] sky130_fd_sc_hd__dfrtp_1
XFILLER_0_1_111 VGND VGND VPWR VPWR sky130_fd_sc_hd__fill_1
X_2583_ _0874_ VGND VGND VPWR VPWR _0875_ sky130_fd_sc_hd__clkbuf_4
X_4322_ _2296_ VGND VGND VPWR VPWR _0473_ sky130_fd_sc_hd__clkbuf_1
X_4253_ _2260_ VGND VGND VPWR VPWR _0506_ sky130_fd_sc_hd__clkbuf_1
XFILLER_0_59_7 VGND VGND VPWR VPWR sky130_fd_sc_hd__fill_1
X_3204_ _1395_ _1398_ _1399_ VGND VGND VPWR VPWR _1400_ sky130_fd_sc_hd__o21ai_1
X_4184_ _2225_ VGND VGND VPWR VPWR _0540_ sky130_fd_sc_hd__clkbuf_1
X_3135_ RF0.regs\[10\]\[27\] _0886_ _0855_ RF0.regs\[15\]\[27\] _1330_ VGND VGND VPWR
+ VPWR _1331_ sky130_fd_sc_hd__a221o_1
XTAP_TAPCELL_ROW_78_893 VGND VPWR sky130_fd_sc_hd__tapvpwrvgnd_1
X_3066_ _0801_ _0823_ VGND VGND VPWR VPWR _1262_ sky130_fd_sc_hd__nor2_1
XFILLER_0_77_423 VGND VGND VPWR VPWR sky130_fd_sc_hd__fill_1
XFILLER_0_54_83 VGND VGND VPWR VPWR sky130_fd_sc_hd__fill_1
XTAP_TAPCELL_ROW_25_418 VGND VPWR sky130_fd_sc_hd__tapvpwrvgnd_1
XFILLER_0_49_169 VGND VGND VPWR VPWR sky130_fd_sc_hd__decap_8
X_3968_ RF0.regs\[5\]\[23\] _1986_ _2102_ VGND VGND VPWR VPWR _2111_ sky130_fd_sc_hd__mux2_1
X_2919_ net95 VGND VGND VPWR VPWR _1165_ sky130_fd_sc_hd__clkbuf_1
XTAP_TAPCELL_ROW_33_484 VGND VPWR sky130_fd_sc_hd__tapvpwrvgnd_1
X_3899_ _2064_ VGND VGND VPWR VPWR _0663_ sky130_fd_sc_hd__clkbuf_1
XFILLER_0_5_461 VPWR VGND VPWR VGND sky130_ef_sc_hd__decap_12
XFILLER_0_60_356 VGND VGND VPWR VPWR sky130_fd_sc_hd__fill_1
Xhold162 RF0.regs\[20\]\[17\] VGND VGND VPWR VPWR net210 sky130_fd_sc_hd__dlygate4sd3_1
Xhold140 IM0.addr\[21\] VGND VGND VPWR VPWR net188 sky130_fd_sc_hd__dlygate4sd3_1
Xhold151 RF0.regs\[12\]\[24\] VGND VGND VPWR VPWR net199 sky130_fd_sc_hd__dlygate4sd3_1
Xhold184 RF0.regs\[6\]\[1\] VGND VGND VPWR VPWR net232 sky130_fd_sc_hd__dlygate4sd3_1
Xhold195 RF0.regs\[0\]\[7\] VGND VGND VPWR VPWR net243 sky130_fd_sc_hd__dlygate4sd3_1
Xhold173 RF0.regs\[20\]\[10\] VGND VGND VPWR VPWR net221 sky130_fd_sc_hd__dlygate4sd3_1
XFILLER_0_87_209 VPWR VGND VPWR VGND sky130_ef_sc_hd__decap_12
XFILLER_0_83_437 VGND VGND VPWR VPWR sky130_fd_sc_hd__decap_8
XFILLER_0_63_150 VGND VGND VPWR VPWR sky130_fd_sc_hd__decap_4
XFILLER_0_63_161 VGND VGND VPWR VPWR sky130_fd_sc_hd__decap_6
XFILLER_0_59_17 VGND VGND VPWR VPWR sky130_fd_sc_hd__fill_1
XFILLER_0_75_27 VPWR VGND VPWR VGND sky130_ef_sc_hd__decap_12
XFILLER_0_78_209 VGND VGND VPWR VPWR sky130_fd_sc_hd__decap_4
XTAP_TAPCELL_ROW_75_863 VGND VPWR sky130_fd_sc_hd__tapvpwrvgnd_1
X_4940_ _2480_ VGND VGND VPWR VPWR _2483_ sky130_fd_sc_hd__buf_4
XFILLER_0_59_434 VPWR VGND VPWR VGND sky130_ef_sc_hd__decap_12
XFILLER_0_86_253 VGND VGND VPWR VPWR sky130_fd_sc_hd__decap_4
X_4871_ _2474_ VGND VGND VPWR VPWR _0268_ sky130_fd_sc_hd__inv_2
X_3822_ RF0.regs\[4\]\[20\] _1996_ _1993_ VGND VGND VPWR VPWR _1997_ sky130_fd_sc_hd__mux2_1
XFILLER_0_46_128 VGND VGND VPWR VPWR sky130_fd_sc_hd__decap_4
XFILLER_0_46_139 VGND VGND VPWR VPWR sky130_fd_sc_hd__fill_1
XFILLER_0_6_247 VGND VGND VPWR VPWR sky130_fd_sc_hd__decap_4
X_3753_ _1542_ _1588_ VGND VGND VPWR VPWR _1939_ sky130_fd_sc_hd__xor2_1
XFILLER_0_54_150 VGND VGND VPWR VPWR sky130_fd_sc_hd__fill_1
X_3684_ _1400_ _1868_ VGND VGND VPWR VPWR _1870_ sky130_fd_sc_hd__or2_1
XFILLER_0_40_85 VGND VGND VPWR VPWR sky130_fd_sc_hd__fill_1
X_2704_ RF0.regs\[10\]\[25\] _0886_ _0865_ RF0.regs\[4\]\[25\] VGND VGND VPWR VPWR
+ _0996_ sky130_fd_sc_hd__a22o_1
X_2635_ RF0.regs\[5\]\[16\] _0874_ _0854_ RF0.regs\[15\]\[16\] VGND VGND VPWR VPWR
+ _0927_ sky130_fd_sc_hd__a22o_1
X_5354_ clknet_leaf_18_clk _0730_ _0346_ VGND VGND VPWR VPWR RF0.regs\[0\]\[17\] sky130_fd_sc_hd__dfrtp_1
XFILLER_0_2_475 VGND VGND VPWR VPWR sky130_fd_sc_hd__fill_1
XFILLER_0_10_253 VPWR VGND VPWR VGND sky130_ef_sc_hd__decap_12
X_2566_ IM0.addr\[1\] _0820_ VGND VGND VPWR VPWR _0858_ sky130_fd_sc_hd__and2_1
X_4305_ _2287_ VGND VGND VPWR VPWR _0481_ sky130_fd_sc_hd__clkbuf_1
X_2497_ IM0.addr\[11\] IM0.addr\[10\] IM0.addr\[9\] IM0.addr\[8\] VGND VGND VPWR VPWR
+ _0789_ sky130_fd_sc_hd__or4_4
X_5285_ clknet_leaf_24_clk _0661_ _0277_ VGND VGND VPWR VPWR RF0.regs\[4\]\[12\] sky130_fd_sc_hd__dfrtp_1
XFILLER_0_4_41 VPWR VGND VPWR VGND sky130_ef_sc_hd__decap_12
X_4236_ net152 VGND VGND VPWR VPWR _2252_ sky130_fd_sc_hd__clkbuf_1
XFILLER_0_4_85 VPWR VGND VPWR VGND sky130_ef_sc_hd__decap_12
X_4167_ _2216_ VGND VGND VPWR VPWR _0548_ sky130_fd_sc_hd__clkbuf_1
X_3118_ RF0.regs\[2\]\[21\] _1238_ _0854_ RF0.regs\[15\]\[21\] _1021_ VGND VGND VPWR
+ VPWR _1314_ sky130_fd_sc_hd__a221o_1
X_4098_ _2181_ VGND VGND VPWR VPWR _0582_ sky130_fd_sc_hd__clkbuf_1
XTAP_TAPCELL_ROW_38_532 VGND VPWR sky130_fd_sc_hd__tapvpwrvgnd_1
X_3049_ _1244_ VGND VGND VPWR VPWR _1245_ sky130_fd_sc_hd__clkbuf_4
XFILLER_0_81_81 VGND VGND VPWR VPWR sky130_fd_sc_hd__fill_2
XFILLER_0_77_253 VPWR VGND VPWR VGND sky130_ef_sc_hd__decap_12
XFILLER_0_33_312 VGND VGND VPWR VPWR sky130_fd_sc_hd__fill_1
XFILLER_0_73_492 VPWR VGND VPWR VGND sky130_ef_sc_hd__decap_12
XFILLER_0_60_164 VGND VGND VPWR VPWR sky130_fd_sc_hd__decap_6
XTAP_TAPCELL_ROW_72_833 VGND VPWR sky130_fd_sc_hd__tapvpwrvgnd_1
XFILLER_0_24_301 VGND VGND VPWR VPWR sky130_fd_sc_hd__decap_6
XFILLER_0_24_356 VGND VGND VPWR VPWR sky130_fd_sc_hd__decap_8
XFILLER_0_51_142 VPWR VGND VPWR VGND sky130_ef_sc_hd__decap_12
XFILLER_0_10_77 VGND VGND VPWR VPWR sky130_fd_sc_hd__decap_6
XFILLER_0_86_15 VPWR VGND VPWR VGND sky130_ef_sc_hd__decap_12
X_5070_ clknet_leaf_11_clk _0446_ _0062_ VGND VGND VPWR VPWR RF0.regs\[20\]\[21\]
+ sky130_fd_sc_hd__dfrtp_1
X_4021_ _2139_ VGND VGND VPWR VPWR _0616_ sky130_fd_sc_hd__clkbuf_1
XFILLER_0_35_52 VGND VGND VPWR VPWR sky130_fd_sc_hd__decap_4
XTAP_TAPCELL_ROW_35_502 VGND VPWR sky130_fd_sc_hd__tapvpwrvgnd_1
X_4923_ _2481_ VGND VGND VPWR VPWR _0313_ sky130_fd_sc_hd__inv_2
XFILLER_0_19_117 VGND VGND VPWR VPWR sky130_fd_sc_hd__fill_1
X_4854_ _2473_ VGND VGND VPWR VPWR _0252_ sky130_fd_sc_hd__inv_2
XFILLER_0_7_501 VGND VGND VPWR VPWR sky130_fd_sc_hd__decap_3
X_3805_ _1641_ _1651_ VGND VGND VPWR VPWR _1983_ sky130_fd_sc_hd__or2b_1
X_4785_ _2462_ VGND VGND VPWR VPWR _2466_ sky130_fd_sc_hd__clkbuf_8
XFILLER_0_27_150 VPWR VGND VPWR VGND sky130_ef_sc_hd__decap_12
X_3736_ _1738_ _1745_ VGND VGND VPWR VPWR _1922_ sky130_fd_sc_hd__or2_1
XFILLER_0_15_334 VGND VGND VPWR VPWR sky130_fd_sc_hd__fill_2
XFILLER_0_15_367 VGND VGND VPWR VPWR sky130_fd_sc_hd__decap_3
X_3667_ _1390_ _1391_ _1413_ VGND VGND VPWR VPWR _1853_ sky130_fd_sc_hd__a21o_1
X_5406_ clknet_leaf_32_clk net29 VGND VGND VPWR VPWR disp.digits\[5\] sky130_fd_sc_hd__dfxtp_1
X_2618_ RF0.regs\[5\]\[7\] _0901_ _0871_ VGND VGND VPWR VPWR _0910_ sky130_fd_sc_hd__and3_1
X_3598_ RF0.regs\[4\]\[8\] _0836_ _1138_ RF0.regs\[12\]\[8\] _1788_ VGND VGND VPWR
+ VPWR _1789_ sky130_fd_sc_hd__a221o_1
X_5337_ clknet_leaf_41_clk _0713_ _0329_ VGND VGND VPWR VPWR RF0.regs\[0\]\[0\] sky130_fd_sc_hd__dfrtp_1
X_2549_ _0840_ VGND VGND VPWR VPWR _0841_ sky130_fd_sc_hd__clkbuf_4
XTAP_TAPCELL_ROW_7_249 VGND VPWR sky130_fd_sc_hd__tapvpwrvgnd_1
X_5268_ clknet_leaf_6_clk _0644_ _0260_ VGND VGND VPWR VPWR RF0.regs\[5\]\[27\] sky130_fd_sc_hd__dfrtp_1
XFILLER_0_76_81 VGND VGND VPWR VPWR sky130_fd_sc_hd__decap_3
X_4219_ _2243_ VGND VGND VPWR VPWR _0523_ sky130_fd_sc_hd__clkbuf_1
X_5199_ clknet_leaf_10_clk _0575_ _0191_ VGND VGND VPWR VPWR RF0.regs\[7\]\[22\] sky130_fd_sc_hd__dfrtp_1
XFILLER_0_65_212 VGND VGND VPWR VPWR sky130_fd_sc_hd__fill_1
XFILLER_0_0_209 VPWR VGND VPWR VGND sky130_ef_sc_hd__decap_12
XFILLER_0_33_175 VGND VGND VPWR VPWR sky130_fd_sc_hd__fill_1
XFILLER_0_61_484 VPWR VGND VPWR VGND sky130_ef_sc_hd__decap_12
XFILLER_0_21_348 VGND VGND VPWR VPWR sky130_fd_sc_hd__fill_1
XFILLER_0_56_29 VGND VGND VPWR VPWR sky130_fd_sc_hd__decap_4
XTAP_TAPCELL_ROW_49_627 VGND VPWR sky130_fd_sc_hd__tapvpwrvgnd_1
XFILLER_0_56_245 VGND VGND VPWR VPWR sky130_fd_sc_hd__decap_6
XFILLER_0_71_204 VGND VGND VPWR VPWR sky130_fd_sc_hd__fill_1
XFILLER_0_44_407 VPWR VGND VPWR VGND sky130_ef_sc_hd__decap_12
X_4570_ _2385_ _2386_ VGND VGND VPWR VPWR _2434_ sky130_fd_sc_hd__or2_1
XTAP_TAPCELL_ROW_12_295 VGND VPWR sky130_fd_sc_hd__tapvpwrvgnd_1
X_3521_ RF0.regs\[25\]\[18\] _0814_ _0896_ _1246_ VGND VGND VPWR VPWR _1713_ sky130_fd_sc_hd__a211o_1
XFILLER_0_12_337 VGND VGND VPWR VPWR sky130_fd_sc_hd__fill_2
XFILLER_0_12_304 VGND VGND VPWR VPWR sky130_fd_sc_hd__fill_1
XFILLER_0_24_197 VGND VGND VPWR VPWR sky130_fd_sc_hd__fill_2
X_3452_ RF0.regs\[7\]\[22\] _1244_ _1643_ _1645_ VGND VGND VPWR VPWR _1646_ sky130_fd_sc_hd__a211o_1
X_3383_ _1575_ _1576_ _1545_ _1577_ _1219_ VGND VGND VPWR VPWR net22 sky130_fd_sc_hd__o2111a_1
X_5122_ clknet_leaf_38_clk _0498_ _0114_ VGND VGND VPWR VPWR RF0.regs\[12\]\[9\] sky130_fd_sc_hd__dfrtp_1
X_5053_ clknet_leaf_34_clk _0429_ _0045_ VGND VGND VPWR VPWR RF0.regs\[20\]\[4\] sky130_fd_sc_hd__dfrtp_1
XFILLER_0_79_315 VPWR VGND VPWR VGND sky130_ef_sc_hd__decap_12
X_4004_ RF0.regs\[5\]\[6\] _2088_ _2124_ VGND VGND VPWR VPWR _2130_ sky130_fd_sc_hd__mux2_1
XFILLER_0_46_73 VGND VGND VPWR VPWR sky130_fd_sc_hd__decap_3
XTAP_TAPCELL_ROW_83_939 VGND VPWR sky130_fd_sc_hd__tapvpwrvgnd_1
X_4906_ _2471_ VGND VGND VPWR VPWR _2479_ sky130_fd_sc_hd__buf_4
X_4837_ _2470_ VGND VGND VPWR VPWR _0238_ sky130_fd_sc_hd__inv_2
XFILLER_0_35_407 VGND VGND VPWR VPWR sky130_fd_sc_hd__fill_1
XFILLER_0_47_267 VGND VGND VPWR VPWR sky130_fd_sc_hd__decap_6
XFILLER_0_7_364 VGND VGND VPWR VPWR sky130_fd_sc_hd__decap_8
X_4768_ _2464_ VGND VGND VPWR VPWR _0175_ sky130_fd_sc_hd__inv_2
XFILLER_0_62_259 VGND VGND VPWR VPWR sky130_fd_sc_hd__decap_8
X_3719_ _1851_ _1900_ _1904_ VGND VGND VPWR VPWR _1905_ sky130_fd_sc_hd__a21oi_2
X_4699_ _2454_ VGND VGND VPWR VPWR _0116_ sky130_fd_sc_hd__inv_2
Xhold22 RF0.regs\[0\]\[13\] VGND VGND VPWR VPWR net70 sky130_fd_sc_hd__dlygate4sd3_1
Xhold55 RF0.regs\[2\]\[13\] VGND VGND VPWR VPWR net103 sky130_fd_sc_hd__dlygate4sd3_1
Xhold33 RF0.regs\[7\]\[8\] VGND VGND VPWR VPWR net81 sky130_fd_sc_hd__dlygate4sd3_1
Xhold44 RF0.regs\[7\]\[10\] VGND VGND VPWR VPWR net92 sky130_fd_sc_hd__dlygate4sd3_1
Xhold77 RF0.regs\[7\]\[9\] VGND VGND VPWR VPWR net125 sky130_fd_sc_hd__dlygate4sd3_1
Xhold66 RF0.regs\[2\]\[26\] VGND VGND VPWR VPWR net114 sky130_fd_sc_hd__dlygate4sd3_1
Xhold99 RF0.regs\[2\]\[15\] VGND VGND VPWR VPWR net147 sky130_fd_sc_hd__dlygate4sd3_1
Xhold88 RF0.regs\[12\]\[14\] VGND VGND VPWR VPWR net136 sky130_fd_sc_hd__dlygate4sd3_1
XPHY_EDGE_ROW_51_Left_139 VGND VGND VPWR VPWR sky130_fd_sc_hd__decap_3
XTAP_TAPCELL_ROW_54_674 VGND VPWR sky130_fd_sc_hd__tapvpwrvgnd_1
XFILLER_0_53_204 VGND VGND VPWR VPWR sky130_fd_sc_hd__decap_6
XFILLER_0_53_248 VGND VGND VPWR VPWR sky130_fd_sc_hd__decap_6
XFILLER_0_53_237 VGND VGND VPWR VPWR sky130_fd_sc_hd__decap_4
XFILLER_0_21_101 VGND VGND VPWR VPWR sky130_fd_sc_hd__decap_8
XFILLER_0_61_281 VGND VGND VPWR VPWR sky130_fd_sc_hd__fill_1
XFILLER_0_21_134 VPWR VGND VPWR VGND sky130_ef_sc_hd__decap_12
XPHY_EDGE_ROW_60_Left_148 VGND VGND VPWR VPWR sky130_fd_sc_hd__decap_3
XFILLER_0_83_27 VPWR VGND VPWR VGND sky130_ef_sc_hd__decap_12
XFILLER_0_76_307 VGND VGND VPWR VPWR sky130_fd_sc_hd__fill_1
XFILLER_0_16_65 VPWR VGND VPWR VGND sky130_ef_sc_hd__decap_12
XTAP_TAPCELL_ROW_80_909 VGND VPWR sky130_fd_sc_hd__tapvpwrvgnd_1
XTAP_TAPCELL_ROW_17_343 VGND VPWR sky130_fd_sc_hd__tapvpwrvgnd_1
X_2952_ _1181_ VGND VGND VPWR VPWR _0714_ sky130_fd_sc_hd__clkbuf_1
XFILLER_0_29_223 VGND VGND VPWR VPWR sky130_fd_sc_hd__fill_1
XFILLER_0_72_513 VGND VGND VPWR VPWR sky130_fd_sc_hd__decap_4
XFILLER_0_8_139 VGND VGND VPWR VPWR sky130_fd_sc_hd__fill_1
XFILLER_0_29_256 VPWR VGND VPWR VGND sky130_ef_sc_hd__decap_12
XFILLER_0_29_289 VGND VGND VPWR VPWR sky130_fd_sc_hd__decap_6
XFILLER_0_44_204 VGND VGND VPWR VPWR sky130_fd_sc_hd__fill_1
X_2883_ IM0.addr\[1\] net67 VGND VGND VPWR VPWR _1145_ sky130_fd_sc_hd__nor2_1
XFILLER_0_4_312 VPWR VGND VPWR VGND sky130_ef_sc_hd__decap_12
X_4622_ _2444_ VGND VGND VPWR VPWR _0049_ sky130_fd_sc_hd__inv_2
XFILLER_0_4_345 VGND VGND VPWR VPWR sky130_fd_sc_hd__decap_3
X_4553_ _1149_ _1631_ _1659_ VGND VGND VPWR VPWR _2426_ sky130_fd_sc_hd__and3_1
X_3504_ RF0.regs\[0\]\[19\] _1218_ _1696_ VGND VGND VPWR VPWR _1697_ sky130_fd_sc_hd__o21ai_4
X_4484_ RF0.regs\[25\]\[2\] _2097_ _2371_ VGND VGND VPWR VPWR _2381_ sky130_fd_sc_hd__mux2_1
XFILLER_0_4_389 VPWR VGND VPWR VGND sky130_ef_sc_hd__decap_12
XFILLER_0_12_167 VPWR VGND VPWR VGND sky130_ef_sc_hd__decap_12
X_3435_ _1627_ _1628_ VGND VGND VPWR VPWR _1629_ sky130_fd_sc_hd__or2_1
X_3366_ RF0.regs\[0\]\[30\] _1219_ _1560_ VGND VGND VPWR VPWR _1561_ sky130_fd_sc_hd__o21ai_1
X_5105_ clknet_leaf_7_clk _0481_ _0097_ VGND VGND VPWR VPWR RF0.regs\[15\]\[24\] sky130_fd_sc_hd__dfrtp_1
X_3297_ RF0.regs\[10\]\[17\] _0812_ _1221_ RF0.regs\[25\]\[17\] VGND VGND VPWR VPWR
+ _1493_ sky130_fd_sc_hd__a22o_1
X_5036_ clknet_leaf_13_clk _0412_ _0028_ VGND VGND VPWR VPWR RF0.regs\[25\]\[19\]
+ sky130_fd_sc_hd__dfrtp_1
XFILLER_0_32_3 VPWR VGND VPWR VGND sky130_ef_sc_hd__decap_12
XTAP_TAPCELL_ROW_68_799 VGND VPWR sky130_fd_sc_hd__tapvpwrvgnd_1
XTAP_TAPCELL_ROW_51_644 VGND VPWR sky130_fd_sc_hd__tapvpwrvgnd_1
XFILLER_0_7_194 VPWR VGND VPWR VGND sky130_ef_sc_hd__decap_12
XFILLER_0_43_281 VGND VGND VPWR VPWR sky130_fd_sc_hd__decap_6
Xoutput12 net12 VGND VGND VPWR VPWR Result[19] sky130_fd_sc_hd__clkbuf_4
Xoutput34 net34 VGND VGND VPWR VPWR an[0] sky130_fd_sc_hd__buf_2
Xoutput23 net23 VGND VGND VPWR VPWR Result[29] sky130_fd_sc_hd__buf_6
XTAP_TAPCELL_ROW_59_722 VGND VPWR sky130_fd_sc_hd__tapvpwrvgnd_1
XFILLER_0_58_307 VGND VGND VPWR VPWR sky130_fd_sc_hd__fill_1
XFILLER_0_85_137 VGND VGND VPWR VPWR sky130_fd_sc_hd__decap_8
XTAP_TAPCELL_ROW_14_313 VGND VPWR sky130_fd_sc_hd__tapvpwrvgnd_1
XTAP_TAPCELL_ROW_22_390 VGND VPWR sky130_fd_sc_hd__tapvpwrvgnd_1
XFILLER_0_78_27 VGND VGND VPWR VPWR sky130_fd_sc_hd__fill_1
XFILLER_0_1_337 VPWR VGND VPWR VGND sky130_ef_sc_hd__decap_12
X_3220_ _1415_ VGND VGND VPWR VPWR _1416_ sky130_fd_sc_hd__inv_2
X_3151_ _1096_ _1346_ VGND VGND VPWR VPWR _1347_ sky130_fd_sc_hd__nand2_1
XFILLER_0_27_75 VGND VGND VPWR VPWR sky130_fd_sc_hd__fill_2
X_3082_ _1263_ _1072_ _1277_ VGND VGND VPWR VPWR _1278_ sky130_fd_sc_hd__o21a_1
XFILLER_0_27_97 VPWR VGND VPWR VGND sky130_ef_sc_hd__decap_12
XFILLER_0_76_126 VGND VGND VPWR VPWR sky130_fd_sc_hd__fill_1
X_3984_ _2119_ VGND VGND VPWR VPWR _0633_ sky130_fd_sc_hd__clkbuf_1
XFILLER_0_84_170 VGND VGND VPWR VPWR sky130_fd_sc_hd__fill_1
X_2935_ net100 VGND VGND VPWR VPWR _1173_ sky130_fd_sc_hd__clkbuf_1
XFILLER_0_17_248 VGND VGND VPWR VPWR sky130_fd_sc_hd__decap_4
X_2866_ _1133_ VGND VGND VPWR VPWR _0752_ sky130_fd_sc_hd__clkbuf_1
X_4605_ _2440_ VGND VGND VPWR VPWR _0036_ sky130_fd_sc_hd__inv_2
X_2797_ RF0.regs\[10\]\[23\] _0813_ _0829_ RF0.regs\[25\]\[23\] _1088_ VGND VGND VPWR
+ VPWR _1089_ sky130_fd_sc_hd__a221oi_4
X_4536_ _2390_ _2393_ _2397_ _2404_ VGND VGND VPWR VPWR _2419_ sky130_fd_sc_hd__or4_1
XFILLER_0_40_251 VGND VGND VPWR VPWR sky130_fd_sc_hd__fill_1
X_4467_ _2372_ VGND VGND VPWR VPWR _0404_ sky130_fd_sc_hd__clkbuf_1
X_4398_ _1225_ VGND VGND VPWR VPWR _2336_ sky130_fd_sc_hd__buf_4
X_3418_ RF0.regs\[10\]\[25\] _0887_ _0807_ RF0.regs\[25\]\[25\] _1247_ VGND VGND VPWR
+ VPWR _1612_ sky130_fd_sc_hd__a221o_1
X_3349_ _1542_ _1352_ _1543_ _1544_ VGND VGND VPWR VPWR _1545_ sky130_fd_sc_hd__a211o_1
X_5019_ clknet_leaf_36_clk _0395_ _0011_ VGND VGND VPWR VPWR RF0.regs\[25\]\[2\] sky130_fd_sc_hd__dfrtp_1
XTAP_TAPCELL_ROW_28_438 VGND VPWR sky130_fd_sc_hd__tapvpwrvgnd_1
XFILLER_0_67_104 VGND VGND VPWR VPWR sky130_fd_sc_hd__decap_8
XFILLER_0_67_148 VGND VGND VPWR VPWR sky130_fd_sc_hd__decap_6
XFILLER_0_51_505 VGND VGND VPWR VPWR sky130_fd_sc_hd__fill_2
XFILLER_0_31_295 VGND VGND VPWR VPWR sky130_fd_sc_hd__decap_3
XFILLER_0_86_413 VGND VGND VPWR VPWR sky130_fd_sc_hd__decap_6
XFILLER_0_58_115 VPWR VGND VPWR VGND sky130_ef_sc_hd__decap_12
XFILLER_0_86_457 VPWR VGND VPWR VGND sky130_ef_sc_hd__decap_12
XFILLER_0_13_55 VGND VGND VPWR VPWR sky130_fd_sc_hd__fill_1
XFILLER_0_13_77 VGND VGND VPWR VPWR sky130_fd_sc_hd__decap_3
X_2720_ RF0.regs\[4\]\[31\] _0839_ _0845_ RF0.regs\[12\]\[31\] VGND VGND VPWR VPWR
+ _1012_ sky130_fd_sc_hd__a22o_1
XFILLER_0_14_229 VGND VGND VPWR VPWR sky130_fd_sc_hd__fill_1
X_2651_ RF0.regs\[10\]\[6\] _0883_ _0862_ RF0.regs\[4\]\[6\] VGND VGND VPWR VPWR _0943_
+ sky130_fd_sc_hd__a22o_1
XFILLER_0_81_184 VGND VGND VPWR VPWR sky130_fd_sc_hd__decap_6
X_5370_ clknet_leaf_40_clk _0746_ _0362_ VGND VGND VPWR VPWR IM0.addr\[1\] sky130_fd_sc_hd__dfrtp_4
X_2582_ _0873_ VGND VGND VPWR VPWR _0874_ sky130_fd_sc_hd__buf_4
X_4321_ RF0.regs\[15\]\[16\] _2008_ _2290_ VGND VGND VPWR VPWR _2296_ sky130_fd_sc_hd__mux2_1
XFILLER_0_10_424 VGND VGND VPWR VPWR sky130_fd_sc_hd__fill_1
XFILLER_0_22_273 VGND VGND VPWR VPWR sky130_fd_sc_hd__fill_1
XFILLER_0_22_284 VGND VGND VPWR VPWR sky130_fd_sc_hd__fill_2
X_4252_ RF0.regs\[12\]\[17\] VGND VGND VPWR VPWR _2260_ sky130_fd_sc_hd__clkbuf_1
X_3203_ _1074_ _1394_ VGND VGND VPWR VPWR _1399_ sky130_fd_sc_hd__or2_1
X_4183_ RF0.regs\[10\]\[19\] _2000_ _2222_ VGND VGND VPWR VPWR _2225_ sky130_fd_sc_hd__mux2_1
X_3134_ RF0.regs\[2\]\[27\] _1239_ _0865_ RF0.regs\[4\]\[27\] _0962_ VGND VGND VPWR
+ VPWR _1330_ sky130_fd_sc_hd__a221o_1
XTAP_TAPCELL_ROW_78_894 VGND VPWR sky130_fd_sc_hd__tapvpwrvgnd_1
X_3065_ RF0.regs\[15\]\[30\] _0856_ _1259_ _1260_ VGND VGND VPWR VPWR _1261_ sky130_fd_sc_hd__a211oi_1
XFILLER_0_49_159 VGND VGND VPWR VPWR sky130_fd_sc_hd__decap_8
X_3967_ _2110_ VGND VGND VPWR VPWR _0641_ sky130_fd_sc_hd__clkbuf_1
X_2918_ _1164_ VGND VGND VPWR VPWR _0731_ sky130_fd_sc_hd__clkbuf_1
XTAP_TAPCELL_ROW_33_485 VGND VPWR sky130_fd_sc_hd__tapvpwrvgnd_1
XFILLER_0_45_332 VGND VGND VPWR VPWR sky130_fd_sc_hd__decap_4
Xclkbuf_leaf_30_clk clknet_2_2__leaf_clk VGND VGND VPWR VPWR clknet_leaf_30_clk sky130_fd_sc_hd__clkbuf_8
XFILLER_0_33_516 VGND VGND VPWR VPWR sky130_fd_sc_hd__fill_1
XFILLER_0_60_313 VGND VGND VPWR VPWR sky130_fd_sc_hd__fill_1
X_3898_ RF0.regs\[4\]\[14\] _2063_ _1993_ VGND VGND VPWR VPWR _2064_ sky130_fd_sc_hd__mux2_1
X_2849_ _1118_ net207 VGND VGND VPWR VPWR _1125_ sky130_fd_sc_hd__and2_1
XFILLER_0_5_473 VPWR VGND VPWR VGND sky130_ef_sc_hd__decap_12
XFILLER_0_13_284 VPWR VGND VPWR VGND sky130_ef_sc_hd__decap_12
X_4519_ _2399_ _2400_ _2404_ VGND VGND VPWR VPWR _2408_ sky130_fd_sc_hd__o21a_1
Xhold152 IM0.addr\[4\] VGND VGND VPWR VPWR net200 sky130_fd_sc_hd__dlygate4sd3_1
Xhold130 RF0.regs\[12\]\[30\] VGND VGND VPWR VPWR net178 sky130_fd_sc_hd__dlygate4sd3_1
Xhold141 RF0.regs\[20\]\[11\] VGND VGND VPWR VPWR net189 sky130_fd_sc_hd__dlygate4sd3_1
Xhold163 RF0.regs\[20\]\[6\] VGND VGND VPWR VPWR net211 sky130_fd_sc_hd__dlygate4sd3_1
Xhold185 IM0.addr\[7\] VGND VGND VPWR VPWR net233 sky130_fd_sc_hd__dlygate4sd3_1
Xhold174 RF0.regs\[2\]\[23\] VGND VGND VPWR VPWR net222 sky130_fd_sc_hd__dlygate4sd3_1
Xhold196 RF0.regs\[2\]\[25\] VGND VGND VPWR VPWR net244 sky130_fd_sc_hd__dlygate4sd3_1
XFILLER_0_83_449 VPWR VGND VPWR VGND sky130_ef_sc_hd__decap_12
Xclkbuf_leaf_21_clk clknet_2_3__leaf_clk VGND VGND VPWR VPWR clknet_leaf_21_clk sky130_fd_sc_hd__clkbuf_8
XFILLER_0_75_39 VPWR VGND VPWR VGND sky130_ef_sc_hd__decap_12
XTAP_TAPCELL_ROW_75_864 VGND VPWR sky130_fd_sc_hd__tapvpwrvgnd_1
XFILLER_0_59_402 VPWR VGND VPWR VGND sky130_ef_sc_hd__decap_12
XFILLER_0_59_446 VGND VGND VPWR VPWR sky130_fd_sc_hd__fill_2
X_4870_ _2474_ VGND VGND VPWR VPWR _0267_ sky130_fd_sc_hd__inv_2
X_3821_ _1990_ _1995_ VGND VGND VPWR VPWR _1996_ sky130_fd_sc_hd__nor2_2
XFILLER_0_24_98 VGND VGND VPWR VPWR sky130_fd_sc_hd__fill_1
XFILLER_0_27_343 VGND VGND VPWR VPWR sky130_fd_sc_hd__fill_1
Xclkbuf_leaf_12_clk clknet_2_1__leaf_clk VGND VGND VPWR VPWR clknet_leaf_12_clk sky130_fd_sc_hd__clkbuf_8
XFILLER_0_15_505 VGND VGND VPWR VPWR sky130_fd_sc_hd__decap_4
XTAP_TAPCELL_ROW_30_455 VGND VPWR sky130_fd_sc_hd__tapvpwrvgnd_1
XFILLER_0_40_42 VGND VGND VPWR VPWR sky130_fd_sc_hd__decap_6
X_3752_ _1595_ VGND VGND VPWR VPWR _1938_ sky130_fd_sc_hd__inv_2
X_3683_ _1400_ _1868_ VGND VGND VPWR VPWR _1869_ sky130_fd_sc_hd__nand2_1
X_2703_ RF0.regs\[5\]\[25\] _0876_ _0856_ RF0.regs\[15\]\[25\] VGND VGND VPWR VPWR
+ _0995_ sky130_fd_sc_hd__a22o_1
XFILLER_0_2_421 VPWR VGND VPWR VGND sky130_ef_sc_hd__decap_12
X_5422_ clknet_leaf_30_clk _0780_ VGND VGND VPWR VPWR net37 sky130_fd_sc_hd__dfxtp_1
XFILLER_0_42_379 VGND VGND VPWR VPWR sky130_fd_sc_hd__fill_2
X_2634_ RF0.regs\[10\]\[15\] _0811_ _0828_ RF0.regs\[25\]\[15\] _0925_ VGND VGND VPWR
+ VPWR _0926_ sky130_fd_sc_hd__a221o_2
X_5353_ clknet_leaf_18_clk _0729_ _0345_ VGND VGND VPWR VPWR RF0.regs\[0\]\[16\] sky130_fd_sc_hd__dfrtp_1
X_2565_ _0792_ net48 _0851_ VGND VGND VPWR VPWR _0857_ sky130_fd_sc_hd__and3_1
X_4304_ RF0.regs\[15\]\[24\] _1981_ _2279_ VGND VGND VPWR VPWR _2287_ sky130_fd_sc_hd__mux2_1
XFILLER_0_10_287 VGND VGND VPWR VPWR sky130_fd_sc_hd__fill_1
XFILLER_0_10_265 VPWR VGND VPWR VGND sky130_ef_sc_hd__decap_12
X_2496_ IM0.addr\[15\] IM0.addr\[14\] IM0.addr\[13\] IM0.addr\[12\] VGND VGND VPWR
+ VPWR _0788_ sky130_fd_sc_hd__or4_1
X_5284_ clknet_leaf_24_clk _0660_ _0276_ VGND VGND VPWR VPWR RF0.regs\[4\]\[11\] sky130_fd_sc_hd__dfrtp_2
X_4235_ _2251_ VGND VGND VPWR VPWR _0515_ sky130_fd_sc_hd__clkbuf_1
XFILLER_0_4_53 VPWR VGND VPWR VGND sky130_ef_sc_hd__decap_12
X_4166_ RF0.regs\[10\]\[27\] _1971_ _2211_ VGND VGND VPWR VPWR _2216_ sky130_fd_sc_hd__mux2_1
X_3117_ RF0.regs\[10\]\[21\] _0885_ _0864_ RF0.regs\[4\]\[21\] VGND VGND VPWR VPWR
+ _1313_ sky130_fd_sc_hd__a22o_1
X_4097_ net107 VGND VGND VPWR VPWR _2181_ sky130_fd_sc_hd__clkbuf_1
XTAP_TAPCELL_ROW_38_533 VGND VPWR sky130_fd_sc_hd__tapvpwrvgnd_1
X_3048_ _1243_ VGND VGND VPWR VPWR _1244_ sky130_fd_sc_hd__clkbuf_4
XFILLER_0_77_265 VPWR VGND VPWR VGND sky130_ef_sc_hd__decap_12
XFILLER_0_77_287 VGND VGND VPWR VPWR sky130_fd_sc_hd__fill_1
XFILLER_0_65_449 VGND VGND VPWR VPWR sky130_fd_sc_hd__decap_8
X_4999_ _2488_ VGND VGND VPWR VPWR _0382_ sky130_fd_sc_hd__inv_2
XFILLER_0_18_365 VGND VGND VPWR VPWR sky130_fd_sc_hd__decap_6
XFILLER_0_45_195 VGND VGND VPWR VPWR sky130_fd_sc_hd__fill_1
XFILLER_0_33_357 VGND VGND VPWR VPWR sky130_fd_sc_hd__fill_1
XFILLER_0_33_368 VGND VGND VPWR VPWR sky130_fd_sc_hd__fill_1
XFILLER_0_5_292 VGND VGND VPWR VPWR sky130_fd_sc_hd__decap_6
XTAP_TAPCELL_ROW_72_834 VGND VPWR sky130_fd_sc_hd__tapvpwrvgnd_1
XFILLER_0_28_129 VGND VGND VPWR VPWR sky130_fd_sc_hd__decap_8
XFILLER_0_36_195 VGND VGND VPWR VPWR sky130_fd_sc_hd__fill_1
XFILLER_0_51_121 VGND VGND VPWR VPWR sky130_fd_sc_hd__fill_1
XFILLER_0_64_493 VGND VGND VPWR VPWR sky130_fd_sc_hd__decap_4
XFILLER_0_51_154 VGND VGND VPWR VPWR sky130_fd_sc_hd__decap_8
XFILLER_0_86_27 VGND VGND VPWR VPWR sky130_fd_sc_hd__fill_1
X_4020_ _1952_ net266 _2138_ VGND VGND VPWR VPWR _2139_ sky130_fd_sc_hd__mux2_1
Xclkbuf_leaf_1_clk clknet_2_0__leaf_clk VGND VGND VPWR VPWR clknet_leaf_1_clk sky130_fd_sc_hd__clkbuf_8
XTAP_TAPCELL_ROW_35_503 VGND VPWR sky130_fd_sc_hd__tapvpwrvgnd_1
XFILLER_0_59_221 VGND VGND VPWR VPWR sky130_fd_sc_hd__decap_3
X_4922_ _2481_ VGND VGND VPWR VPWR _0312_ sky130_fd_sc_hd__inv_2
X_4853_ _2473_ VGND VGND VPWR VPWR _0251_ sky130_fd_sc_hd__inv_2
XFILLER_0_47_449 VGND VGND VPWR VPWR sky130_fd_sc_hd__fill_2
X_4784_ _2465_ VGND VGND VPWR VPWR _0190_ sky130_fd_sc_hd__inv_2
XFILLER_0_27_162 VGND VGND VPWR VPWR sky130_fd_sc_hd__decap_6
XTAP_TAPCELL_ROW_43_580 VGND VPWR sky130_fd_sc_hd__tapvpwrvgnd_1
XFILLER_0_51_96 VGND VGND VPWR VPWR sky130_fd_sc_hd__decap_3
XFILLER_0_55_460 VGND VGND VPWR VPWR sky130_fd_sc_hd__fill_1
X_3804_ _1982_ VGND VGND VPWR VPWR _0673_ sky130_fd_sc_hd__clkbuf_1
XFILLER_0_62_419 VGND VGND VPWR VPWR sky130_fd_sc_hd__fill_1
X_3735_ _1781_ _1918_ _1920_ VGND VGND VPWR VPWR _1921_ sky130_fd_sc_hd__a21oi_2
XFILLER_0_70_496 VPWR VGND VPWR VGND sky130_ef_sc_hd__decap_12
X_3666_ _1390_ _1391_ _1413_ VGND VGND VPWR VPWR _1852_ sky130_fd_sc_hd__nand3_1
X_5405_ clknet_leaf_31_clk net28 VGND VGND VPWR VPWR disp.digits\[4\] sky130_fd_sc_hd__dfxtp_1
XFILLER_0_30_316 VPWR VGND VPWR VGND sky130_ef_sc_hd__decap_12
XFILLER_0_42_187 VGND VGND VPWR VPWR sky130_fd_sc_hd__fill_2
X_2617_ _0887_ VGND VGND VPWR VPWR _0909_ sky130_fd_sc_hd__buf_4
X_3597_ RF0.regs\[10\]\[8\] _0811_ _1221_ RF0.regs\[25\]\[8\] VGND VGND VPWR VPWR
+ _1788_ sky130_fd_sc_hd__a22o_1
X_2548_ _0801_ _0818_ _0823_ VGND VGND VPWR VPWR _0840_ sky130_fd_sc_hd__or3_1
X_5336_ clknet_leaf_45_clk _0712_ _0328_ VGND VGND VPWR VPWR RF0.regs\[2\]\[31\] sky130_fd_sc_hd__dfrtp_1
X_5267_ clknet_leaf_6_clk _0643_ _0259_ VGND VGND VPWR VPWR RF0.regs\[5\]\[26\] sky130_fd_sc_hd__dfrtp_1
X_4218_ RF0.regs\[10\]\[2\] _2097_ _2233_ VGND VGND VPWR VPWR _2243_ sky130_fd_sc_hd__mux2_1
X_5198_ clknet_leaf_11_clk _0574_ _0190_ VGND VGND VPWR VPWR RF0.regs\[7\]\[21\] sky130_fd_sc_hd__dfrtp_1
XTAP_TAPCELL_ROW_86_959 VGND VPWR sky130_fd_sc_hd__tapvpwrvgnd_1
X_4149_ net129 VGND VGND VPWR VPWR _2207_ sky130_fd_sc_hd__clkbuf_1
XFILLER_0_65_279 VGND VGND VPWR VPWR sky130_fd_sc_hd__fill_1
Xclkload0 clknet_2_0__leaf_clk VGND VGND VPWR VPWR clkload0/X sky130_fd_sc_hd__clkbuf_8
XFILLER_0_61_496 VGND VGND VPWR VPWR sky130_fd_sc_hd__decap_8
XTAP_TAPCELL_ROW_49_628 VGND VPWR sky130_fd_sc_hd__tapvpwrvgnd_1
XFILLER_0_72_29 VGND VGND VPWR VPWR sky130_fd_sc_hd__decap_8
XFILLER_0_56_213 VGND VGND VPWR VPWR sky130_fd_sc_hd__fill_1
XFILLER_0_29_449 VGND VGND VPWR VPWR sky130_fd_sc_hd__decap_3
XFILLER_0_56_257 VGND VGND VPWR VPWR sky130_fd_sc_hd__fill_1
XFILLER_0_44_419 VGND VGND VPWR VPWR sky130_fd_sc_hd__fill_1
XFILLER_0_71_238 VPWR VGND VPWR VGND sky130_ef_sc_hd__decap_12
XFILLER_0_21_55 VGND VGND VPWR VPWR sky130_fd_sc_hd__fill_1
XFILLER_0_37_482 VPWR VGND VPWR VGND sky130_ef_sc_hd__decap_12
XTAP_TAPCELL_ROW_40_550 VGND VPWR sky130_fd_sc_hd__tapvpwrvgnd_1
X_3520_ RF0.regs\[7\]\[18\] _1244_ VGND VGND VPWR VPWR _1712_ sky130_fd_sc_hd__and2_1
XTAP_TAPCELL_ROW_12_296 VGND VPWR sky130_fd_sc_hd__tapvpwrvgnd_1
X_3451_ RF0.regs\[5\]\[22\] _0866_ _1223_ RF0.regs\[20\]\[22\] _1644_ VGND VGND VPWR
+ VPWR _1645_ sky130_fd_sc_hd__a221o_1
X_3382_ _0821_ IM0.addr\[1\] _0819_ VGND VGND VPWR VPWR _1577_ sky130_fd_sc_hd__or3b_2
X_5121_ clknet_leaf_27_clk _0497_ _0113_ VGND VGND VPWR VPWR RF0.regs\[12\]\[8\] sky130_fd_sc_hd__dfrtp_1
X_5052_ clknet_leaf_35_clk _0428_ _0044_ VGND VGND VPWR VPWR RF0.regs\[20\]\[3\] sky130_fd_sc_hd__dfrtp_1
X_4003_ _2129_ VGND VGND VPWR VPWR _0624_ sky130_fd_sc_hd__clkbuf_1
XFILLER_0_46_85 VGND VGND VPWR VPWR sky130_fd_sc_hd__decap_3
XFILLER_0_79_327 VGND VGND VPWR VPWR sky130_fd_sc_hd__decap_8
XFILLER_0_62_40 VGND VGND VPWR VPWR sky130_fd_sc_hd__fill_2
XFILLER_0_62_62 VPWR VGND VPWR VGND sky130_ef_sc_hd__decap_12
XFILLER_0_87_393 VPWR VGND VPWR VGND sky130_ef_sc_hd__decap_12
X_4905_ _2478_ VGND VGND VPWR VPWR _0298_ sky130_fd_sc_hd__inv_2
X_4836_ _2470_ VGND VGND VPWR VPWR _0237_ sky130_fd_sc_hd__inv_2
XFILLER_0_28_493 VGND VGND VPWR VPWR sky130_fd_sc_hd__decap_6
X_4767_ _2464_ VGND VGND VPWR VPWR _0174_ sky130_fd_sc_hd__inv_2
XFILLER_0_15_165 VGND VGND VPWR VPWR sky130_fd_sc_hd__decap_3
X_3718_ _1008_ _1850_ _1902_ _1903_ VGND VGND VPWR VPWR _1904_ sky130_fd_sc_hd__and4_1
XFILLER_0_43_496 VGND VGND VPWR VPWR sky130_fd_sc_hd__fill_1
X_4698_ _2454_ VGND VGND VPWR VPWR _0115_ sky130_fd_sc_hd__inv_2
X_3649_ RF0.regs\[4\]\[6\] _1238_ _1227_ RF0.regs\[15\]\[6\] VGND VGND VPWR VPWR _1835_
+ sky130_fd_sc_hd__a22o_1
XFILLER_0_30_179 VGND VGND VPWR VPWR sky130_fd_sc_hd__decap_4
XFILLER_0_87_81 VGND VGND VPWR VPWR sky130_fd_sc_hd__decap_3
X_5319_ clknet_leaf_16_clk _0695_ _0311_ VGND VGND VPWR VPWR RF0.regs\[2\]\[14\] sky130_fd_sc_hd__dfrtp_1
Xhold23 RF0.regs\[7\]\[7\] VGND VGND VPWR VPWR net71 sky130_fd_sc_hd__dlygate4sd3_1
Xhold56 RF0.regs\[0\]\[15\] VGND VGND VPWR VPWR net104 sky130_fd_sc_hd__dlygate4sd3_1
Xhold45 RF0.regs\[7\]\[14\] VGND VGND VPWR VPWR net93 sky130_fd_sc_hd__dlygate4sd3_1
XTAP_TAPCELL_ROW_3_220 VGND VPWR sky130_fd_sc_hd__tapvpwrvgnd_1
Xhold34 RF0.regs\[12\]\[2\] VGND VGND VPWR VPWR net82 sky130_fd_sc_hd__dlygate4sd3_1
Xhold89 RF0.regs\[0\]\[2\] VGND VGND VPWR VPWR net137 sky130_fd_sc_hd__dlygate4sd3_1
Xhold78 RF0.regs\[12\]\[4\] VGND VGND VPWR VPWR net126 sky130_fd_sc_hd__dlygate4sd3_1
Xhold67 RF0.regs\[12\]\[11\] VGND VGND VPWR VPWR net115 sky130_fd_sc_hd__dlygate4sd3_1
XTAP_TAPCELL_ROW_54_675 VGND VPWR sky130_fd_sc_hd__tapvpwrvgnd_1
XFILLER_0_81_503 VGND VGND VPWR VPWR sky130_fd_sc_hd__fill_1
XFILLER_0_21_146 VPWR VGND VPWR VGND sky130_ef_sc_hd__decap_12
XFILLER_0_83_39 VPWR VGND VPWR VGND sky130_ef_sc_hd__decap_12
XFILLER_0_16_77 VGND VGND VPWR VPWR sky130_fd_sc_hd__decap_6
XTAP_TAPCELL_ROW_17_344 VGND VPWR sky130_fd_sc_hd__tapvpwrvgnd_1
XFILLER_0_29_213 VGND VGND VPWR VPWR sky130_fd_sc_hd__fill_2
X_2951_ net156 VGND VGND VPWR VPWR _1181_ sky130_fd_sc_hd__clkbuf_1
XFILLER_0_17_408 VGND VGND VPWR VPWR sky130_fd_sc_hd__fill_1
XFILLER_0_29_268 VGND VGND VPWR VPWR sky130_fd_sc_hd__decap_4
XFILLER_0_32_32 VGND VGND VPWR VPWR sky130_fd_sc_hd__fill_2
X_2882_ net1 _0819_ _1143_ _1144_ VGND VGND VPWR VPWR _0747_ sky130_fd_sc_hd__o22a_1
X_4621_ _2442_ VGND VGND VPWR VPWR _2444_ sky130_fd_sc_hd__clkbuf_8
XFILLER_0_4_324 VGND VGND VPWR VPWR sky130_fd_sc_hd__decap_3
X_4552_ _2425_ VGND VGND VPWR VPWR net12 sky130_fd_sc_hd__buf_1
X_3503_ RF0.regs\[20\]\[19\] _1223_ _1692_ _1695_ VGND VGND VPWR VPWR _1696_ sky130_fd_sc_hd__a211o_1
X_4483_ _2380_ VGND VGND VPWR VPWR _0396_ sky130_fd_sc_hd__clkbuf_1
XFILLER_0_12_179 VPWR VGND VPWR VGND sky130_ef_sc_hd__decap_12
X_3434_ _1624_ _1626_ VGND VGND VPWR VPWR _1628_ sky130_fd_sc_hd__nor2_1
X_3365_ RF0.regs\[15\]\[30\] _1229_ _1556_ _1559_ VGND VGND VPWR VPWR _1560_ sky130_fd_sc_hd__a211o_1
X_5104_ clknet_leaf_9_clk _0480_ _0096_ VGND VGND VPWR VPWR RF0.regs\[15\]\[23\] sky130_fd_sc_hd__dfrtp_2
X_3296_ _1482_ _1485_ _1490_ _1491_ VGND VGND VPWR VPWR _1492_ sky130_fd_sc_hd__o211a_1
X_5035_ clknet_leaf_13_clk _0411_ _0027_ VGND VGND VPWR VPWR RF0.regs\[25\]\[18\]
+ sky130_fd_sc_hd__dfrtp_1
XFILLER_0_79_113 VGND VGND VPWR VPWR sky130_fd_sc_hd__decap_8
XFILLER_0_79_102 VGND VGND VPWR VPWR sky130_fd_sc_hd__decap_3
XFILLER_0_79_135 VGND VGND VPWR VPWR sky130_fd_sc_hd__decap_8
XTAP_TAPCELL_ROW_51_645 VGND VPWR sky130_fd_sc_hd__tapvpwrvgnd_1
XFILLER_0_75_385 VGND VGND VPWR VPWR sky130_fd_sc_hd__decap_6
XFILLER_0_7_140 VGND VGND VPWR VPWR sky130_fd_sc_hd__decap_8
X_4819_ _2469_ VGND VGND VPWR VPWR _0221_ sky130_fd_sc_hd__inv_2
XFILLER_0_43_293 VPWR VGND VPWR VGND sky130_ef_sc_hd__decap_12
Xoutput13 net13 VGND VGND VPWR VPWR Result[1] sky130_fd_sc_hd__buf_2
Xoutput24 net24 VGND VGND VPWR VPWR Result[2] sky130_fd_sc_hd__buf_2
Xoutput35 net35 VGND VGND VPWR VPWR an[1] sky130_fd_sc_hd__buf_2
XTAP_TAPCELL_ROW_59_723 VGND VPWR sky130_fd_sc_hd__tapvpwrvgnd_1
XFILLER_0_85_105 VGND VGND VPWR VPWR sky130_fd_sc_hd__decap_6
XPHY_EDGE_ROW_19_Right_19 VGND VGND VPWR VPWR sky130_fd_sc_hd__decap_3
XFILLER_0_39_500 VGND VGND VPWR VPWR sky130_fd_sc_hd__decap_4
XFILLER_0_39_511 VGND VGND VPWR VPWR sky130_fd_sc_hd__fill_2
XTAP_TAPCELL_ROW_14_314 VGND VPWR sky130_fd_sc_hd__tapvpwrvgnd_1
XFILLER_0_66_363 VGND VGND VPWR VPWR sky130_fd_sc_hd__fill_1
XFILLER_0_81_399 VPWR VGND VPWR VGND sky130_ef_sc_hd__decap_12
XTAP_TAPCELL_ROW_22_391 VGND VPWR sky130_fd_sc_hd__tapvpwrvgnd_1
XFILLER_0_1_349 VPWR VGND VPWR VGND sky130_ef_sc_hd__decap_12
XFILLER_0_22_455 VPWR VGND VPWR VGND sky130_ef_sc_hd__decap_12
XPHY_EDGE_ROW_28_Right_28 VGND VGND VPWR VPWR sky130_fd_sc_hd__decap_3
XFILLER_0_22_499 VGND VGND VPWR VPWR sky130_fd_sc_hd__fill_1
X_3150_ _1333_ _1334_ _1335_ _0829_ VGND VGND VPWR VPWR _1346_ sky130_fd_sc_hd__a211o_1
X_3081_ _0818_ _0825_ VGND VGND VPWR VPWR _1277_ sky130_fd_sc_hd__or2_4
XFILLER_0_27_65 VGND VGND VPWR VPWR sky130_fd_sc_hd__fill_2
XPHY_EDGE_ROW_37_Right_37 VGND VGND VPWR VPWR sky130_fd_sc_hd__decap_3
X_3983_ RF0.regs\[5\]\[16\] _2008_ _2113_ VGND VGND VPWR VPWR _2119_ sky130_fd_sc_hd__mux2_1
XFILLER_0_45_503 VGND VGND VPWR VPWR sky130_fd_sc_hd__fill_1
XFILLER_0_57_352 VPWR VGND VPWR VGND sky130_ef_sc_hd__decap_12
XFILLER_0_17_205 VGND VGND VPWR VPWR sky130_fd_sc_hd__fill_1
X_2934_ _1172_ VGND VGND VPWR VPWR _0723_ sky130_fd_sc_hd__clkbuf_1
XFILLER_0_72_355 VGND VGND VPWR VPWR sky130_fd_sc_hd__fill_1
X_2865_ _1117_ net233 VGND VGND VPWR VPWR _1133_ sky130_fd_sc_hd__and2_1
XFILLER_0_13_400 VGND VGND VPWR VPWR sky130_fd_sc_hd__decap_4
XPHY_EDGE_ROW_46_Right_46 VGND VGND VPWR VPWR sky130_fd_sc_hd__decap_3
X_4604_ _2440_ VGND VGND VPWR VPWR _0035_ sky130_fd_sc_hd__inv_2
XFILLER_0_13_433 VGND VGND VPWR VPWR sky130_fd_sc_hd__fill_1
XFILLER_0_4_165 VGND VGND VPWR VPWR sky130_fd_sc_hd__fill_1
X_4535_ _2417_ _2418_ VGND VGND VPWR VPWR _0005_ sky130_fd_sc_hd__nor2_1
XFILLER_0_25_293 VPWR VGND VPWR VGND sky130_ef_sc_hd__decap_12
X_2796_ RF0.regs\[4\]\[23\] _0837_ _0844_ RF0.regs\[12\]\[23\] VGND VGND VPWR VPWR
+ _1088_ sky130_fd_sc_hd__a22o_1
X_4466_ RF0.regs\[25\]\[11\] _2072_ _2371_ VGND VGND VPWR VPWR _2372_ sky130_fd_sc_hd__mux2_1
X_3417_ RF0.regs\[20\]\[25\] _1224_ _1229_ RF0.regs\[15\]\[25\] _1610_ VGND VGND VPWR
+ VPWR _1611_ sky130_fd_sc_hd__a221o_1
X_4397_ _2335_ VGND VGND VPWR VPWR _0437_ sky130_fd_sc_hd__clkbuf_1
XFILLER_0_68_83 VGND VGND VPWR VPWR sky130_fd_sc_hd__fill_1
XFILLER_0_0_393 VPWR VGND VPWR VGND sky130_ef_sc_hd__decap_12
X_3348_ _0966_ _1351_ VGND VGND VPWR VPWR _1544_ sky130_fd_sc_hd__nor2_1
XPHY_EDGE_ROW_55_Right_55 VGND VGND VPWR VPWR sky130_fd_sc_hd__decap_3
X_3279_ _1461_ _1469_ _1474_ VGND VGND VPWR VPWR _1475_ sky130_fd_sc_hd__a21oi_4
XTAP_TAPCELL_ROW_28_439 VGND VPWR sky130_fd_sc_hd__tapvpwrvgnd_1
X_5018_ clknet_leaf_38_clk _0394_ _0010_ VGND VGND VPWR VPWR RF0.regs\[25\]\[1\] sky130_fd_sc_hd__dfrtp_1
XFILLER_0_8_471 VGND VGND VPWR VPWR sky130_fd_sc_hd__decap_4
XPHY_EDGE_ROW_64_Right_64 VGND VGND VPWR VPWR sky130_fd_sc_hd__decap_3
XFILLER_0_31_263 VGND VGND VPWR VPWR sky130_fd_sc_hd__fill_2
XPHY_EDGE_ROW_73_Right_73 VGND VGND VPWR VPWR sky130_fd_sc_hd__decap_3
XFILLER_0_80_29 VPWR VGND VPWR VGND sky130_ef_sc_hd__decap_12
XFILLER_0_86_469 VGND VGND VPWR VPWR sky130_fd_sc_hd__decap_6
XPHY_EDGE_ROW_82_Right_82 VGND VGND VPWR VPWR sky130_fd_sc_hd__decap_3
XFILLER_0_66_182 VGND VGND VPWR VPWR sky130_fd_sc_hd__fill_2
X_2650_ RF0.regs\[5\]\[6\] _0873_ _0853_ RF0.regs\[15\]\[6\] VGND VGND VPWR VPWR _0942_
+ sky130_fd_sc_hd__a22o_1
X_2581_ _0872_ VGND VGND VPWR VPWR _0873_ sky130_fd_sc_hd__clkbuf_4
XFILLER_0_1_113 VGND VGND VPWR VPWR sky130_fd_sc_hd__decap_3
XFILLER_0_22_230 VPWR VGND VPWR VGND sky130_ef_sc_hd__decap_12
X_4320_ _2295_ VGND VGND VPWR VPWR _0474_ sky130_fd_sc_hd__clkbuf_1
X_4251_ _2259_ VGND VGND VPWR VPWR _0507_ sky130_fd_sc_hd__clkbuf_1
X_3202_ _1397_ _1393_ VGND VGND VPWR VPWR _1398_ sky130_fd_sc_hd__nor2_1
X_4182_ _2224_ VGND VGND VPWR VPWR _0541_ sky130_fd_sc_hd__clkbuf_1
X_3133_ _1324_ _1327_ _1328_ VGND VGND VPWR VPWR _1329_ sky130_fd_sc_hd__nor3b_1
XTAP_TAPCELL_ROW_78_895 VGND VPWR sky130_fd_sc_hd__tapvpwrvgnd_1
X_3064_ RF0.regs\[2\]\[30\] _1241_ _0875_ RF0.regs\[5\]\[30\] VGND VGND VPWR VPWR
+ _1260_ sky130_fd_sc_hd__a22o_1
XFILLER_0_49_127 VGND VGND VPWR VPWR sky130_fd_sc_hd__decap_4
XFILLER_0_54_85 VPWR VGND VPWR VGND sky130_ef_sc_hd__decap_12
XFILLER_0_77_469 VPWR VGND VPWR VGND sky130_ef_sc_hd__decap_12
X_3966_ RF0.regs\[5\]\[24\] _1981_ _2102_ VGND VGND VPWR VPWR _2110_ sky130_fd_sc_hd__mux2_1
XTAP_TAPCELL_ROW_61_740 VGND VPWR sky130_fd_sc_hd__tapvpwrvgnd_1
XFILLER_0_64_119 VGND VGND VPWR VPWR sky130_fd_sc_hd__decap_3
X_2917_ net166 VGND VGND VPWR VPWR _1164_ sky130_fd_sc_hd__clkbuf_1
XFILLER_0_70_73 VGND VGND VPWR VPWR sky130_fd_sc_hd__fill_2
XTAP_TAPCELL_ROW_33_486 VGND VPWR sky130_fd_sc_hd__tapvpwrvgnd_1
XFILLER_0_72_141 VGND VGND VPWR VPWR sky130_fd_sc_hd__decap_6
X_3897_ _1759_ _2062_ VGND VGND VPWR VPWR _2063_ sky130_fd_sc_hd__xor2_2
XFILLER_0_5_441 VGND VGND VPWR VPWR sky130_fd_sc_hd__decap_6
X_2848_ _1124_ VGND VGND VPWR VPWR _0761_ sky130_fd_sc_hd__clkbuf_1
XFILLER_0_45_399 VGND VGND VPWR VPWR sky130_fd_sc_hd__fill_1
XFILLER_0_5_485 VPWR VGND VPWR VGND sky130_ef_sc_hd__decap_12
X_2779_ RF0.regs\[4\]\[1\] _0901_ _0860_ _0877_ RF0.regs\[2\]\[1\] VGND VGND VPWR
+ VPWR _1071_ sky130_fd_sc_hd__a32o_1
Xhold142 RF0.regs\[6\]\[14\] VGND VGND VPWR VPWR net190 sky130_fd_sc_hd__dlygate4sd3_1
X_4518_ _2399_ _2406_ VGND VGND VPWR VPWR _2407_ sky130_fd_sc_hd__nand2_1
Xhold153 RF0.regs\[20\]\[2\] VGND VGND VPWR VPWR net201 sky130_fd_sc_hd__dlygate4sd3_1
Xhold131 RF0.regs\[20\]\[24\] VGND VGND VPWR VPWR net179 sky130_fd_sc_hd__dlygate4sd3_1
Xhold120 RF0.regs\[0\]\[25\] VGND VGND VPWR VPWR net168 sky130_fd_sc_hd__dlygate4sd3_1
Xhold186 RF0.regs\[6\]\[17\] VGND VGND VPWR VPWR net234 sky130_fd_sc_hd__dlygate4sd3_1
X_4449_ RF0.regs\[25\]\[19\] _2000_ _2360_ VGND VGND VPWR VPWR _2363_ sky130_fd_sc_hd__mux2_1
XFILLER_0_13_296 VGND VGND VPWR VPWR sky130_fd_sc_hd__decap_8
Xhold164 RF0.regs\[20\]\[26\] VGND VGND VPWR VPWR net212 sky130_fd_sc_hd__dlygate4sd3_1
Xhold175 RF0.regs\[12\]\[18\] VGND VGND VPWR VPWR net223 sky130_fd_sc_hd__dlygate4sd3_1
Xhold197 RF0.regs\[6\]\[12\] VGND VGND VPWR VPWR net245 sky130_fd_sc_hd__dlygate4sd3_1
XFILLER_0_55_119 VGND VGND VPWR VPWR sky130_fd_sc_hd__fill_1
XTAP_TAPCELL_ROW_75_865 VGND VPWR sky130_fd_sc_hd__tapvpwrvgnd_1
XFILLER_0_59_414 VPWR VGND VPWR VGND sky130_ef_sc_hd__decap_12
XFILLER_0_86_200 VPWR VGND VPWR VGND sky130_ef_sc_hd__decap_12
XFILLER_0_24_55 VGND VGND VPWR VPWR sky130_fd_sc_hd__fill_2
X_3820_ _1663_ _1928_ VGND VGND VPWR VPWR _1995_ sky130_fd_sc_hd__and2_1
XFILLER_0_74_417 VGND VGND VPWR VPWR sky130_fd_sc_hd__decap_3
XFILLER_0_67_480 VPWR VGND VPWR VGND sky130_ef_sc_hd__decap_12
X_3751_ _1615_ _1936_ VGND VGND VPWR VPWR _1937_ sky130_fd_sc_hd__or2_1
X_2702_ _0988_ _0992_ _0931_ _0993_ VGND VGND VPWR VPWR _0994_ sky130_fd_sc_hd__a2bb2o_1
XFILLER_0_42_303 VGND VGND VPWR VPWR sky130_fd_sc_hd__decap_4
XFILLER_0_54_141 VGND VGND VPWR VPWR sky130_fd_sc_hd__fill_2
X_3682_ _1082_ _1403_ VGND VGND VPWR VPWR _1868_ sky130_fd_sc_hd__xor2_1
XTAP_TAPCELL_ROW_30_456 VGND VPWR sky130_fd_sc_hd__tapvpwrvgnd_1
XFILLER_0_40_76 VGND VGND VPWR VPWR sky130_fd_sc_hd__fill_1
XFILLER_0_54_174 VGND VGND VPWR VPWR sky130_fd_sc_hd__decap_3
X_5421_ clknet_leaf_30_clk _0779_ VGND VGND VPWR VPWR net36 sky130_fd_sc_hd__dfxtp_1
X_2633_ RF0.regs\[4\]\[15\] _0836_ _0843_ RF0.regs\[12\]\[15\] VGND VGND VPWR VPWR
+ _0925_ sky130_fd_sc_hd__a22o_1
X_5352_ clknet_leaf_21_clk _0728_ _0344_ VGND VGND VPWR VPWR RF0.regs\[0\]\[15\] sky130_fd_sc_hd__dfrtp_1
XFILLER_0_10_200 VGND VGND VPWR VPWR sky130_fd_sc_hd__decap_4
XFILLER_0_2_433 VPWR VGND VPWR VGND sky130_ef_sc_hd__decap_12
X_2564_ _0855_ VGND VGND VPWR VPWR _0856_ sky130_fd_sc_hd__clkbuf_4
XFILLER_0_2_477 VPWR VGND VPWR VGND sky130_ef_sc_hd__decap_12
X_4303_ _2286_ VGND VGND VPWR VPWR _0482_ sky130_fd_sc_hd__clkbuf_1
X_2495_ net48 VGND VGND VPWR VPWR _0787_ sky130_fd_sc_hd__buf_6
XFILLER_0_10_277 VGND VGND VPWR VPWR sky130_fd_sc_hd__fill_1
X_5283_ clknet_leaf_24_clk _0659_ _0275_ VGND VGND VPWR VPWR RF0.regs\[4\]\[10\] sky130_fd_sc_hd__dfrtp_1
X_4234_ net146 VGND VGND VPWR VPWR _2251_ sky130_fd_sc_hd__clkbuf_1
XFILLER_0_4_65 VPWR VGND VPWR VGND sky130_ef_sc_hd__decap_12
X_4165_ _2215_ VGND VGND VPWR VPWR _0549_ sky130_fd_sc_hd__clkbuf_1
X_3116_ _1310_ _1308_ _1311_ VGND VGND VPWR VPWR _1312_ sky130_fd_sc_hd__or3b_4
X_4096_ _2180_ VGND VGND VPWR VPWR _0583_ sky130_fd_sc_hd__clkbuf_1
XTAP_TAPCELL_ROW_38_534 VGND VPWR sky130_fd_sc_hd__tapvpwrvgnd_1
XFILLER_0_65_95 VGND VGND VPWR VPWR sky130_fd_sc_hd__fill_1
X_3047_ net47 VGND VGND VPWR VPWR _1243_ sky130_fd_sc_hd__clkbuf_4
XFILLER_0_77_277 VGND VGND VPWR VPWR sky130_fd_sc_hd__decap_3
X_4998_ _2488_ VGND VGND VPWR VPWR _0381_ sky130_fd_sc_hd__inv_2
X_3949_ RF0.regs\[4\]\[0\] VGND VGND VPWR VPWR _2101_ sky130_fd_sc_hd__clkbuf_1
XFILLER_0_45_185 VGND VGND VPWR VPWR sky130_fd_sc_hd__fill_1
XFILLER_0_41_391 VGND VGND VPWR VPWR sky130_fd_sc_hd__fill_1
XTAP_TAPCELL_ROW_72_835 VGND VPWR sky130_fd_sc_hd__tapvpwrvgnd_1
XFILLER_0_83_225 VGND VGND VPWR VPWR sky130_fd_sc_hd__decap_8
XFILLER_0_28_108 VGND VGND VPWR VPWR sky130_fd_sc_hd__decap_4
XFILLER_0_36_141 VGND VGND VPWR VPWR sky130_fd_sc_hd__decap_8
XTAP_TAPCELL_ROW_9_270 VGND VPWR sky130_fd_sc_hd__tapvpwrvgnd_1
XTAP_TAPCELL_ROW_35_504 VGND VPWR sky130_fd_sc_hd__tapvpwrvgnd_1
X_4921_ _2481_ VGND VGND VPWR VPWR _0311_ sky130_fd_sc_hd__inv_2
X_4852_ _2471_ VGND VGND VPWR VPWR _2473_ sky130_fd_sc_hd__clkbuf_8
XFILLER_0_51_53 VGND VGND VPWR VPWR sky130_fd_sc_hd__decap_3
X_3803_ RF0.regs\[4\]\[24\] _1981_ _1953_ VGND VGND VPWR VPWR _1982_ sky130_fd_sc_hd__mux2_1
X_4783_ _2465_ VGND VGND VPWR VPWR _0189_ sky130_fd_sc_hd__inv_2
XFILLER_0_15_314 VPWR VGND VPWR VGND sky130_ef_sc_hd__decap_12
XFILLER_0_55_494 VGND VGND VPWR VPWR sky130_fd_sc_hd__decap_8
X_3734_ _1009_ _1765_ _1766_ _1767_ _1919_ VGND VGND VPWR VPWR _1920_ sky130_fd_sc_hd__a41o_1
XFILLER_0_15_347 VPWR VGND VPWR VGND sky130_ef_sc_hd__decap_12
X_3665_ _1008_ _1844_ _1850_ VGND VGND VPWR VPWR _1851_ sky130_fd_sc_hd__a21o_1
XFILLER_0_42_133 VGND VGND VPWR VPWR sky130_fd_sc_hd__decap_4
X_5404_ clknet_leaf_32_clk net27 VGND VGND VPWR VPWR disp.digits\[3\] sky130_fd_sc_hd__dfxtp_1
XFILLER_0_30_328 VGND VGND VPWR VPWR sky130_fd_sc_hd__decap_8
Xclkload40 clknet_leaf_23_clk VGND VGND VPWR VPWR clkload40/X sky130_fd_sc_hd__clkbuf_4
X_2616_ _0905_ _0907_ VGND VGND VPWR VPWR _0908_ sky130_fd_sc_hd__xor2_1
X_3596_ _1783_ _1784_ _1786_ _1217_ RF0.regs\[0\]\[11\] VGND VGND VPWR VPWR _1787_
+ sky130_fd_sc_hd__o32a_1
X_5335_ clknet_leaf_3_clk _0711_ _0327_ VGND VGND VPWR VPWR RF0.regs\[2\]\[30\] sky130_fd_sc_hd__dfrtp_1
X_2547_ _0838_ VGND VGND VPWR VPWR _0839_ sky130_fd_sc_hd__buf_4
X_5266_ clknet_leaf_8_clk _0642_ _0258_ VGND VGND VPWR VPWR RF0.regs\[5\]\[25\] sky130_fd_sc_hd__dfrtp_2
XFILLER_0_76_94 VGND VGND VPWR VPWR sky130_fd_sc_hd__fill_1
X_4217_ _2242_ VGND VGND VPWR VPWR _0524_ sky130_fd_sc_hd__clkbuf_1
X_5197_ clknet_leaf_11_clk _0573_ _0189_ VGND VGND VPWR VPWR RF0.regs\[7\]\[20\] sky130_fd_sc_hd__dfrtp_1
X_4148_ _2206_ VGND VGND VPWR VPWR _0557_ sky130_fd_sc_hd__clkbuf_1
X_4079_ _2169_ VGND VGND VPWR VPWR _0588_ sky130_fd_sc_hd__clkbuf_1
XFILLER_0_65_225 VGND VGND VPWR VPWR sky130_fd_sc_hd__decap_8
XFILLER_0_53_409 VGND VGND VPWR VPWR sky130_fd_sc_hd__fill_2
Xclkload1 clknet_2_1__leaf_clk VGND VGND VPWR VPWR clkload1/X sky130_fd_sc_hd__clkbuf_8
XFILLER_0_61_431 VPWR VGND VPWR VGND sky130_ef_sc_hd__decap_12
XTAP_TAPCELL_ROW_6_240 VGND VPWR sky130_fd_sc_hd__tapvpwrvgnd_1
XTAP_TAPCELL_ROW_49_629 VGND VPWR sky130_fd_sc_hd__tapvpwrvgnd_1
XFILLER_0_84_501 VPWR VGND VPWR VGND sky130_ef_sc_hd__decap_12
XFILLER_0_71_228 VGND VGND VPWR VPWR sky130_fd_sc_hd__fill_1
XFILLER_0_37_494 VGND VGND VPWR VPWR sky130_fd_sc_hd__decap_4
XTAP_TAPCELL_ROW_40_551 VGND VPWR sky130_fd_sc_hd__tapvpwrvgnd_1
XTAP_TAPCELL_ROW_12_297 VGND VPWR sky130_fd_sc_hd__tapvpwrvgnd_1
XFILLER_0_52_464 VPWR VGND VPWR VGND sky130_ef_sc_hd__decap_12
X_3450_ RF0.regs\[25\]\[22\] _0814_ _1062_ _1246_ VGND VGND VPWR VPWR _1644_ sky130_fd_sc_hd__a211o_1
X_3381_ _1352_ _1542_ _1544_ VGND VGND VPWR VPWR _1576_ sky130_fd_sc_hd__a21oi_1
XFILLER_0_20_372 VGND VGND VPWR VPWR sky130_fd_sc_hd__decap_4
X_5120_ clknet_leaf_28_clk _0496_ _0112_ VGND VGND VPWR VPWR RF0.regs\[12\]\[7\] sky130_fd_sc_hd__dfrtp_1
X_5051_ clknet_leaf_35_clk _0427_ _0043_ VGND VGND VPWR VPWR RF0.regs\[20\]\[2\] sky130_fd_sc_hd__dfrtp_1
X_4002_ RF0.regs\[5\]\[7\] _2086_ _2124_ VGND VGND VPWR VPWR _2129_ sky130_fd_sc_hd__mux2_1
XFILLER_0_1_55 VGND VGND VPWR VPWR sky130_fd_sc_hd__fill_1
X_4904_ _2478_ VGND VGND VPWR VPWR _0297_ sky130_fd_sc_hd__inv_2
XFILLER_0_47_225 VGND VGND VPWR VPWR sky130_fd_sc_hd__decap_6
XFILLER_0_62_74 VGND VGND VPWR VPWR sky130_fd_sc_hd__decap_4
X_4835_ _2470_ VGND VGND VPWR VPWR _0236_ sky130_fd_sc_hd__inv_2
X_4766_ _2464_ VGND VGND VPWR VPWR _0173_ sky130_fd_sc_hd__inv_2
X_3717_ _1843_ _1901_ VGND VGND VPWR VPWR _1903_ sky130_fd_sc_hd__or2_1
XFILLER_0_55_291 VGND VGND VPWR VPWR sky130_fd_sc_hd__fill_2
X_4697_ _2454_ VGND VGND VPWR VPWR _0114_ sky130_fd_sc_hd__inv_2
XFILLER_0_43_464 VGND VGND VPWR VPWR sky130_fd_sc_hd__fill_2
X_3648_ _1829_ net31 VGND VGND VPWR VPWR _1834_ sky130_fd_sc_hd__xnor2_1
XFILLER_0_11_350 VGND VGND VPWR VPWR sky130_fd_sc_hd__fill_2
X_3579_ RF0.regs\[4\]\[12\] _1239_ _1231_ RF0.regs\[6\]\[12\] VGND VGND VPWR VPWR
+ _1770_ sky130_fd_sc_hd__a22o_1
X_5318_ clknet_leaf_16_clk _0694_ _0310_ VGND VGND VPWR VPWR RF0.regs\[2\]\[13\] sky130_fd_sc_hd__dfrtp_1
Xhold24 RF0.regs\[7\]\[23\] VGND VGND VPWR VPWR net72 sky130_fd_sc_hd__dlygate4sd3_1
Xhold35 RF0.regs\[2\]\[31\] VGND VGND VPWR VPWR net83 sky130_fd_sc_hd__dlygate4sd3_1
X_5249_ clknet_leaf_29_clk _0625_ _0241_ VGND VGND VPWR VPWR RF0.regs\[5\]\[8\] sky130_fd_sc_hd__dfrtp_1
Xhold46 RF0.regs\[12\]\[12\] VGND VGND VPWR VPWR net94 sky130_fd_sc_hd__dlygate4sd3_1
Xhold68 RF0.regs\[0\]\[4\] VGND VGND VPWR VPWR net116 sky130_fd_sc_hd__dlygate4sd3_1
Xhold79 RF0.regs\[2\]\[29\] VGND VGND VPWR VPWR net127 sky130_fd_sc_hd__dlygate4sd3_1
Xhold57 RF0.regs\[0\]\[12\] VGND VGND VPWR VPWR net105 sky130_fd_sc_hd__dlygate4sd3_1
XTAP_TAPCELL_ROW_82_930 VGND VPWR sky130_fd_sc_hd__tapvpwrvgnd_1
XTAP_TAPCELL_ROW_54_676 VGND VPWR sky130_fd_sc_hd__tapvpwrvgnd_1
XFILLER_0_69_350 VGND VGND VPWR VPWR sky130_fd_sc_hd__decap_3
XTAP_TAPCELL_ROW_17_345 VGND VPWR sky130_fd_sc_hd__tapvpwrvgnd_1
X_2950_ _1180_ VGND VGND VPWR VPWR _0715_ sky130_fd_sc_hd__clkbuf_1
X_2881_ _0833_ _1103_ _1117_ VGND VGND VPWR VPWR _1144_ sky130_fd_sc_hd__a21o_1
XFILLER_0_32_88 VPWR VGND VPWR VGND sky130_ef_sc_hd__decap_12
X_4620_ _2443_ VGND VGND VPWR VPWR _0048_ sky130_fd_sc_hd__inv_2
XFILLER_0_52_250 VGND VGND VPWR VPWR sky130_fd_sc_hd__fill_2
X_4551_ _1705_ _1706_ _1148_ VGND VGND VPWR VPWR _2425_ sky130_fd_sc_hd__and3b_1
X_3502_ RF0.regs\[7\]\[19\] _1244_ _1694_ VGND VGND VPWR VPWR _1695_ sky130_fd_sc_hd__a21o_1
X_4482_ RF0.regs\[25\]\[3\] _2094_ _2371_ VGND VGND VPWR VPWR _2380_ sky130_fd_sc_hd__mux2_1
XFILLER_0_40_467 VGND VGND VPWR VPWR sky130_fd_sc_hd__fill_1
X_3433_ _1624_ _1626_ VGND VGND VPWR VPWR _1627_ sky130_fd_sc_hd__and2_1
X_5103_ clknet_leaf_10_clk _0479_ _0095_ VGND VGND VPWR VPWR RF0.regs\[15\]\[22\]
+ sky130_fd_sc_hd__dfrtp_1
X_3364_ RF0.regs\[7\]\[30\] _1245_ _1558_ VGND VGND VPWR VPWR _1559_ sky130_fd_sc_hd__a21o_1
XFILLER_0_57_52 VGND VGND VPWR VPWR sky130_fd_sc_hd__fill_1
X_3295_ _0841_ net53 _1489_ _1488_ VGND VGND VPWR VPWR _1491_ sky130_fd_sc_hd__a31o_1
X_5034_ clknet_leaf_17_clk _0410_ _0026_ VGND VGND VPWR VPWR RF0.regs\[25\]\[17\]
+ sky130_fd_sc_hd__dfrtp_1
XFILLER_0_73_51 VGND VGND VPWR VPWR sky130_fd_sc_hd__decap_4
XFILLER_0_18_3 VPWR VGND VPWR VGND sky130_ef_sc_hd__decap_12
XTAP_TAPCELL_ROW_51_646 VGND VPWR sky130_fd_sc_hd__tapvpwrvgnd_1
XFILLER_0_35_228 VGND VGND VPWR VPWR sky130_fd_sc_hd__decap_4
X_4818_ _2462_ VGND VGND VPWR VPWR _2469_ sky130_fd_sc_hd__buf_4
XFILLER_0_16_475 VGND VGND VPWR VPWR sky130_fd_sc_hd__fill_1
X_4749_ _2460_ VGND VGND VPWR VPWR _0160_ sky130_fd_sc_hd__inv_2
XFILLER_0_43_272 VGND VGND VPWR VPWR sky130_fd_sc_hd__decap_8
Xoutput14 net14 VGND VGND VPWR VPWR Result[20] sky130_fd_sc_hd__clkbuf_4
Xoutput25 net25 VGND VGND VPWR VPWR Result[30] sky130_fd_sc_hd__clkbuf_4
Xoutput36 net36 VGND VGND VPWR VPWR an[2] sky130_fd_sc_hd__buf_2
XTAP_TAPCELL_ROW_59_724 VGND VPWR sky130_fd_sc_hd__tapvpwrvgnd_1
XFILLER_0_58_309 VPWR VGND VPWR VGND sky130_ef_sc_hd__decap_12
XTAP_TAPCELL_ROW_67_790 VGND VPWR sky130_fd_sc_hd__tapvpwrvgnd_1
XTAP_TAPCELL_ROW_14_315 VGND VPWR sky130_fd_sc_hd__tapvpwrvgnd_1
XFILLER_0_78_29 VPWR VGND VPWR VGND sky130_ef_sc_hd__decap_12
XFILLER_0_22_467 VGND VGND VPWR VPWR sky130_fd_sc_hd__decap_8
X_3080_ RF0.regs\[10\]\[7\] _0883_ _0853_ RF0.regs\[15\]\[7\] _0911_ VGND VGND VPWR
+ VPWR _1276_ sky130_fd_sc_hd__a221o_1
XFILLER_0_27_55 VGND VGND VPWR VPWR sky130_fd_sc_hd__fill_1
X_3982_ _2118_ VGND VGND VPWR VPWR _0634_ sky130_fd_sc_hd__clkbuf_1
XFILLER_0_9_406 VGND VGND VPWR VPWR sky130_fd_sc_hd__decap_6
X_2933_ net101 VGND VGND VPWR VPWR _1172_ sky130_fd_sc_hd__clkbuf_1
XFILLER_0_57_364 VPWR VGND VPWR VGND sky130_ef_sc_hd__decap_12
XFILLER_0_84_161 VGND VGND VPWR VPWR sky130_fd_sc_hd__fill_1
XFILLER_0_84_194 VGND VGND VPWR VPWR sky130_fd_sc_hd__fill_2
X_2864_ _1132_ VGND VGND VPWR VPWR _0753_ sky130_fd_sc_hd__clkbuf_1
X_2795_ RF0.regs\[2\]\[23\] _0880_ _1085_ _1086_ VGND VGND VPWR VPWR _1087_ sky130_fd_sc_hd__a211o_1
X_4603_ _2440_ VGND VGND VPWR VPWR _0034_ sky130_fd_sc_hd__inv_2
XFILLER_0_13_412 VGND VGND VPWR VPWR sky130_fd_sc_hd__decap_8
X_4534_ _2390_ _2397_ _2393_ VGND VGND VPWR VPWR _2418_ sky130_fd_sc_hd__a21oi_1
XFILLER_0_25_272 VGND VGND VPWR VPWR sky130_fd_sc_hd__decap_3
XFILLER_0_13_456 VGND VGND VPWR VPWR sky130_fd_sc_hd__decap_4
XFILLER_0_13_445 VGND VGND VPWR VPWR sky130_fd_sc_hd__decap_3
XFILLER_0_40_253 VGND VGND VPWR VPWR sky130_fd_sc_hd__fill_2
X_4465_ _0817_ VGND VGND VPWR VPWR _2371_ sky130_fd_sc_hd__buf_4
XFILLER_0_0_361 VGND VGND VPWR VPWR sky130_fd_sc_hd__decap_3
X_4396_ net237 _2069_ _2325_ VGND VGND VPWR VPWR _2335_ sky130_fd_sc_hd__mux2_1
X_3416_ RF0.regs\[5\]\[25\] _0866_ _1232_ RF0.regs\[6\]\[25\] VGND VGND VPWR VPWR
+ _1610_ sky130_fd_sc_hd__a22o_1
X_3347_ _1096_ _1346_ VGND VGND VPWR VPWR _1543_ sky130_fd_sc_hd__xnor2_1
XFILLER_0_84_83 VGND VGND VPWR VPWR sky130_fd_sc_hd__fill_1
X_5017_ clknet_leaf_38_clk _0393_ _0009_ VGND VGND VPWR VPWR RF0.regs\[25\]\[0\] sky130_fd_sc_hd__dfrtp_1
X_3278_ _1471_ _1473_ VGND VGND VPWR VPWR _1474_ sky130_fd_sc_hd__xnor2_1
XFILLER_0_63_389 VGND VGND VPWR VPWR sky130_fd_sc_hd__decap_3
XPHY_EDGE_ROW_39_Left_127 VGND VGND VPWR VPWR sky130_fd_sc_hd__decap_3
XFILLER_0_7_3 VPWR VGND VPWR VGND sky130_ef_sc_hd__decap_12
XPHY_EDGE_ROW_48_Left_136 VGND VGND VPWR VPWR sky130_fd_sc_hd__decap_3
XFILLER_0_13_57 VPWR VGND VPWR VGND sky130_ef_sc_hd__decap_12
XPHY_EDGE_ROW_57_Left_145 VGND VGND VPWR VPWR sky130_fd_sc_hd__decap_3
X_2580_ _0857_ _0871_ VGND VGND VPWR VPWR _0872_ sky130_fd_sc_hd__and2_1
XFILLER_0_22_242 VGND VGND VPWR VPWR sky130_fd_sc_hd__decap_4
XFILLER_0_1_136 VGND VGND VPWR VPWR sky130_fd_sc_hd__decap_6
XFILLER_0_1_169 VGND VGND VPWR VPWR sky130_fd_sc_hd__fill_2
X_4250_ net223 VGND VGND VPWR VPWR _2259_ sky130_fd_sc_hd__clkbuf_1
X_4181_ RF0.regs\[10\]\[20\] _1996_ _2222_ VGND VGND VPWR VPWR _2224_ sky130_fd_sc_hd__mux2_1
X_3201_ RF0.regs\[4\]\[0\] _0834_ _1254_ RF0.regs\[12\]\[0\] _1396_ VGND VGND VPWR
+ VPWR _1397_ sky130_fd_sc_hd__a221o_1
X_3132_ _1258_ _1035_ VGND VGND VPWR VPWR _1328_ sky130_fd_sc_hd__nand2_1
XPHY_EDGE_ROW_66_Left_154 VGND VGND VPWR VPWR sky130_fd_sc_hd__decap_3
X_3063_ RF0.regs\[4\]\[30\] _0867_ _0888_ VGND VGND VPWR VPWR _1259_ sky130_fd_sc_hd__a21o_1
XFILLER_0_54_75 VGND VGND VPWR VPWR sky130_fd_sc_hd__decap_8
XFILLER_0_54_97 VPWR VGND VPWR VGND sky130_ef_sc_hd__decap_12
X_3965_ _2109_ VGND VGND VPWR VPWR _0642_ sky130_fd_sc_hd__clkbuf_1
XFILLER_0_57_150 VPWR VGND VPWR VGND sky130_ef_sc_hd__decap_12
XTAP_TAPCELL_ROW_61_741 VGND VPWR sky130_fd_sc_hd__tapvpwrvgnd_1
X_2916_ _1163_ VGND VGND VPWR VPWR _0732_ sky130_fd_sc_hd__clkbuf_1
XPHY_EDGE_ROW_75_Left_163 VGND VGND VPWR VPWR sky130_fd_sc_hd__decap_3
XTAP_TAPCELL_ROW_33_487 VGND VPWR sky130_fd_sc_hd__tapvpwrvgnd_1
X_3896_ _1769_ _1780_ _2017_ _2061_ VGND VGND VPWR VPWR _2062_ sky130_fd_sc_hd__o211a_1
X_2847_ _1118_ net229 VGND VGND VPWR VPWR _1124_ sky130_fd_sc_hd__and2_1
XFILLER_0_85_3 VPWR VGND VPWR VGND sky130_ef_sc_hd__decap_12
XFILLER_0_72_197 VPWR VGND VPWR VGND sky130_ef_sc_hd__decap_12
X_2778_ RF0.regs\[5\]\[1\] _0857_ _0871_ _0852_ RF0.regs\[15\]\[1\] VGND VGND VPWR
+ VPWR _1070_ sky130_fd_sc_hd__a32o_1
XFILLER_0_13_220 VGND VGND VPWR VPWR sky130_fd_sc_hd__fill_1
XFILLER_0_5_497 VGND VGND VPWR VPWR sky130_fd_sc_hd__decap_6
Xhold110 RF0.regs\[12\]\[13\] VGND VGND VPWR VPWR net158 sky130_fd_sc_hd__dlygate4sd3_1
Xhold143 RF0.regs\[0\]\[22\] VGND VGND VPWR VPWR net191 sky130_fd_sc_hd__dlygate4sd3_1
X_4517_ _2390_ _2393_ VGND VGND VPWR VPWR _2406_ sky130_fd_sc_hd__or2_1
Xhold132 RF0.regs\[0\]\[29\] VGND VGND VPWR VPWR net180 sky130_fd_sc_hd__dlygate4sd3_1
Xhold121 RF0.regs\[2\]\[30\] VGND VGND VPWR VPWR net169 sky130_fd_sc_hd__dlygate4sd3_1
X_4448_ _2362_ VGND VGND VPWR VPWR _0413_ sky130_fd_sc_hd__clkbuf_1
Xhold165 IM0.addr\[5\] VGND VGND VPWR VPWR net213 sky130_fd_sc_hd__dlygate4sd3_1
Xhold154 IM0.addr\[22\] VGND VGND VPWR VPWR net202 sky130_fd_sc_hd__dlygate4sd3_1
Xhold176 RF0.regs\[6\]\[30\] VGND VGND VPWR VPWR net224 sky130_fd_sc_hd__dlygate4sd3_1
Xhold187 RF0.regs\[20\]\[13\] VGND VGND VPWR VPWR net235 sky130_fd_sc_hd__dlygate4sd3_1
Xhold198 RF0.regs\[6\]\[22\] VGND VGND VPWR VPWR net246 sky130_fd_sc_hd__dlygate4sd3_1
XPHY_EDGE_ROW_84_Left_172 VGND VGND VPWR VPWR sky130_fd_sc_hd__decap_3
X_4379_ _2326_ VGND VGND VPWR VPWR _0446_ sky130_fd_sc_hd__clkbuf_1
XFILLER_0_68_448 VGND VGND VPWR VPWR sky130_fd_sc_hd__decap_3
XFILLER_0_48_161 VGND VGND VPWR VPWR sky130_fd_sc_hd__decap_8
XFILLER_0_8_291 VGND VGND VPWR VPWR sky130_fd_sc_hd__decap_8
XFILLER_0_86_212 VGND VGND VPWR VPWR sky130_fd_sc_hd__fill_2
XTAP_TAPCELL_ROW_75_866 VGND VPWR sky130_fd_sc_hd__tapvpwrvgnd_1
XFILLER_0_27_301 VGND VGND VPWR VPWR sky130_fd_sc_hd__fill_2
X_3750_ _1010_ _1616_ _1934_ _1935_ _1628_ VGND VGND VPWR VPWR _1936_ sky130_fd_sc_hd__a41oi_2
XFILLER_0_67_492 VPWR VGND VPWR VGND sky130_ef_sc_hd__decap_12
XFILLER_0_54_131 VGND VGND VPWR VPWR sky130_fd_sc_hd__fill_1
X_2701_ _0929_ VGND VGND VPWR VPWR _0993_ sky130_fd_sc_hd__inv_2
X_3681_ _1007_ _1861_ _1866_ VGND VGND VPWR VPWR _1867_ sky130_fd_sc_hd__a21oi_2
XTAP_TAPCELL_ROW_30_457 VGND VPWR sky130_fd_sc_hd__tapvpwrvgnd_1
XFILLER_0_2_401 VPWR VGND VPWR VGND sky130_ef_sc_hd__decap_12
X_5420_ clknet_leaf_32_clk _0778_ VGND VGND VPWR VPWR net35 sky130_fd_sc_hd__dfxtp_1
XFILLER_0_42_359 VGND VGND VPWR VPWR sky130_fd_sc_hd__decap_4
X_2632_ RF0.regs\[2\]\[15\] _0880_ _0922_ _0923_ VGND VGND VPWR VPWR _0924_ sky130_fd_sc_hd__a211oi_1
X_5351_ clknet_leaf_22_clk _0727_ _0343_ VGND VGND VPWR VPWR RF0.regs\[0\]\[14\] sky130_fd_sc_hd__dfrtp_1
XFILLER_0_2_445 VPWR VGND VPWR VGND sky130_ef_sc_hd__decap_12
X_2563_ _0854_ VGND VGND VPWR VPWR _0855_ sky130_fd_sc_hd__clkbuf_4
XFILLER_0_10_234 VGND VGND VPWR VPWR sky130_fd_sc_hd__decap_6
XFILLER_0_2_489 VPWR VGND VPWR VGND sky130_ef_sc_hd__decap_12
X_5282_ clknet_leaf_29_clk _0658_ _0274_ VGND VGND VPWR VPWR RF0.regs\[4\]\[9\] sky130_fd_sc_hd__dfrtp_4
XFILLER_0_49_53 VGND VGND VPWR VPWR sky130_fd_sc_hd__decap_3
X_4302_ RF0.regs\[15\]\[25\] _1978_ _2279_ VGND VGND VPWR VPWR _2286_ sky130_fd_sc_hd__mux2_1
X_2494_ _0782_ _0783_ _0784_ _0785_ VGND VGND VPWR VPWR _0786_ sky130_fd_sc_hd__nor4_2
X_4233_ _2250_ VGND VGND VPWR VPWR _0516_ sky130_fd_sc_hd__clkbuf_1
XFILLER_0_49_75 VGND VGND VPWR VPWR sky130_fd_sc_hd__decap_4
XFILLER_0_57_7 VGND VGND VPWR VPWR sky130_fd_sc_hd__fill_1
X_4164_ RF0.regs\[10\]\[28\] _1965_ _2211_ VGND VGND VPWR VPWR _2215_ sky130_fd_sc_hd__mux2_1
XFILLER_0_65_41 VGND VGND VPWR VPWR sky130_fd_sc_hd__fill_2
XFILLER_0_4_77 VGND VGND VPWR VPWR sky130_fd_sc_hd__decap_6
X_4095_ net91 VGND VGND VPWR VPWR _2180_ sky130_fd_sc_hd__clkbuf_1
X_3115_ _1257_ _1059_ VGND VGND VPWR VPWR _1311_ sky130_fd_sc_hd__nand2_1
XFILLER_0_65_52 VGND VGND VPWR VPWR sky130_fd_sc_hd__fill_1
X_3046_ _0801_ _1006_ _0818_ VGND VGND VPWR VPWR _1242_ sky130_fd_sc_hd__nor3_1
XTAP_TAPCELL_ROW_38_535 VGND VPWR sky130_fd_sc_hd__tapvpwrvgnd_1
XFILLER_0_81_51 VGND VGND VPWR VPWR sky130_fd_sc_hd__decap_4
X_4997_ _2488_ VGND VGND VPWR VPWR _0380_ sky130_fd_sc_hd__inv_2
XFILLER_0_33_304 VGND VGND VPWR VPWR sky130_fd_sc_hd__decap_8
X_3948_ _2100_ VGND VGND VPWR VPWR _0650_ sky130_fd_sc_hd__clkbuf_1
X_3879_ _2033_ _2044_ _2032_ VGND VGND VPWR VPWR _2045_ sky130_fd_sc_hd__o21bai_4
XFILLER_0_60_178 VGND VGND VPWR VPWR sky130_fd_sc_hd__decap_3
XTAP_TAPCELL_ROW_72_836 VGND VPWR sky130_fd_sc_hd__tapvpwrvgnd_1
XFILLER_0_36_197 VGND VGND VPWR VPWR sky130_fd_sc_hd__decap_6
XFILLER_0_86_29 VPWR VGND VPWR VGND sky130_ef_sc_hd__decap_12
XTAP_TAPCELL_ROW_9_271 VGND VPWR sky130_fd_sc_hd__tapvpwrvgnd_1
XFILLER_0_59_201 VPWR VGND VPWR VGND sky130_ef_sc_hd__decap_12
X_4920_ _2481_ VGND VGND VPWR VPWR _0310_ sky130_fd_sc_hd__inv_2
XTAP_TAPCELL_ROW_35_505 VGND VPWR sky130_fd_sc_hd__tapvpwrvgnd_1
X_4851_ _2472_ VGND VGND VPWR VPWR _0250_ sky130_fd_sc_hd__inv_2
XFILLER_0_51_43 VGND VGND VPWR VPWR sky130_fd_sc_hd__fill_1
X_3802_ _1968_ _1980_ VGND VGND VPWR VPWR _1981_ sky130_fd_sc_hd__and2_1
X_4782_ _2465_ VGND VGND VPWR VPWR _0188_ sky130_fd_sc_hd__inv_2
XFILLER_0_51_65 VGND VGND VPWR VPWR sky130_fd_sc_hd__decap_3
XFILLER_0_82_270 VGND VGND VPWR VPWR sky130_fd_sc_hd__fill_1
XFILLER_0_70_421 VGND VGND VPWR VPWR sky130_fd_sc_hd__decap_4
XFILLER_0_15_326 VGND VGND VPWR VPWR sky130_fd_sc_hd__decap_8
X_3733_ _1775_ _1778_ VGND VGND VPWR VPWR _1919_ sky130_fd_sc_hd__and2_1
XFILLER_0_82_292 VGND VGND VPWR VPWR sky130_fd_sc_hd__decap_8
XFILLER_0_15_359 VGND VGND VPWR VPWR sky130_fd_sc_hd__decap_8
XFILLER_0_15_337 VGND VGND VPWR VPWR sky130_fd_sc_hd__decap_6
X_3664_ _1846_ _1847_ _1849_ _1216_ RF0.regs\[0\]\[5\] VGND VGND VPWR VPWR _1850_
+ sky130_fd_sc_hd__o32a_1
X_5403_ clknet_leaf_32_clk net24 VGND VGND VPWR VPWR disp.digits\[2\] sky130_fd_sc_hd__dfxtp_1
Xclkload30 clknet_leaf_36_clk VGND VGND VPWR VPWR clkload30/Y sky130_fd_sc_hd__inv_8
XFILLER_0_42_167 VGND VGND VPWR VPWR sky130_fd_sc_hd__decap_4
Xclkload41 clknet_leaf_24_clk VGND VGND VPWR VPWR clkload41/Y sky130_fd_sc_hd__clkinvlp_4
X_2615_ RF0.regs\[10\]\[17\] _0816_ _0830_ RF0.regs\[25\]\[17\] _0906_ VGND VGND VPWR
+ VPWR _0907_ sky130_fd_sc_hd__a221o_1
XFILLER_0_2_253 VGND VGND VPWR VPWR sky130_fd_sc_hd__fill_2
XFILLER_0_23_370 VGND VGND VPWR VPWR sky130_fd_sc_hd__fill_2
X_3595_ RF0.regs\[4\]\[11\] _1239_ _1222_ RF0.regs\[20\]\[11\] _1785_ VGND VGND VPWR
+ VPWR _1786_ sky130_fd_sc_hd__a221o_1
X_5334_ clknet_leaf_1_clk _0710_ _0326_ VGND VGND VPWR VPWR RF0.regs\[2\]\[29\] sky130_fd_sc_hd__dfrtp_1
X_2546_ _0837_ VGND VGND VPWR VPWR _0838_ sky130_fd_sc_hd__clkbuf_4
X_5265_ clknet_leaf_7_clk _0641_ _0257_ VGND VGND VPWR VPWR RF0.regs\[5\]\[24\] sky130_fd_sc_hd__dfrtp_1
X_5196_ clknet_leaf_12_clk _0572_ _0188_ VGND VGND VPWR VPWR RF0.regs\[7\]\[19\] sky130_fd_sc_hd__dfrtp_1
X_4216_ RF0.regs\[10\]\[3\] _2094_ _2233_ VGND VGND VPWR VPWR _2242_ sky130_fd_sc_hd__mux2_1
X_4147_ net76 VGND VGND VPWR VPWR _2206_ sky130_fd_sc_hd__clkbuf_1
X_4078_ _2094_ RF0.regs\[6\]\[3\] _2160_ VGND VGND VPWR VPWR _2169_ sky130_fd_sc_hd__mux2_1
X_3029_ _1224_ VGND VGND VPWR VPWR _1225_ sky130_fd_sc_hd__buf_4
Xclkload2 clknet_leaf_1_clk VGND VGND VPWR VPWR clkload2/Y sky130_fd_sc_hd__clkinv_2
XFILLER_0_61_443 VGND VGND VPWR VPWR sky130_fd_sc_hd__decap_4
XTAP_TAPCELL_ROW_6_241 VGND VPWR sky130_fd_sc_hd__tapvpwrvgnd_1
XTAP_TAPCELL_ROW_85_950 VGND VPWR sky130_fd_sc_hd__tapvpwrvgnd_1
XFILLER_0_84_513 VGND VGND VPWR VPWR sky130_fd_sc_hd__decap_4
XFILLER_0_56_226 VGND VGND VPWR VPWR sky130_fd_sc_hd__decap_4
XTAP_TAPCELL_ROW_40_552 VGND VPWR sky130_fd_sc_hd__tapvpwrvgnd_1
XFILLER_0_21_57 VPWR VGND VPWR VGND sky130_ef_sc_hd__decap_12
XTAP_TAPCELL_ROW_12_298 VGND VPWR sky130_fd_sc_hd__tapvpwrvgnd_1
XFILLER_0_24_167 VGND VGND VPWR VPWR sky130_fd_sc_hd__fill_2
XFILLER_0_24_178 VPWR VGND VPWR VGND sky130_ef_sc_hd__decap_12
XFILLER_0_12_329 VGND VGND VPWR VPWR sky130_fd_sc_hd__decap_8
X_3380_ _1574_ _1347_ VGND VGND VPWR VPWR _1575_ sky130_fd_sc_hd__and2_1
X_5050_ clknet_leaf_40_clk _0426_ _0042_ VGND VGND VPWR VPWR RF0.regs\[20\]\[1\] sky130_fd_sc_hd__dfrtp_1
XFILLER_0_34_9 VGND VGND VPWR VPWR sky130_fd_sc_hd__fill_1
X_4001_ _2128_ VGND VGND VPWR VPWR _0625_ sky130_fd_sc_hd__clkbuf_1
XFILLER_0_46_65 VGND VGND VPWR VPWR sky130_fd_sc_hd__decap_8
X_4903_ _2471_ VGND VGND VPWR VPWR _2478_ sky130_fd_sc_hd__buf_1
X_4834_ _2470_ VGND VGND VPWR VPWR _0235_ sky130_fd_sc_hd__inv_2
XFILLER_0_15_101 VGND VGND VPWR VPWR sky130_fd_sc_hd__decap_3
XFILLER_0_7_334 VGND VGND VPWR VPWR sky130_fd_sc_hd__fill_2
X_4765_ _2464_ VGND VGND VPWR VPWR _0172_ sky130_fd_sc_hd__inv_2
X_3716_ _1843_ _1901_ VGND VGND VPWR VPWR _1902_ sky130_fd_sc_hd__nand2_1
X_4696_ _2454_ VGND VGND VPWR VPWR _0113_ sky130_fd_sc_hd__inv_2
X_3647_ _1833_ VGND VGND VPWR VPWR net31 sky130_fd_sc_hd__buf_1
X_3578_ _1765_ net6 VGND VGND VPWR VPWR _1769_ sky130_fd_sc_hd__nor2_2
X_2529_ IM0.addr\[3\] VGND VGND VPWR VPWR _0821_ sky130_fd_sc_hd__clkbuf_4
X_5317_ clknet_leaf_16_clk _0693_ _0309_ VGND VGND VPWR VPWR RF0.regs\[2\]\[12\] sky130_fd_sc_hd__dfrtp_1
Xhold47 RF0.regs\[0\]\[17\] VGND VGND VPWR VPWR net95 sky130_fd_sc_hd__dlygate4sd3_1
X_5248_ clknet_leaf_28_clk _0624_ _0240_ VGND VGND VPWR VPWR RF0.regs\[5\]\[7\] sky130_fd_sc_hd__dfrtp_1
Xhold36 RF0.regs\[12\]\[31\] VGND VGND VPWR VPWR net84 sky130_fd_sc_hd__dlygate4sd3_1
Xhold25 RF0.regs\[7\]\[11\] VGND VGND VPWR VPWR net73 sky130_fd_sc_hd__dlygate4sd3_1
Xhold69 RF0.regs\[0\]\[5\] VGND VGND VPWR VPWR net117 sky130_fd_sc_hd__dlygate4sd3_1
X_5179_ clknet_leaf_35_clk _0555_ _0171_ VGND VGND VPWR VPWR RF0.regs\[7\]\[2\] sky130_fd_sc_hd__dfrtp_1
Xhold58 RF0.regs\[2\]\[7\] VGND VGND VPWR VPWR net106 sky130_fd_sc_hd__dlygate4sd3_1
XTAP_TAPCELL_ROW_82_931 VGND VPWR sky130_fd_sc_hd__tapvpwrvgnd_1
XTAP_TAPCELL_ROW_54_677 VGND VPWR sky130_fd_sc_hd__tapvpwrvgnd_1
XFILLER_0_81_505 VPWR VGND VPWR VGND sky130_ef_sc_hd__decap_12
XFILLER_0_53_218 VGND VGND VPWR VPWR sky130_fd_sc_hd__decap_6
XPHY_EDGE_ROW_20_Left_108 VGND VGND VPWR VPWR sky130_fd_sc_hd__decap_3
XFILLER_0_34_487 VGND VGND VPWR VPWR sky130_fd_sc_hd__fill_2
XTAP_TAPCELL_ROW_17_346 VGND VPWR sky130_fd_sc_hd__tapvpwrvgnd_1
X_2880_ _0805_ _0848_ _0859_ _1102_ VGND VGND VPWR VPWR _1143_ sky130_fd_sc_hd__and4_1
X_4550_ _0799_ _1686_ _1687_ VGND VGND VPWR VPWR net10 sky130_fd_sc_hd__nor3_1
X_3501_ RF0.regs\[4\]\[19\] _1239_ _1232_ RF0.regs\[6\]\[19\] _1693_ VGND VGND VPWR
+ VPWR _1694_ sky130_fd_sc_hd__a221o_1
X_4481_ _2379_ VGND VGND VPWR VPWR _0397_ sky130_fd_sc_hd__clkbuf_1
X_3432_ _1010_ _1534_ _1625_ VGND VGND VPWR VPWR _1626_ sky130_fd_sc_hd__nand3_1
X_3363_ RF0.regs\[4\]\[30\] _1241_ _1225_ RF0.regs\[20\]\[30\] _1557_ VGND VGND VPWR
+ VPWR _1558_ sky130_fd_sc_hd__a221o_1
X_5102_ clknet_leaf_11_clk _0478_ _0094_ VGND VGND VPWR VPWR RF0.regs\[15\]\[21\]
+ sky130_fd_sc_hd__dfrtp_1
X_3294_ _1488_ _0841_ _1308_ _1489_ VGND VGND VPWR VPWR _1490_ sky130_fd_sc_hd__nand4_1
X_5033_ clknet_leaf_17_clk _0409_ _0025_ VGND VGND VPWR VPWR RF0.regs\[25\]\[16\]
+ sky130_fd_sc_hd__dfrtp_1
XFILLER_0_73_63 VGND VGND VPWR VPWR sky130_fd_sc_hd__decap_4
XPHY_EDGE_ROW_11_Left_99 VGND VGND VPWR VPWR sky130_fd_sc_hd__decap_3
XFILLER_0_87_181 VPWR VGND VPWR VGND sky130_ef_sc_hd__decap_12
XTAP_TAPCELL_ROW_51_647 VGND VPWR sky130_fd_sc_hd__tapvpwrvgnd_1
X_4817_ _2468_ VGND VGND VPWR VPWR _0220_ sky130_fd_sc_hd__inv_2
XFILLER_0_63_516 VGND VGND VPWR VPWR sky130_fd_sc_hd__fill_1
X_4748_ _2460_ VGND VGND VPWR VPWR _0159_ sky130_fd_sc_hd__inv_2
XFILLER_0_16_498 VGND VGND VPWR VPWR sky130_fd_sc_hd__fill_2
X_4679_ _2450_ VGND VGND VPWR VPWR _0100_ sky130_fd_sc_hd__inv_2
Xoutput15 net15 VGND VGND VPWR VPWR Result[21] sky130_fd_sc_hd__clkbuf_4
XPHY_EDGE_ROW_1_Right_1 VGND VGND VPWR VPWR sky130_fd_sc_hd__decap_3
XFILLER_0_3_381 VGND VGND VPWR VPWR sky130_fd_sc_hd__decap_8
Xoutput26 net26 VGND VGND VPWR VPWR Result[31] sky130_fd_sc_hd__buf_6
Xoutput37 net37 VGND VGND VPWR VPWR an[3] sky130_fd_sc_hd__buf_2
XTAP_TAPCELL_ROW_67_791 VGND VPWR sky130_fd_sc_hd__tapvpwrvgnd_1
XFILLER_0_78_170 VGND VGND VPWR VPWR sky130_fd_sc_hd__decap_6
XTAP_TAPCELL_ROW_14_316 VGND VPWR sky130_fd_sc_hd__tapvpwrvgnd_1
XFILLER_0_54_505 VPWR VGND VPWR VGND sky130_ef_sc_hd__decap_12
XFILLER_0_81_346 VGND VGND VPWR VPWR sky130_fd_sc_hd__decap_6
XFILLER_0_19_281 VPWR VGND VPWR VGND sky130_ef_sc_hd__decap_12
XFILLER_0_34_262 VPWR VGND VPWR VGND sky130_ef_sc_hd__decap_12
XFILLER_0_1_329 VGND VGND VPWR VPWR sky130_fd_sc_hd__fill_1
XFILLER_0_43_11 VGND VGND VPWR VPWR sky130_fd_sc_hd__fill_1
X_3981_ RF0.regs\[5\]\[17\] _2005_ _2113_ VGND VGND VPWR VPWR _2118_ sky130_fd_sc_hd__mux2_1
X_2932_ _1171_ VGND VGND VPWR VPWR _0724_ sky130_fd_sc_hd__clkbuf_1
Xclkbuf_leaf_42_clk clknet_2_0__leaf_clk VGND VGND VPWR VPWR clknet_leaf_42_clk sky130_fd_sc_hd__clkbuf_8
XFILLER_0_45_505 VPWR VGND VPWR VGND sky130_ef_sc_hd__decap_12
XFILLER_0_57_376 VGND VGND VPWR VPWR sky130_fd_sc_hd__fill_2
X_2863_ _1117_ net240 VGND VGND VPWR VPWR _1132_ sky130_fd_sc_hd__and2_1
X_2794_ RF0.regs\[10\]\[23\] _0909_ _0868_ RF0.regs\[4\]\[23\] VGND VGND VPWR VPWR
+ _1086_ sky130_fd_sc_hd__a22o_1
X_4602_ _2440_ VGND VGND VPWR VPWR _0033_ sky130_fd_sc_hd__inv_2
X_4533_ _2404_ _2415_ VGND VGND VPWR VPWR _2417_ sky130_fd_sc_hd__xnor2_1
XFILLER_0_7_55 VGND VGND VPWR VPWR sky130_fd_sc_hd__fill_1
X_4464_ _2370_ VGND VGND VPWR VPWR _0405_ sky130_fd_sc_hd__clkbuf_1
XFILLER_0_68_41 VGND VGND VPWR VPWR sky130_fd_sc_hd__fill_2
X_4395_ _2334_ VGND VGND VPWR VPWR _0438_ sky130_fd_sc_hd__clkbuf_1
X_3415_ _1607_ _1608_ VGND VGND VPWR VPWR _1609_ sky130_fd_sc_hd__xnor2_1
X_3346_ _1540_ _1356_ _1541_ VGND VGND VPWR VPWR _1542_ sky130_fd_sc_hd__a21boi_4
X_5016_ clknet_leaf_32_clk _0006_ VGND VGND VPWR VPWR net44 sky130_fd_sc_hd__dfxtp_1
X_3277_ _0828_ _1304_ _1472_ VGND VGND VPWR VPWR _1473_ sky130_fd_sc_hd__or3_2
XTAP_TAPCELL_ROW_64_761 VGND VPWR sky130_fd_sc_hd__tapvpwrvgnd_1
XFILLER_0_75_173 VGND VGND VPWR VPWR sky130_fd_sc_hd__fill_1
Xclkbuf_leaf_33_clk clknet_2_2__leaf_clk VGND VGND VPWR VPWR clknet_leaf_33_clk sky130_fd_sc_hd__clkbuf_8
XFILLER_0_36_516 VGND VGND VPWR VPWR sky130_fd_sc_hd__fill_1
XFILLER_0_48_365 VGND VGND VPWR VPWR sky130_fd_sc_hd__decap_3
XFILLER_0_31_287 VGND VGND VPWR VPWR sky130_fd_sc_hd__decap_8
XTAP_TAPCELL_ROW_27_430 VGND VPWR sky130_fd_sc_hd__tapvpwrvgnd_1
XFILLER_0_58_107 VGND VGND VPWR VPWR sky130_fd_sc_hd__decap_4
XFILLER_0_39_332 VGND VGND VPWR VPWR sky130_fd_sc_hd__decap_4
Xclkbuf_leaf_24_clk clknet_2_3__leaf_clk VGND VGND VPWR VPWR clknet_leaf_24_clk sky130_fd_sc_hd__clkbuf_8
XFILLER_0_13_69 VGND VGND VPWR VPWR sky130_fd_sc_hd__decap_8
XFILLER_0_39_398 VGND VGND VPWR VPWR sky130_fd_sc_hd__decap_8
XFILLER_0_66_173 VGND VGND VPWR VPWR sky130_fd_sc_hd__fill_2
X_3200_ RF0.regs\[10\]\[0\] _0809_ _1251_ RF0.regs\[25\]\[0\] VGND VGND VPWR VPWR
+ _1396_ sky130_fd_sc_hd__a22o_1
X_4180_ _2223_ VGND VGND VPWR VPWR _0542_ sky130_fd_sc_hd__clkbuf_1
X_3131_ _0996_ _1326_ _1258_ VGND VGND VPWR VPWR _1327_ sky130_fd_sc_hd__o21a_1
X_3062_ _1257_ VGND VGND VPWR VPWR _1258_ sky130_fd_sc_hd__clkbuf_4
X_3964_ RF0.regs\[5\]\[25\] _1978_ _2102_ VGND VGND VPWR VPWR _2109_ sky130_fd_sc_hd__mux2_1
XFILLER_0_18_516 VGND VGND VPWR VPWR sky130_fd_sc_hd__fill_1
Xclkbuf_leaf_15_clk clknet_2_3__leaf_clk VGND VGND VPWR VPWR clknet_leaf_15_clk sky130_fd_sc_hd__clkbuf_8
XFILLER_0_57_162 VGND VGND VPWR VPWR sky130_fd_sc_hd__decap_6
XTAP_TAPCELL_ROW_61_742 VGND VPWR sky130_fd_sc_hd__tapvpwrvgnd_1
X_2915_ RF0.regs\[0\]\[19\] VGND VGND VPWR VPWR _1163_ sky130_fd_sc_hd__clkbuf_1
XTAP_TAPCELL_ROW_33_488 VGND VPWR sky130_fd_sc_hd__tapvpwrvgnd_1
XFILLER_0_57_184 VGND VGND VPWR VPWR sky130_fd_sc_hd__decap_6
X_3895_ _2018_ _2060_ VGND VGND VPWR VPWR _2061_ sky130_fd_sc_hd__nand2_1
X_2846_ _1123_ VGND VGND VPWR VPWR _0762_ sky130_fd_sc_hd__clkbuf_1
XFILLER_0_33_508 VGND VGND VPWR VPWR sky130_fd_sc_hd__decap_8
XFILLER_0_45_357 VGND VGND VPWR VPWR sky130_fd_sc_hd__decap_6
XFILLER_0_79_51 VGND VGND VPWR VPWR sky130_fd_sc_hd__decap_4
XFILLER_0_78_3 VPWR VGND VPWR VGND sky130_ef_sc_hd__decap_12
X_2777_ RF0.regs\[10\]\[1\] _0882_ VGND VGND VPWR VPWR _1069_ sky130_fd_sc_hd__and2_1
Xhold100 RF0.regs\[2\]\[17\] VGND VGND VPWR VPWR net148 sky130_fd_sc_hd__dlygate4sd3_1
X_4516_ _2399_ _2401_ _2404_ VGND VGND VPWR VPWR _2405_ sky130_fd_sc_hd__a21oi_1
Xhold133 RF0.regs\[20\]\[3\] VGND VGND VPWR VPWR net181 sky130_fd_sc_hd__dlygate4sd3_1
Xhold122 IM0.addr\[12\] VGND VGND VPWR VPWR net170 sky130_fd_sc_hd__dlygate4sd3_1
Xhold144 RF0.regs\[0\]\[28\] VGND VGND VPWR VPWR net192 sky130_fd_sc_hd__dlygate4sd3_1
Xhold111 RF0.regs\[7\]\[27\] VGND VGND VPWR VPWR net159 sky130_fd_sc_hd__dlygate4sd3_1
X_4447_ RF0.regs\[25\]\[20\] _1996_ _2360_ VGND VGND VPWR VPWR _2362_ sky130_fd_sc_hd__mux2_1
Xhold177 RF0.regs\[20\]\[23\] VGND VGND VPWR VPWR net225 sky130_fd_sc_hd__dlygate4sd3_1
Xhold155 RF0.regs\[5\]\[0\] VGND VGND VPWR VPWR net203 sky130_fd_sc_hd__dlygate4sd3_1
Xhold166 IM0.addr\[9\] VGND VGND VPWR VPWR net214 sky130_fd_sc_hd__dlygate4sd3_1
Xhold199 RF0.regs\[20\]\[21\] VGND VGND VPWR VPWR net247 sky130_fd_sc_hd__dlygate4sd3_1
Xhold188 RF0.regs\[20\]\[25\] VGND VGND VPWR VPWR net236 sky130_fd_sc_hd__dlygate4sd3_1
X_4378_ net247 _1992_ _2325_ VGND VGND VPWR VPWR _2326_ sky130_fd_sc_hd__mux2_1
X_3329_ net59 _1507_ VGND VGND VPWR VPWR _1525_ sky130_fd_sc_hd__and2_1
XFILLER_0_63_110 VGND VGND VPWR VPWR sky130_fd_sc_hd__fill_2
XFILLER_0_63_121 VPWR VGND VPWR VGND sky130_ef_sc_hd__decap_12
XTAP_TAPCELL_ROW_75_867 VGND VPWR sky130_fd_sc_hd__tapvpwrvgnd_1
XFILLER_0_86_257 VGND VGND VPWR VPWR sky130_fd_sc_hd__fill_1
XFILLER_0_39_162 VGND VGND VPWR VPWR sky130_fd_sc_hd__decap_6
XFILLER_0_27_335 VGND VGND VPWR VPWR sky130_fd_sc_hd__fill_1
XFILLER_0_39_173 VGND VGND VPWR VPWR sky130_fd_sc_hd__fill_1
X_2700_ _0989_ _0990_ _0991_ VGND VGND VPWR VPWR _0992_ sky130_fd_sc_hd__or3_1
XFILLER_0_54_154 VPWR VGND VPWR VGND sky130_ef_sc_hd__decap_12
X_3680_ RF0.regs\[0\]\[3\] _1216_ _1863_ _1865_ VGND VGND VPWR VPWR _1866_ sky130_fd_sc_hd__o22a_1
XTAP_TAPCELL_ROW_30_458 VGND VPWR sky130_fd_sc_hd__tapvpwrvgnd_1
X_2631_ RF0.regs\[10\]\[15\] _0884_ _0874_ RF0.regs\[5\]\[15\] VGND VGND VPWR VPWR
+ _0923_ sky130_fd_sc_hd__a22o_1
XFILLER_0_2_413 VGND VGND VPWR VPWR sky130_fd_sc_hd__decap_6
X_5350_ clknet_leaf_21_clk _0726_ _0342_ VGND VGND VPWR VPWR RF0.regs\[0\]\[13\] sky130_fd_sc_hd__dfrtp_1
XFILLER_0_2_457 VPWR VGND VPWR VGND sky130_ef_sc_hd__decap_12
X_2562_ _0853_ VGND VGND VPWR VPWR _0854_ sky130_fd_sc_hd__clkbuf_4
X_5281_ clknet_leaf_28_clk _0657_ _0273_ VGND VGND VPWR VPWR RF0.regs\[4\]\[8\] sky130_fd_sc_hd__dfrtp_1
X_4301_ _2285_ VGND VGND VPWR VPWR _0483_ sky130_fd_sc_hd__clkbuf_1
X_2493_ IM0.addr\[16\] IM0.addr\[18\] IM0.addr\[17\] IM0.addr\[19\] VGND VGND VPWR
+ VPWR _0785_ sky130_fd_sc_hd__or4_4
X_4232_ net261 VGND VGND VPWR VPWR _2250_ sky130_fd_sc_hd__clkbuf_1
Xclkbuf_leaf_4_clk clknet_2_1__leaf_clk VGND VGND VPWR VPWR clknet_leaf_4_clk sky130_fd_sc_hd__clkbuf_8
X_4163_ _2214_ VGND VGND VPWR VPWR _0550_ sky130_fd_sc_hd__clkbuf_1
X_4094_ _2179_ VGND VGND VPWR VPWR _0584_ sky130_fd_sc_hd__clkbuf_1
X_3114_ _1027_ _1026_ _1309_ _1257_ VGND VGND VPWR VPWR _1310_ sky130_fd_sc_hd__o31a_1
X_3045_ _1240_ VGND VGND VPWR VPWR _1241_ sky130_fd_sc_hd__buf_4
X_4996_ _2488_ VGND VGND VPWR VPWR _0379_ sky130_fd_sc_hd__inv_2
X_3947_ RF0.regs\[4\]\[1\] _2099_ _0880_ VGND VGND VPWR VPWR _2100_ sky130_fd_sc_hd__mux2_1
X_3878_ _2034_ _2043_ _1897_ VGND VGND VPWR VPWR _2044_ sky130_fd_sc_hd__a21oi_2
X_2829_ _1108_ net172 VGND VGND VPWR VPWR _1114_ sky130_fd_sc_hd__and2_1
XFILLER_0_5_273 VGND VGND VPWR VPWR sky130_fd_sc_hd__fill_1
XTAP_TAPCELL_ROW_72_837 VGND VPWR sky130_fd_sc_hd__tapvpwrvgnd_1
XTAP_TAPCELL_ROW_1_194 VGND VPWR sky130_fd_sc_hd__tapvpwrvgnd_1
XFILLER_0_83_216 VGND VGND VPWR VPWR sky130_fd_sc_hd__decap_8
XFILLER_0_36_187 VGND VGND VPWR VPWR sky130_fd_sc_hd__decap_8
XFILLER_0_51_113 VGND VGND VPWR VPWR sky130_fd_sc_hd__fill_2
XFILLER_0_10_15 VPWR VGND VPWR VGND sky130_ef_sc_hd__decap_12
XTAP_TAPCELL_ROW_9_272 VGND VPWR sky130_fd_sc_hd__tapvpwrvgnd_1
XFILLER_0_19_57 VGND VGND VPWR VPWR sky130_fd_sc_hd__fill_1
XFILLER_0_59_213 VGND VGND VPWR VPWR sky130_fd_sc_hd__decap_8
XTAP_TAPCELL_ROW_35_506 VGND VPWR sky130_fd_sc_hd__tapvpwrvgnd_1
X_4850_ _2472_ VGND VGND VPWR VPWR _0249_ sky130_fd_sc_hd__inv_2
XFILLER_0_59_268 VPWR VGND VPWR VGND sky130_ef_sc_hd__decap_12
XFILLER_0_7_505 VPWR VGND VPWR VGND sky130_ef_sc_hd__decap_12
X_3801_ _1629_ _1933_ VGND VGND VPWR VPWR _1980_ sky130_fd_sc_hd__nand2_1
X_4781_ _2465_ VGND VGND VPWR VPWR _0187_ sky130_fd_sc_hd__inv_2
XTAP_TAPCELL_ROW_43_572 VGND VPWR sky130_fd_sc_hd__tapvpwrvgnd_1
XFILLER_0_51_88 VGND VGND VPWR VPWR sky130_fd_sc_hd__decap_8
XFILLER_0_55_430 VGND VGND VPWR VPWR sky130_fd_sc_hd__fill_1
X_3732_ _1794_ _1914_ _1917_ VGND VGND VPWR VPWR _1918_ sky130_fd_sc_hd__o21ai_2
Xclkload20 clknet_leaf_13_clk VGND VGND VPWR VPWR clkload20/Y sky130_fd_sc_hd__clkinv_1
X_3663_ RF0.regs\[5\]\[5\] _0864_ _1231_ RF0.regs\[6\]\[5\] _1848_ VGND VGND VPWR
+ VPWR _1849_ sky130_fd_sc_hd__a221o_1
XFILLER_0_70_477 VGND VGND VPWR VPWR sky130_fd_sc_hd__fill_2
X_5402_ clknet_leaf_32_clk net13 VGND VGND VPWR VPWR disp.digits\[1\] sky130_fd_sc_hd__dfxtp_1
Xclkload31 clknet_leaf_37_clk VGND VGND VPWR VPWR clkload31/Y sky130_fd_sc_hd__bufinv_16
X_2614_ RF0.regs\[4\]\[17\] _0839_ _0845_ RF0.regs\[12\]\[17\] VGND VGND VPWR VPWR
+ _0906_ sky130_fd_sc_hd__a22o_1
Xclkload42 clknet_leaf_25_clk VGND VGND VPWR VPWR clkload42/Y sky130_fd_sc_hd__clkinv_4
X_5333_ clknet_leaf_1_clk _0709_ _0325_ VGND VGND VPWR VPWR RF0.regs\[2\]\[28\] sky130_fd_sc_hd__dfrtp_1
X_3594_ RF0.regs\[25\]\[11\] _0813_ _0974_ _0795_ VGND VGND VPWR VPWR _1785_ sky130_fd_sc_hd__a211o_1
X_2545_ _0836_ VGND VGND VPWR VPWR _0837_ sky130_fd_sc_hd__clkbuf_4
XFILLER_0_76_41 VPWR VGND VPWR VGND sky130_ef_sc_hd__decap_12
X_5264_ clknet_leaf_8_clk _0640_ _0256_ VGND VGND VPWR VPWR RF0.regs\[5\]\[23\] sky130_fd_sc_hd__dfrtp_2
X_5195_ clknet_leaf_12_clk _0571_ _0187_ VGND VGND VPWR VPWR RF0.regs\[7\]\[18\] sky130_fd_sc_hd__dfrtp_1
XFILLER_0_76_85 VGND VGND VPWR VPWR sky130_fd_sc_hd__fill_1
X_4215_ _2241_ VGND VGND VPWR VPWR _0525_ sky130_fd_sc_hd__clkbuf_1
X_4146_ _2205_ VGND VGND VPWR VPWR _0558_ sky130_fd_sc_hd__clkbuf_1
X_4077_ _2168_ VGND VGND VPWR VPWR _0589_ sky130_fd_sc_hd__clkbuf_1
X_3028_ _1223_ VGND VGND VPWR VPWR _1224_ sky130_fd_sc_hd__buf_4
XFILLER_0_65_216 VGND VGND VPWR VPWR sky130_fd_sc_hd__decap_8
X_4979_ _2486_ VGND VGND VPWR VPWR _0364_ sky130_fd_sc_hd__inv_2
Xclkload3 clknet_leaf_2_clk VGND VGND VPWR VPWR clkload3/Y sky130_fd_sc_hd__inv_6
XFILLER_0_33_102 VGND VGND VPWR VPWR sky130_fd_sc_hd__fill_1
XFILLER_0_33_124 VGND VGND VPWR VPWR sky130_fd_sc_hd__fill_1
XFILLER_0_61_422 VGND VGND VPWR VPWR sky130_fd_sc_hd__fill_1
XFILLER_0_14_393 VGND VGND VPWR VPWR sky130_fd_sc_hd__fill_1
XFILLER_0_41_190 VGND VGND VPWR VPWR sky130_fd_sc_hd__decap_3
XTAP_TAPCELL_ROW_6_242 VGND VPWR sky130_fd_sc_hd__tapvpwrvgnd_1
XTAP_TAPCELL_ROW_85_951 VGND VPWR sky130_fd_sc_hd__tapvpwrvgnd_1
XFILLER_0_24_102 VGND VGND VPWR VPWR sky130_fd_sc_hd__decap_3
XFILLER_0_37_463 VGND VGND VPWR VPWR sky130_fd_sc_hd__fill_1
XTAP_TAPCELL_ROW_40_553 VGND VPWR sky130_fd_sc_hd__tapvpwrvgnd_1
XFILLER_0_21_69 VPWR VGND VPWR VGND sky130_ef_sc_hd__decap_12
XTAP_TAPCELL_ROW_12_299 VGND VPWR sky130_fd_sc_hd__tapvpwrvgnd_1
XFILLER_0_52_477 VGND VGND VPWR VPWR sky130_fd_sc_hd__decap_4
X_4000_ RF0.regs\[5\]\[8\] _2083_ _2124_ VGND VGND VPWR VPWR _2128_ sky130_fd_sc_hd__mux2_1
XTAP_TAPCELL_ROW_48_620 VGND VPWR sky130_fd_sc_hd__tapvpwrvgnd_1
XFILLER_0_75_503 VGND VGND VPWR VPWR sky130_fd_sc_hd__fill_1
XFILLER_0_1_57 VPWR VGND VPWR VGND sky130_ef_sc_hd__decap_12
X_4902_ _2477_ VGND VGND VPWR VPWR _0296_ sky130_fd_sc_hd__inv_2
X_4833_ _2470_ VGND VGND VPWR VPWR _0234_ sky130_fd_sc_hd__inv_2
X_4764_ _2464_ VGND VGND VPWR VPWR _0171_ sky130_fd_sc_hd__inv_2
XFILLER_0_28_474 VGND VGND VPWR VPWR sky130_fd_sc_hd__fill_2
X_3715_ _1418_ _1386_ VGND VGND VPWR VPWR _1901_ sky130_fd_sc_hd__or2b_1
X_4695_ _2454_ VGND VGND VPWR VPWR _0112_ sky130_fd_sc_hd__inv_2
XFILLER_0_70_296 VGND VGND VPWR VPWR sky130_fd_sc_hd__fill_2
XFILLER_0_11_91 VGND VGND VPWR VPWR sky130_fd_sc_hd__decap_4
X_3646_ _1831_ _1832_ _1007_ VGND VGND VPWR VPWR _1833_ sky130_fd_sc_hd__and3b_1
XFILLER_0_60_3 VGND VGND VPWR VPWR sky130_fd_sc_hd__decap_4
X_3577_ _1768_ VGND VGND VPWR VPWR net6 sky130_fd_sc_hd__buf_1
X_2528_ IM0.addr\[0\] VGND VGND VPWR VPWR _0820_ sky130_fd_sc_hd__buf_6
X_5316_ clknet_leaf_26_clk _0692_ _0308_ VGND VGND VPWR VPWR RF0.regs\[2\]\[11\] sky130_fd_sc_hd__dfrtp_1
X_5247_ clknet_leaf_33_clk _0623_ _0239_ VGND VGND VPWR VPWR RF0.regs\[5\]\[6\] sky130_fd_sc_hd__dfrtp_1
XFILLER_0_11_396 VGND VGND VPWR VPWR sky130_fd_sc_hd__fill_1
Xhold26 RF0.regs\[12\]\[6\] VGND VGND VPWR VPWR net74 sky130_fd_sc_hd__dlygate4sd3_1
Xhold37 RF0.regs\[2\]\[16\] VGND VGND VPWR VPWR net85 sky130_fd_sc_hd__dlygate4sd3_1
Xhold48 RF0.regs\[7\]\[22\] VGND VGND VPWR VPWR net96 sky130_fd_sc_hd__dlygate4sd3_1
XTAP_TAPCELL_ROW_3_212 VGND VPWR sky130_fd_sc_hd__tapvpwrvgnd_1
X_5178_ clknet_leaf_41_clk _0554_ _0170_ VGND VGND VPWR VPWR RF0.regs\[7\]\[1\] sky130_fd_sc_hd__dfrtp_1
Xhold59 RF0.regs\[7\]\[29\] VGND VGND VPWR VPWR net107 sky130_fd_sc_hd__dlygate4sd3_1
X_4129_ net80 VGND VGND VPWR VPWR _2197_ sky130_fd_sc_hd__clkbuf_1
XFILLER_0_78_374 VGND VGND VPWR VPWR sky130_fd_sc_hd__decap_4
XFILLER_0_38_216 VGND VGND VPWR VPWR sky130_fd_sc_hd__fill_1
XFILLER_0_38_227 VGND VGND VPWR VPWR sky130_fd_sc_hd__fill_1
XTAP_TAPCELL_ROW_54_678 VGND VPWR sky130_fd_sc_hd__tapvpwrvgnd_1
XFILLER_0_19_496 VGND VGND VPWR VPWR sky130_fd_sc_hd__fill_1
XFILLER_0_46_293 VGND VGND VPWR VPWR sky130_fd_sc_hd__fill_1
XFILLER_0_34_477 VGND VGND VPWR VPWR sky130_fd_sc_hd__decap_4
XFILLER_0_61_285 VGND VGND VPWR VPWR sky130_fd_sc_hd__decap_6
XFILLER_0_14_190 VGND VGND VPWR VPWR sky130_fd_sc_hd__decap_6
XFILLER_0_57_503 VGND VGND VPWR VPWR sky130_fd_sc_hd__fill_1
XFILLER_0_32_79 VGND VGND VPWR VPWR sky130_fd_sc_hd__decap_4
XFILLER_0_37_260 VGND VGND VPWR VPWR sky130_fd_sc_hd__decap_3
XFILLER_0_4_305 VGND VGND VPWR VPWR sky130_fd_sc_hd__decap_3
X_3500_ RF0.regs\[10\]\[19\] _0886_ _0814_ RF0.regs\[25\]\[19\] _1246_ VGND VGND VPWR
+ VPWR _1693_ sky130_fd_sc_hd__a221o_1
XFILLER_0_12_127 VGND VGND VPWR VPWR sky130_fd_sc_hd__fill_2
XPHY_EDGE_ROW_2_Left_90 VGND VGND VPWR VPWR sky130_fd_sc_hd__decap_3
X_4480_ RF0.regs\[25\]\[4\] _2092_ _2371_ VGND VGND VPWR VPWR _2379_ sky130_fd_sc_hd__mux2_1
X_3431_ _1533_ _1359_ _1517_ _1532_ VGND VGND VPWR VPWR _1625_ sky130_fd_sc_hd__o211ai_1
X_3362_ RF0.regs\[25\]\[30\] _0816_ _0888_ _1247_ VGND VGND VPWR VPWR _1557_ sky130_fd_sc_hd__a211o_1
X_5101_ clknet_leaf_11_clk _0477_ _0093_ VGND VGND VPWR VPWR RF0.regs\[15\]\[20\]
+ sky130_fd_sc_hd__dfrtp_1
XFILLER_0_20_193 VGND VGND VPWR VPWR sky130_fd_sc_hd__decap_3
X_3293_ net49 _1307_ _1265_ VGND VGND VPWR VPWR _1489_ sky130_fd_sc_hd__a21bo_1
X_5032_ clknet_leaf_19_clk _0408_ _0024_ VGND VGND VPWR VPWR RF0.regs\[25\]\[15\]
+ sky130_fd_sc_hd__dfrtp_1
XFILLER_0_75_311 VPWR VGND VPWR VGND sky130_ef_sc_hd__decap_12
XFILLER_0_87_193 VGND VGND VPWR VPWR sky130_fd_sc_hd__decap_3
XFILLER_0_75_355 VGND VGND VPWR VPWR sky130_fd_sc_hd__fill_1
XFILLER_0_75_333 VGND VGND VPWR VPWR sky130_fd_sc_hd__decap_3
X_4816_ _2468_ VGND VGND VPWR VPWR _0219_ sky130_fd_sc_hd__inv_2
XFILLER_0_35_219 VGND VGND VPWR VPWR sky130_fd_sc_hd__decap_4
XTAP_TAPCELL_ROW_51_648 VGND VPWR sky130_fd_sc_hd__tapvpwrvgnd_1
XFILLER_0_7_154 VGND VGND VPWR VPWR sky130_fd_sc_hd__decap_4
XFILLER_0_16_477 VGND VGND VPWR VPWR sky130_fd_sc_hd__fill_1
X_4747_ _2460_ VGND VGND VPWR VPWR _0158_ sky130_fd_sc_hd__inv_2
X_4678_ _2450_ VGND VGND VPWR VPWR _0099_ sky130_fd_sc_hd__inv_2
X_3629_ RF0.regs\[7\]\[8\] _1243_ VGND VGND VPWR VPWR _1817_ sky130_fd_sc_hd__and2_1
Xoutput16 net16 VGND VGND VPWR VPWR Result[22] sky130_fd_sc_hd__clkbuf_4
Xoutput38 net38 VGND VGND VPWR VPWR seg[0] sky130_fd_sc_hd__buf_2
XFILLER_0_3_393 VPWR VGND VPWR VGND sky130_ef_sc_hd__decap_12
Xoutput27 net27 VGND VGND VPWR VPWR Result[3] sky130_fd_sc_hd__buf_2
XTAP_TAPCELL_ROW_67_792 VGND VPWR sky130_fd_sc_hd__tapvpwrvgnd_1
XFILLER_0_78_160 VGND VGND VPWR VPWR sky130_fd_sc_hd__fill_1
XFILLER_0_66_300 VGND VGND VPWR VPWR sky130_fd_sc_hd__decap_8
XTAP_TAPCELL_ROW_14_317 VGND VPWR sky130_fd_sc_hd__tapvpwrvgnd_1
XFILLER_0_19_293 VGND VGND VPWR VPWR sky130_fd_sc_hd__fill_2
XTAP_TAPCELL_ROW_22_383 VGND VPWR sky130_fd_sc_hd__tapvpwrvgnd_1
XFILLER_0_22_425 VGND VGND VPWR VPWR sky130_fd_sc_hd__decap_8
XFILLER_0_34_274 VGND VGND VPWR VPWR sky130_fd_sc_hd__fill_2
XFILLER_0_27_57 VGND VGND VPWR VPWR sky130_fd_sc_hd__decap_8
X_3980_ _2117_ VGND VGND VPWR VPWR _0635_ sky130_fd_sc_hd__clkbuf_1
XFILLER_0_57_311 VPWR VGND VPWR VGND sky130_ef_sc_hd__decap_12
XFILLER_0_43_78 VPWR VGND VPWR VGND sky130_ef_sc_hd__decap_12
X_2931_ net143 VGND VGND VPWR VPWR _1171_ sky130_fd_sc_hd__clkbuf_1
Xclkbuf_0_clk clk VGND VGND VPWR VPWR clknet_0_clk sky130_fd_sc_hd__clkbuf_16
X_2862_ _1131_ VGND VGND VPWR VPWR _0754_ sky130_fd_sc_hd__clkbuf_1
X_4601_ _2440_ VGND VGND VPWR VPWR _0032_ sky130_fd_sc_hd__inv_2
X_2793_ RF0.regs\[5\]\[23\] _0876_ _0856_ RF0.regs\[15\]\[23\] VGND VGND VPWR VPWR
+ _1085_ sky130_fd_sc_hd__a22o_1
X_4532_ _2393_ _2415_ _2416_ _2404_ VGND VGND VPWR VPWR _0004_ sky130_fd_sc_hd__o22a_1
XFILLER_0_25_285 VGND VGND VPWR VPWR sky130_fd_sc_hd__fill_1
X_4463_ RF0.regs\[25\]\[12\] _2069_ _2360_ VGND VGND VPWR VPWR _2370_ sky130_fd_sc_hd__mux2_1
XFILLER_0_13_469 VGND VGND VPWR VPWR sky130_fd_sc_hd__decap_6
X_3414_ _1539_ _1537_ VGND VGND VPWR VPWR _1608_ sky130_fd_sc_hd__nor2_1
X_4394_ net235 _2066_ _2325_ VGND VGND VPWR VPWR _2334_ sky130_fd_sc_hd__mux2_1
XPHY_EDGE_ROW_15_Right_15 VGND VGND VPWR VPWR sky130_fd_sc_hd__decap_3
XFILLER_0_7_89 VGND VGND VPWR VPWR sky130_fd_sc_hd__decap_3
X_3345_ _1353_ _1355_ VGND VGND VPWR VPWR _1541_ sky130_fd_sc_hd__nand2_1
XFILLER_0_84_41 VPWR VGND VPWR VGND sky130_ef_sc_hd__decap_12
X_3276_ _1300_ _1302_ _1303_ VGND VGND VPWR VPWR _1472_ sky130_fd_sc_hd__o21a_1
X_5015_ clknet_leaf_32_clk _0005_ VGND VGND VPWR VPWR net43 sky130_fd_sc_hd__dfxtp_1
XFILLER_0_84_85 VPWR VGND VPWR VGND sky130_ef_sc_hd__decap_12
XFILLER_0_23_3 VPWR VGND VPWR VGND sky130_ef_sc_hd__decap_12
XPHY_EDGE_ROW_24_Right_24 VGND VGND VPWR VPWR sky130_fd_sc_hd__decap_3
XTAP_TAPCELL_ROW_64_762 VGND VPWR sky130_fd_sc_hd__tapvpwrvgnd_1
XFILLER_0_63_325 VGND VGND VPWR VPWR sky130_fd_sc_hd__decap_8
XFILLER_0_16_241 VGND VGND VPWR VPWR sky130_fd_sc_hd__decap_4
XFILLER_0_71_391 VGND VGND VPWR VPWR sky130_fd_sc_hd__fill_1
XFILLER_0_31_233 VGND VGND VPWR VPWR sky130_fd_sc_hd__decap_3
XFILLER_0_31_255 VGND VGND VPWR VPWR sky130_fd_sc_hd__decap_8
XPHY_EDGE_ROW_33_Right_33 VGND VGND VPWR VPWR sky130_fd_sc_hd__decap_3
XPHY_EDGE_ROW_42_Right_42 VGND VGND VPWR VPWR sky130_fd_sc_hd__decap_3
XFILLER_0_79_480 VPWR VGND VPWR VGND sky130_ef_sc_hd__decap_12
XTAP_TAPCELL_ROW_27_431 VGND VPWR sky130_fd_sc_hd__tapvpwrvgnd_1
XFILLER_0_13_15 VPWR VGND VPWR VGND sky130_ef_sc_hd__decap_12
XFILLER_0_54_303 VGND VGND VPWR VPWR sky130_fd_sc_hd__decap_4
XFILLER_0_81_155 VGND VGND VPWR VPWR sky130_fd_sc_hd__decap_6
XFILLER_0_81_199 VPWR VGND VPWR VGND sky130_ef_sc_hd__decap_12
XFILLER_0_81_177 VGND VGND VPWR VPWR sky130_fd_sc_hd__fill_1
XFILLER_0_81_166 VGND VGND VPWR VPWR sky130_fd_sc_hd__fill_2
XPHY_EDGE_ROW_51_Right_51 VGND VGND VPWR VPWR sky130_fd_sc_hd__decap_3
XFILLER_0_1_105 VGND VGND VPWR VPWR sky130_fd_sc_hd__decap_6
XFILLER_0_62_391 VGND VGND VPWR VPWR sky130_fd_sc_hd__decap_4
X_3130_ RF0.regs\[5\]\[25\] _0875_ _1325_ VGND VGND VPWR VPWR _1326_ sky130_fd_sc_hd__a21o_1
XTAP_TAPCELL_ROW_78_887 VGND VPWR sky130_fd_sc_hd__tapvpwrvgnd_1
X_3061_ net65 VGND VGND VPWR VPWR _1257_ sky130_fd_sc_hd__clkbuf_4
XPHY_EDGE_ROW_60_Right_60 VGND VGND VPWR VPWR sky130_fd_sc_hd__decap_3
XFILLER_0_85_461 VPWR VGND VPWR VGND sky130_ef_sc_hd__decap_12
X_3963_ _2108_ VGND VGND VPWR VPWR _0643_ sky130_fd_sc_hd__clkbuf_1
X_2914_ _1162_ VGND VGND VPWR VPWR _0733_ sky130_fd_sc_hd__clkbuf_1
X_3894_ _2019_ _2059_ VGND VGND VPWR VPWR _2060_ sky130_fd_sc_hd__nor2_1
X_2845_ _1118_ net257 VGND VGND VPWR VPWR _1123_ sky130_fd_sc_hd__and2_1
XTAP_TAPCELL_ROW_33_489 VGND VPWR sky130_fd_sc_hd__tapvpwrvgnd_1
X_4515_ disp.digits\[3\] _0777_ _2403_ VGND VGND VPWR VPWR _2404_ sky130_fd_sc_hd__o21ai_4
Xhold101 RF0.regs\[12\]\[29\] VGND VGND VPWR VPWR net149 sky130_fd_sc_hd__dlygate4sd3_1
X_2776_ RF0.regs\[10\]\[22\] _0817_ _0830_ RF0.regs\[25\]\[22\] _1067_ VGND VGND VPWR
+ VPWR _1068_ sky130_fd_sc_hd__a221o_1
Xhold123 RF0.regs\[20\]\[14\] VGND VGND VPWR VPWR net171 sky130_fd_sc_hd__dlygate4sd3_1
Xhold134 IM0.addr\[20\] VGND VGND VPWR VPWR net182 sky130_fd_sc_hd__dlygate4sd3_1
Xhold112 RF0.regs\[0\]\[26\] VGND VGND VPWR VPWR net160 sky130_fd_sc_hd__dlygate4sd3_1
Xhold145 RF0.regs\[6\]\[16\] VGND VGND VPWR VPWR net193 sky130_fd_sc_hd__dlygate4sd3_1
Xhold167 RF0.regs\[20\]\[22\] VGND VGND VPWR VPWR net215 sky130_fd_sc_hd__dlygate4sd3_1
Xhold156 RF0.regs\[2\]\[27\] VGND VGND VPWR VPWR net204 sky130_fd_sc_hd__dlygate4sd3_1
X_4446_ _2361_ VGND VGND VPWR VPWR _0414_ sky130_fd_sc_hd__clkbuf_1
Xhold178 RF0.regs\[6\]\[8\] VGND VGND VPWR VPWR net226 sky130_fd_sc_hd__dlygate4sd3_1
X_4377_ _1225_ VGND VGND VPWR VPWR _2325_ sky130_fd_sc_hd__buf_4
Xhold189 RF0.regs\[20\]\[12\] VGND VGND VPWR VPWR net237 sky130_fd_sc_hd__dlygate4sd3_1
XTAP_TAPCELL_ROW_69_810 VGND VPWR sky130_fd_sc_hd__tapvpwrvgnd_1
X_3328_ _1518_ _1523_ VGND VGND VPWR VPWR _1524_ sky130_fd_sc_hd__or2_1
X_3259_ _1447_ _1450_ VGND VGND VPWR VPWR _1455_ sky130_fd_sc_hd__or2_1
XTAP_TAPCELL_ROW_24_401 VGND VPWR sky130_fd_sc_hd__tapvpwrvgnd_1
XFILLER_0_36_303 VGND VGND VPWR VPWR sky130_fd_sc_hd__decap_4
XFILLER_0_76_472 VGND VGND VPWR VPWR sky130_fd_sc_hd__decap_4
XFILLER_0_63_133 VGND VGND VPWR VPWR sky130_fd_sc_hd__decap_3
XTAP_TAPCELL_ROW_75_868 VGND VPWR sky130_fd_sc_hd__tapvpwrvgnd_1
XFILLER_0_74_409 VGND VGND VPWR VPWR sky130_fd_sc_hd__decap_8
XFILLER_0_39_152 VGND VGND VPWR VPWR sky130_fd_sc_hd__decap_3
XFILLER_0_27_314 VGND VGND VPWR VPWR sky130_fd_sc_hd__decap_3
XFILLER_0_40_24 VGND VGND VPWR VPWR sky130_fd_sc_hd__fill_1
XFILLER_0_82_475 VGND VGND VPWR VPWR sky130_fd_sc_hd__fill_1
XTAP_TAPCELL_ROW_30_459 VGND VPWR sky130_fd_sc_hd__tapvpwrvgnd_1
XFILLER_0_54_166 VGND VGND VPWR VPWR sky130_fd_sc_hd__fill_2
X_2630_ RF0.regs\[15\]\[15\] _0854_ _0863_ RF0.regs\[4\]\[15\] VGND VGND VPWR VPWR
+ _0922_ sky130_fd_sc_hd__a22o_1
X_2561_ _0852_ VGND VGND VPWR VPWR _0853_ sky130_fd_sc_hd__clkbuf_4
X_2492_ IM0.addr\[23\] IM0.addr\[22\] IM0.addr\[21\] IM0.addr\[20\] VGND VGND VPWR
+ VPWR _0784_ sky130_fd_sc_hd__or4_4
XFILLER_0_2_469 VGND VGND VPWR VPWR sky130_fd_sc_hd__decap_6
X_5280_ clknet_leaf_28_clk _0656_ _0272_ VGND VGND VPWR VPWR RF0.regs\[4\]\[7\] sky130_fd_sc_hd__dfrtp_1
X_4300_ RF0.regs\[15\]\[26\] _1975_ _2279_ VGND VGND VPWR VPWR _2285_ sky130_fd_sc_hd__mux2_1
X_4231_ _2249_ VGND VGND VPWR VPWR _0517_ sky130_fd_sc_hd__clkbuf_1
XFILLER_0_49_99 VPWR VGND VPWR VGND sky130_ef_sc_hd__decap_12
X_4162_ RF0.regs\[10\]\[29\] _1962_ _2211_ VGND VGND VPWR VPWR _2214_ sky130_fd_sc_hd__mux2_1
X_4093_ net99 VGND VGND VPWR VPWR _2179_ sky130_fd_sc_hd__clkbuf_1
X_3113_ RF0.regs\[2\]\[19\] _1237_ VGND VGND VPWR VPWR _1309_ sky130_fd_sc_hd__and2_1
X_3044_ _1239_ VGND VGND VPWR VPWR _1240_ sky130_fd_sc_hd__clkbuf_4
X_4995_ _2488_ VGND VGND VPWR VPWR _0378_ sky130_fd_sc_hd__inv_2
X_3946_ _2037_ _2040_ VGND VGND VPWR VPWR _2099_ sky130_fd_sc_hd__xor2_4
XFILLER_0_58_472 VGND VGND VPWR VPWR sky130_fd_sc_hd__decap_4
XFILLER_0_73_431 VPWR VGND VPWR VGND sky130_ef_sc_hd__decap_12
XFILLER_0_45_122 VPWR VGND VPWR VGND sky130_ef_sc_hd__decap_12
X_3877_ net24 _1876_ _2042_ VGND VGND VPWR VPWR _2043_ sky130_fd_sc_hd__a21o_1
XFILLER_0_45_166 VGND VGND VPWR VPWR sky130_fd_sc_hd__fill_2
X_2828_ _1113_ VGND VGND VPWR VPWR _0770_ sky130_fd_sc_hd__clkbuf_1
X_2759_ RF0.regs\[5\]\[14\] _0874_ _0878_ RF0.regs\[2\]\[14\] _1050_ VGND VGND VPWR
+ VPWR _1051_ sky130_fd_sc_hd__a221o_1
X_4429_ _2352_ VGND VGND VPWR VPWR _0422_ sky130_fd_sc_hd__clkbuf_1
XTAP_TAPCELL_ROW_72_838 VGND VPWR sky130_fd_sc_hd__tapvpwrvgnd_1
XFILLER_0_68_236 VPWR VGND VPWR VGND sky130_ef_sc_hd__decap_12
XTAP_TAPCELL_ROW_1_195 VGND VPWR sky130_fd_sc_hd__tapvpwrvgnd_1
XFILLER_0_36_100 VGND VGND VPWR VPWR sky130_fd_sc_hd__fill_2
XFILLER_0_49_494 VGND VGND VPWR VPWR sky130_fd_sc_hd__decap_6
XFILLER_0_76_291 VPWR VGND VPWR VGND sky130_ef_sc_hd__decap_12
XFILLER_0_64_486 VGND VGND VPWR VPWR sky130_fd_sc_hd__decap_4
XFILLER_0_17_391 VGND VGND VPWR VPWR sky130_fd_sc_hd__fill_1
XFILLER_0_10_27 VGND VGND VPWR VPWR sky130_fd_sc_hd__fill_1
XTAP_TAPCELL_ROW_9_273 VGND VPWR sky130_fd_sc_hd__tapvpwrvgnd_1
XFILLER_0_87_501 VGND VGND VPWR VPWR sky130_fd_sc_hd__decap_3
XFILLER_0_35_57 VPWR VGND VPWR VGND sky130_ef_sc_hd__decap_12
XTAP_TAPCELL_ROW_35_507 VGND VPWR sky130_fd_sc_hd__tapvpwrvgnd_1
XFILLER_0_59_225 VGND VGND VPWR VPWR sky130_fd_sc_hd__fill_2
X_4780_ _2465_ VGND VGND VPWR VPWR _0186_ sky130_fd_sc_hd__inv_2
XFILLER_0_74_228 VGND VGND VPWR VPWR sky130_fd_sc_hd__decap_4
XFILLER_0_74_217 VGND VGND VPWR VPWR sky130_fd_sc_hd__decap_8
X_3800_ _1979_ VGND VGND VPWR VPWR _0674_ sky130_fd_sc_hd__clkbuf_1
XTAP_TAPCELL_ROW_43_573 VGND VPWR sky130_fd_sc_hd__tapvpwrvgnd_1
X_3731_ net60 _1792_ _1915_ _1916_ VGND VGND VPWR VPWR _1917_ sky130_fd_sc_hd__a211o_1
XFILLER_0_70_401 VGND VGND VPWR VPWR sky130_fd_sc_hd__fill_1
Xclkload10 clknet_leaf_44_clk VGND VGND VPWR VPWR clkload10/Y sky130_fd_sc_hd__inv_6
X_3662_ RF0.regs\[25\]\[5\] _0811_ _0948_ _0795_ VGND VGND VPWR VPWR _1848_ sky130_fd_sc_hd__a211o_1
X_5401_ clknet_leaf_32_clk net2 VGND VGND VPWR VPWR disp.digits\[0\] sky130_fd_sc_hd__dfxtp_1
Xclkload32 clknet_leaf_38_clk VGND VGND VPWR VPWR clkload32/Y sky130_fd_sc_hd__inv_2
Xclkload43 clknet_leaf_26_clk VGND VGND VPWR VPWR clkload43/Y sky130_fd_sc_hd__bufinv_16
X_3593_ RF0.regs\[7\]\[11\] _1243_ VGND VGND VPWR VPWR _1784_ sky130_fd_sc_hd__and2_1
X_2613_ RF0.regs\[15\]\[17\] _0856_ _0902_ _0904_ VGND VGND VPWR VPWR _0905_ sky130_fd_sc_hd__a211o_1
Xclkload21 clknet_leaf_14_clk VGND VGND VPWR VPWR clkload21/Y sky130_fd_sc_hd__inv_8
X_5332_ clknet_leaf_3_clk _0708_ _0324_ VGND VGND VPWR VPWR RF0.regs\[2\]\[27\] sky130_fd_sc_hd__dfrtp_1
X_2544_ _0835_ VGND VGND VPWR VPWR _0836_ sky130_fd_sc_hd__clkbuf_4
X_5263_ clknet_leaf_8_clk _0639_ _0255_ VGND VGND VPWR VPWR RF0.regs\[5\]\[22\] sky130_fd_sc_hd__dfrtp_1
X_5194_ clknet_leaf_18_clk _0570_ _0186_ VGND VGND VPWR VPWR RF0.regs\[7\]\[17\] sky130_fd_sc_hd__dfrtp_1
XFILLER_0_76_53 VGND VGND VPWR VPWR sky130_fd_sc_hd__decap_6
X_4214_ RF0.regs\[10\]\[4\] _2092_ _2233_ VGND VGND VPWR VPWR _2241_ sky130_fd_sc_hd__mux2_1
X_4145_ net77 VGND VGND VPWR VPWR _2205_ sky130_fd_sc_hd__clkbuf_1
XFILLER_0_78_501 VPWR VGND VPWR VGND sky130_ef_sc_hd__decap_12
X_4076_ _2092_ net263 _2160_ VGND VGND VPWR VPWR _2168_ sky130_fd_sc_hd__mux2_1
X_3027_ _1222_ VGND VGND VPWR VPWR _1223_ sky130_fd_sc_hd__buf_4
X_4978_ _2486_ VGND VGND VPWR VPWR _0363_ sky130_fd_sc_hd__inv_2
XFILLER_0_80_209 VGND VGND VPWR VPWR sky130_fd_sc_hd__decap_6
X_3929_ _2087_ VGND VGND VPWR VPWR _0656_ sky130_fd_sc_hd__clkbuf_1
Xclkload4 clknet_leaf_3_clk VGND VGND VPWR VPWR clkload4/Y sky130_fd_sc_hd__inv_6
XFILLER_0_18_188 VGND VGND VPWR VPWR sky130_fd_sc_hd__decap_3
XFILLER_0_33_169 VGND VGND VPWR VPWR sky130_fd_sc_hd__decap_6
XTAP_TAPCELL_ROW_6_243 VGND VPWR sky130_fd_sc_hd__tapvpwrvgnd_1
XTAP_TAPCELL_ROW_85_952 VGND VPWR sky130_fd_sc_hd__tapvpwrvgnd_1
XTAP_TAPCELL_ROW_57_698 VGND VPWR sky130_fd_sc_hd__tapvpwrvgnd_1
XFILLER_0_21_15 VPWR VGND VPWR VGND sky130_ef_sc_hd__decap_12
XFILLER_0_64_283 VPWR VGND VPWR VGND sky130_ef_sc_hd__decap_12
XFILLER_0_46_23 VGND VGND VPWR VPWR sky130_fd_sc_hd__fill_2
XTAP_TAPCELL_ROW_48_621 VGND VPWR sky130_fd_sc_hd__tapvpwrvgnd_1
XFILLER_0_1_69 VPWR VGND VPWR VGND sky130_ef_sc_hd__decap_12
X_4901_ _2477_ VGND VGND VPWR VPWR _0295_ sky130_fd_sc_hd__inv_2
X_4832_ _2470_ VGND VGND VPWR VPWR _0233_ sky130_fd_sc_hd__inv_2
X_4763_ _2462_ VGND VGND VPWR VPWR _2464_ sky130_fd_sc_hd__clkbuf_8
X_3714_ _1860_ _1898_ _1899_ VGND VGND VPWR VPWR _1900_ sky130_fd_sc_hd__a21o_1
X_4694_ _2454_ VGND VGND VPWR VPWR _0111_ sky130_fd_sc_hd__inv_2
XFILLER_0_70_253 VGND VGND VPWR VPWR sky130_fd_sc_hd__fill_1
XFILLER_0_15_169 VGND VGND VPWR VPWR sky130_fd_sc_hd__fill_2
XFILLER_0_15_158 VGND VGND VPWR VPWR sky130_fd_sc_hd__fill_1
XFILLER_0_43_456 VGND VGND VPWR VPWR sky130_fd_sc_hd__decap_8
XFILLER_0_43_478 VPWR VGND VPWR VGND sky130_ef_sc_hd__decap_12
XFILLER_0_11_81 VGND VGND VPWR VPWR sky130_fd_sc_hd__decap_6
X_3645_ _1425_ _1427_ _1830_ VGND VGND VPWR VPWR _1832_ sky130_fd_sc_hd__a21o_1
XFILLER_0_87_41 VPWR VGND VPWR VGND sky130_ef_sc_hd__decap_12
X_3576_ _1009_ _1766_ _1767_ VGND VGND VPWR VPWR _1768_ sky130_fd_sc_hd__and3_1
XFILLER_0_87_85 VPWR VGND VPWR VGND sky130_ef_sc_hd__decap_12
X_2527_ IM0.addr\[2\] VGND VGND VPWR VPWR _0819_ sky130_fd_sc_hd__buf_2
XFILLER_0_11_375 VGND VGND VPWR VPWR sky130_fd_sc_hd__fill_2
X_5315_ clknet_leaf_26_clk _0691_ _0307_ VGND VGND VPWR VPWR RF0.regs\[2\]\[10\] sky130_fd_sc_hd__dfrtp_1
X_5246_ clknet_leaf_33_clk _0622_ _0238_ VGND VGND VPWR VPWR RF0.regs\[5\]\[5\] sky130_fd_sc_hd__dfrtp_1
XFILLER_0_53_3 VGND VGND VPWR VPWR sky130_fd_sc_hd__decap_4
Xhold38 RF0.regs\[0\]\[30\] VGND VGND VPWR VPWR net86 sky130_fd_sc_hd__dlygate4sd3_1
Xhold27 RF0.regs\[12\]\[10\] VGND VGND VPWR VPWR net75 sky130_fd_sc_hd__dlygate4sd3_1
Xhold49 RF0.regs\[7\]\[18\] VGND VGND VPWR VPWR net97 sky130_fd_sc_hd__dlygate4sd3_1
X_5177_ clknet_leaf_41_clk _0553_ _0169_ VGND VGND VPWR VPWR RF0.regs\[7\]\[0\] sky130_fd_sc_hd__dfrtp_1
XTAP_TAPCELL_ROW_3_213 VGND VPWR sky130_fd_sc_hd__tapvpwrvgnd_1
X_4128_ _2196_ VGND VGND VPWR VPWR _0567_ sky130_fd_sc_hd__clkbuf_1
X_4059_ _2069_ net245 _2149_ VGND VGND VPWR VPWR _2159_ sky130_fd_sc_hd__mux2_1
XFILLER_0_78_342 VPWR VGND VPWR VGND sky130_ef_sc_hd__decap_12
XTAP_TAPCELL_ROW_54_679 VGND VPWR sky130_fd_sc_hd__tapvpwrvgnd_1
XFILLER_0_19_431 VPWR VGND VPWR VGND sky130_ef_sc_hd__decap_12
XFILLER_0_38_239 VPWR VGND VPWR VGND sky130_ef_sc_hd__decap_12
XFILLER_0_46_261 VGND VGND VPWR VPWR sky130_fd_sc_hd__decap_6
XFILLER_0_61_253 VGND VGND VPWR VPWR sky130_fd_sc_hd__fill_1
XFILLER_0_16_15 VPWR VGND VPWR VGND sky130_ef_sc_hd__decap_12
XFILLER_0_52_220 VGND VGND VPWR VPWR sky130_fd_sc_hd__decap_4
XFILLER_0_12_117 VGND VGND VPWR VPWR sky130_fd_sc_hd__fill_2
XFILLER_0_0_501 VGND VGND VPWR VPWR sky130_fd_sc_hd__decap_3
X_3430_ RF0.regs\[0\]\[24\] _1219_ _1621_ _1623_ VGND VGND VPWR VPWR _1624_ sky130_fd_sc_hd__o22ai_1
X_3361_ RF0.regs\[5\]\[30\] _0868_ _1233_ RF0.regs\[6\]\[30\] VGND VGND VPWR VPWR
+ _1556_ sky130_fd_sc_hd__a22o_1
X_5100_ clknet_leaf_12_clk _0476_ _0092_ VGND VGND VPWR VPWR RF0.regs\[15\]\[19\]
+ sky130_fd_sc_hd__dfrtp_1
XFILLER_0_20_161 VGND VGND VPWR VPWR sky130_fd_sc_hd__decap_3
X_3292_ _1487_ VGND VGND VPWR VPWR _1488_ sky130_fd_sc_hd__inv_2
XFILLER_0_57_77 VGND VGND VPWR VPWR sky130_fd_sc_hd__fill_1
X_5031_ clknet_leaf_16_clk _0407_ _0023_ VGND VGND VPWR VPWR RF0.regs\[25\]\[14\]
+ sky130_fd_sc_hd__dfrtp_1
XFILLER_0_73_76 VPWR VGND VPWR VGND sky130_ef_sc_hd__decap_12
XFILLER_0_75_323 VGND VGND VPWR VPWR sky130_fd_sc_hd__fill_1
X_4815_ _2468_ VGND VGND VPWR VPWR _0218_ sky130_fd_sc_hd__inv_2
XTAP_TAPCELL_ROW_51_649 VGND VPWR sky130_fd_sc_hd__tapvpwrvgnd_1
XFILLER_0_16_467 VGND VGND VPWR VPWR sky130_fd_sc_hd__decap_8
X_4746_ _2460_ VGND VGND VPWR VPWR _0157_ sky130_fd_sc_hd__inv_2
X_4677_ _2450_ VGND VGND VPWR VPWR _0098_ sky130_fd_sc_hd__inv_2
X_3628_ RF0.regs\[6\]\[8\] _1231_ _1227_ RF0.regs\[15\]\[8\] _1815_ VGND VGND VPWR
+ VPWR _1816_ sky130_fd_sc_hd__a221o_1
Xoutput17 net17 VGND VGND VPWR VPWR Result[23] sky130_fd_sc_hd__clkbuf_4
Xoutput39 net39 VGND VGND VPWR VPWR seg[1] sky130_fd_sc_hd__buf_2
Xoutput28 net28 VGND VGND VPWR VPWR Result[4] sky130_fd_sc_hd__buf_2
X_3559_ RF0.regs\[5\]\[14\] _0961_ _1139_ VGND VGND VPWR VPWR _1751_ sky130_fd_sc_hd__and3_1
X_5229_ clknet_leaf_11_clk _0605_ _0221_ VGND VGND VPWR VPWR RF0.regs\[6\]\[20\] sky130_fd_sc_hd__dfrtp_1
XTAP_TAPCELL_ROW_59_716 VGND VPWR sky130_fd_sc_hd__tapvpwrvgnd_1
XTAP_TAPCELL_ROW_67_793 VGND VPWR sky130_fd_sc_hd__tapvpwrvgnd_1
XTAP_TAPCELL_ROW_14_318 VGND VPWR sky130_fd_sc_hd__tapvpwrvgnd_1
XFILLER_0_81_326 VGND VGND VPWR VPWR sky130_fd_sc_hd__fill_1
XTAP_TAPCELL_ROW_22_384 VGND VPWR sky130_fd_sc_hd__tapvpwrvgnd_1
XFILLER_0_76_109 VGND VGND VPWR VPWR sky130_fd_sc_hd__decap_3
XFILLER_0_57_323 VPWR VGND VPWR VGND sky130_ef_sc_hd__decap_12
XFILLER_0_57_345 VGND VGND VPWR VPWR sky130_fd_sc_hd__fill_1
X_2930_ _1170_ VGND VGND VPWR VPWR _0725_ sky130_fd_sc_hd__clkbuf_1
X_2861_ _1117_ net214 VGND VGND VPWR VPWR _1131_ sky130_fd_sc_hd__and2_1
X_4600_ _2440_ VGND VGND VPWR VPWR _0031_ sky130_fd_sc_hd__inv_2
XFILLER_0_72_359 VGND VGND VPWR VPWR sky130_fd_sc_hd__fill_2
XFILLER_0_25_231 VGND VGND VPWR VPWR sky130_fd_sc_hd__decap_8
X_2792_ _1052_ _1054_ _1072_ _1074_ _1083_ VGND VGND VPWR VPWR _1084_ sky130_fd_sc_hd__o221a_1
X_4531_ _2390_ _2399_ VGND VGND VPWR VPWR _2416_ sky130_fd_sc_hd__nor2_1
X_4462_ _2369_ VGND VGND VPWR VPWR _0406_ sky130_fd_sc_hd__clkbuf_1
XFILLER_0_7_57 VPWR VGND VPWR VGND sky130_ef_sc_hd__decap_12
X_3413_ _1360_ _1534_ VGND VGND VPWR VPWR _1607_ sky130_fd_sc_hd__nand2_1
X_4393_ _2333_ VGND VGND VPWR VPWR _0439_ sky130_fd_sc_hd__clkbuf_1
X_3344_ _1534_ _1360_ _1538_ _1539_ VGND VGND VPWR VPWR _1540_ sky130_fd_sc_hd__a31oi_4
X_3275_ RF0.regs\[10\]\[16\] _0812_ _1254_ RF0.regs\[12\]\[16\] _1470_ VGND VGND VPWR
+ VPWR _1471_ sky130_fd_sc_hd__a221o_1
XFILLER_0_84_53 VPWR VGND VPWR VGND sky130_ef_sc_hd__decap_12
X_5014_ clknet_leaf_32_clk _0004_ VGND VGND VPWR VPWR net42 sky130_fd_sc_hd__dfxtp_1
XFILLER_0_84_97 VPWR VGND VPWR VGND sky130_ef_sc_hd__decap_12
XFILLER_0_17_80 VGND VGND VPWR VPWR sky130_fd_sc_hd__decap_4
XFILLER_0_16_3 VPWR VGND VPWR VGND sky130_ef_sc_hd__decap_12
XFILLER_0_48_301 VGND VGND VPWR VPWR sky130_fd_sc_hd__fill_1
XTAP_TAPCELL_ROW_64_763 VGND VPWR sky130_fd_sc_hd__tapvpwrvgnd_1
XFILLER_0_8_475 VGND VGND VPWR VPWR sky130_fd_sc_hd__fill_1
XFILLER_0_16_253 VGND VGND VPWR VPWR sky130_fd_sc_hd__decap_6
X_4729_ _2458_ VGND VGND VPWR VPWR _0142_ sky130_fd_sc_hd__inv_2
XFILLER_0_31_223 VGND VGND VPWR VPWR sky130_fd_sc_hd__fill_1
XTAP_TAPCELL_ROW_27_432 VGND VPWR sky130_fd_sc_hd__tapvpwrvgnd_1
XFILLER_0_79_492 VPWR VGND VPWR VGND sky130_ef_sc_hd__decap_12
XPHY_EDGE_ROW_17_Left_105 VGND VGND VPWR VPWR sky130_fd_sc_hd__decap_3
XFILLER_0_13_27 VPWR VGND VPWR VGND sky130_ef_sc_hd__decap_12
XFILLER_0_66_197 VGND VGND VPWR VPWR sky130_fd_sc_hd__fill_1
XFILLER_0_10_418 VGND VGND VPWR VPWR sky130_fd_sc_hd__fill_2
XPHY_EDGE_ROW_26_Left_114 VGND VGND VPWR VPWR sky130_fd_sc_hd__decap_3
X_3060_ RF0.regs\[25\]\[30\] _1252_ _1254_ RF0.regs\[12\]\[30\] _1255_ VGND VGND VPWR
+ VPWR _1256_ sky130_fd_sc_hd__a221o_1
XTAP_TAPCELL_ROW_78_888 VGND VPWR sky130_fd_sc_hd__tapvpwrvgnd_1
XPHY_EDGE_ROW_35_Left_123 VGND VGND VPWR VPWR sky130_fd_sc_hd__decap_3
X_3962_ RF0.regs\[5\]\[26\] _1975_ _2102_ VGND VGND VPWR VPWR _2108_ sky130_fd_sc_hd__mux2_1
XFILLER_0_85_473 VPWR VGND VPWR VGND sky130_ef_sc_hd__decap_12
X_2913_ net133 VGND VGND VPWR VPWR _1162_ sky130_fd_sc_hd__clkbuf_1
XFILLER_0_72_112 VPWR VGND VPWR VGND sky130_ef_sc_hd__decap_12
X_3893_ _2021_ _1805_ _2052_ _2058_ _1794_ VGND VGND VPWR VPWR _2059_ sky130_fd_sc_hd__a221o_1
XFILLER_0_72_156 VGND VGND VPWR VPWR sky130_fd_sc_hd__fill_2
X_2844_ _1122_ VGND VGND VPWR VPWR _0763_ sky130_fd_sc_hd__clkbuf_1
XFILLER_0_13_234 VGND VGND VPWR VPWR sky130_fd_sc_hd__fill_2
X_4514_ disp.digits\[7\] _2385_ _2402_ _2384_ VGND VGND VPWR VPWR _2403_ sky130_fd_sc_hd__a211o_1
X_2775_ RF0.regs\[4\]\[22\] _0839_ _0845_ RF0.regs\[12\]\[22\] VGND VGND VPWR VPWR
+ _1067_ sky130_fd_sc_hd__a22o_1
XFILLER_0_79_75 VGND VGND VPWR VPWR sky130_fd_sc_hd__fill_1
Xhold113 IM0.addr\[27\] VGND VGND VPWR VPWR net161 sky130_fd_sc_hd__dlygate4sd3_1
Xhold135 RF0.regs\[20\]\[0\] VGND VGND VPWR VPWR net183 sky130_fd_sc_hd__dlygate4sd3_1
Xhold124 IM0.addr\[24\] VGND VGND VPWR VPWR net172 sky130_fd_sc_hd__dlygate4sd3_1
XPHY_EDGE_ROW_44_Left_132 VGND VGND VPWR VPWR sky130_fd_sc_hd__decap_3
Xhold102 RF0.regs\[2\]\[24\] VGND VGND VPWR VPWR net150 sky130_fd_sc_hd__dlygate4sd3_1
XFILLER_0_13_278 VGND VGND VPWR VPWR sky130_fd_sc_hd__fill_2
Xhold157 IM0.addr\[31\] VGND VGND VPWR VPWR net205 sky130_fd_sc_hd__dlygate4sd3_1
Xhold146 RF0.regs\[6\]\[9\] VGND VGND VPWR VPWR net194 sky130_fd_sc_hd__dlygate4sd3_1
Xhold168 RF0.regs\[2\]\[11\] VGND VGND VPWR VPWR net216 sky130_fd_sc_hd__dlygate4sd3_1
X_4445_ RF0.regs\[25\]\[21\] _1992_ _2360_ VGND VGND VPWR VPWR _2361_ sky130_fd_sc_hd__mux2_1
X_4376_ _2324_ VGND VGND VPWR VPWR _0447_ sky130_fd_sc_hd__clkbuf_1
Xhold179 RF0.regs\[12\]\[21\] VGND VGND VPWR VPWR net227 sky130_fd_sc_hd__dlygate4sd3_1
XTAP_TAPCELL_ROW_69_811 VGND VPWR sky130_fd_sc_hd__tapvpwrvgnd_1
X_3327_ _1520_ _1511_ _1514_ _1522_ VGND VGND VPWR VPWR _1523_ sky130_fd_sc_hd__o22a_1
X_3258_ _1442_ _1445_ _1453_ VGND VGND VPWR VPWR _1454_ sky130_fd_sc_hd__and3_1
X_3189_ _1340_ _1384_ VGND VGND VPWR VPWR _1385_ sky130_fd_sc_hd__nor2_1
XPHY_EDGE_ROW_53_Left_141 VGND VGND VPWR VPWR sky130_fd_sc_hd__decap_3
XTAP_TAPCELL_ROW_24_402 VGND VPWR sky130_fd_sc_hd__tapvpwrvgnd_1
XPHY_EDGE_ROW_62_Left_150 VGND VGND VPWR VPWR sky130_fd_sc_hd__decap_3
XFILLER_0_63_167 VGND VGND VPWR VPWR sky130_fd_sc_hd__fill_1
XFILLER_0_5_3 VPWR VGND VPWR VGND sky130_ef_sc_hd__decap_12
XFILLER_0_24_15 VPWR VGND VPWR VGND sky130_ef_sc_hd__decap_12
Xclkbuf_2_0__f_clk clknet_0_clk VGND VGND VPWR VPWR clknet_2_0__leaf_clk sky130_fd_sc_hd__clkbuf_16
XFILLER_0_82_421 VPWR VGND VPWR VGND sky130_ef_sc_hd__decap_12
XFILLER_0_42_307 VGND VGND VPWR VPWR sky130_fd_sc_hd__fill_1
X_2560_ _0793_ _0787_ _0849_ _0851_ VGND VGND VPWR VPWR _0852_ sky130_fd_sc_hd__and4_1
X_2491_ IM0.addr\[31\] IM0.addr\[30\] IM0.addr\[29\] IM0.addr\[28\] VGND VGND VPWR
+ VPWR _0783_ sky130_fd_sc_hd__or4_4
XFILLER_0_10_204 VGND VGND VPWR VPWR sky130_fd_sc_hd__fill_1
X_4230_ net145 VGND VGND VPWR VPWR _2249_ sky130_fd_sc_hd__clkbuf_1
X_4161_ _2213_ VGND VGND VPWR VPWR _0551_ sky130_fd_sc_hd__clkbuf_1
X_4092_ _2178_ VGND VGND VPWR VPWR _0585_ sky130_fd_sc_hd__clkbuf_1
X_3112_ _1265_ _1304_ _1307_ VGND VGND VPWR VPWR _1308_ sky130_fd_sc_hd__nand3b_4
XTAP_TAPCELL_ROW_38_527 VGND VPWR sky130_fd_sc_hd__tapvpwrvgnd_1
X_3043_ _1238_ VGND VGND VPWR VPWR _1239_ sky130_fd_sc_hd__buf_4
X_4994_ _2488_ VGND VGND VPWR VPWR _0377_ sky130_fd_sc_hd__inv_2
X_3945_ _2098_ VGND VGND VPWR VPWR _0651_ sky130_fd_sc_hd__clkbuf_1
XFILLER_0_18_304 VGND VGND VPWR VPWR sky130_fd_sc_hd__decap_4
XFILLER_0_73_443 VGND VGND VPWR VPWR sky130_fd_sc_hd__fill_2
XFILLER_0_45_134 VPWR VGND VPWR VGND sky130_ef_sc_hd__decap_12
X_3876_ _2036_ _2041_ VGND VGND VPWR VPWR _2042_ sky130_fd_sc_hd__nor2_1
XFILLER_0_83_3 VPWR VGND VPWR VGND sky130_ef_sc_hd__decap_12
X_2827_ _1108_ net139 VGND VGND VPWR VPWR _1113_ sky130_fd_sc_hd__and2_1
XFILLER_0_45_189 VGND VGND VPWR VPWR sky130_fd_sc_hd__decap_6
X_2758_ RF0.regs\[15\]\[14\] _0853_ VGND VGND VPWR VPWR _1050_ sky130_fd_sc_hd__and2_1
X_4428_ RF0.regs\[25\]\[29\] _1962_ _2349_ VGND VGND VPWR VPWR _2352_ sky130_fd_sc_hd__mux2_1
X_2689_ RF0.regs\[5\]\[9\] _0876_ _0879_ RF0.regs\[2\]\[9\] _0980_ VGND VGND VPWR
+ VPWR _0981_ sky130_fd_sc_hd__a221o_1
X_4359_ net253 _1957_ _2314_ VGND VGND VPWR VPWR _2316_ sky130_fd_sc_hd__mux2_1
XTAP_TAPCELL_ROW_72_839 VGND VPWR sky130_fd_sc_hd__tapvpwrvgnd_1
XTAP_TAPCELL_ROW_1_196 VGND VPWR sky130_fd_sc_hd__tapvpwrvgnd_1
XFILLER_0_68_248 VGND VGND VPWR VPWR sky130_fd_sc_hd__decap_4
XFILLER_0_36_134 VGND VGND VPWR VPWR sky130_fd_sc_hd__fill_1
XFILLER_0_64_421 VGND VGND VPWR VPWR sky130_fd_sc_hd__fill_2
XFILLER_0_24_307 VGND VGND VPWR VPWR sky130_fd_sc_hd__fill_1
XTAP_TAPCELL_ROW_9_274 VGND VPWR sky130_fd_sc_hd__tapvpwrvgnd_1
XFILLER_0_19_15 VPWR VGND VPWR VGND sky130_ef_sc_hd__decap_12
XFILLER_0_35_69 VGND VGND VPWR VPWR sky130_fd_sc_hd__decap_3
XTAP_TAPCELL_ROW_35_508 VGND VPWR sky130_fd_sc_hd__tapvpwrvgnd_1
XFILLER_0_51_13 VGND VGND VPWR VPWR sky130_fd_sc_hd__fill_2
XTAP_TAPCELL_ROW_43_574 VGND VPWR sky130_fd_sc_hd__tapvpwrvgnd_1
X_3730_ _1787_ VGND VGND VPWR VPWR _1916_ sky130_fd_sc_hd__inv_2
XFILLER_0_82_262 VGND VGND VPWR VPWR sky130_fd_sc_hd__decap_8
XFILLER_0_82_251 VGND VGND VPWR VPWR sky130_fd_sc_hd__fill_1
XFILLER_0_15_307 VGND VGND VPWR VPWR sky130_fd_sc_hd__decap_4
XFILLER_0_55_476 VGND VGND VPWR VPWR sky130_fd_sc_hd__fill_2
X_3661_ RF0.regs\[7\]\[5\] _1243_ VGND VGND VPWR VPWR _1847_ sky130_fd_sc_hd__and2_1
X_5400_ clknet_leaf_43_clk _0776_ _0392_ VGND VGND VPWR VPWR IM0.addr\[31\] sky130_fd_sc_hd__dfrtp_1
Xclkload11 clknet_leaf_45_clk VGND VGND VPWR VPWR clkload11/X sky130_fd_sc_hd__clkbuf_4
XFILLER_0_23_340 VGND VGND VPWR VPWR sky130_fd_sc_hd__fill_2
Xclkload22 clknet_leaf_27_clk VGND VGND VPWR VPWR clkload22/Y sky130_fd_sc_hd__inv_8
Xclkload33 clknet_leaf_15_clk VGND VGND VPWR VPWR clkload33/Y sky130_fd_sc_hd__inv_6
X_2612_ RF0.regs\[5\]\[17\] _0876_ _0880_ RF0.regs\[2\]\[17\] _0903_ VGND VGND VPWR
+ VPWR _0904_ sky130_fd_sc_hd__a221o_1
X_3592_ RF0.regs\[6\]\[11\] _1231_ _1227_ RF0.regs\[15\]\[11\] _1782_ VGND VGND VPWR
+ VPWR _1783_ sky130_fd_sc_hd__a221o_1
XFILLER_0_23_362 VGND VGND VPWR VPWR sky130_fd_sc_hd__decap_8
X_2543_ _0834_ VGND VGND VPWR VPWR _0835_ sky130_fd_sc_hd__clkbuf_4
X_5331_ clknet_leaf_6_clk _0707_ _0323_ VGND VGND VPWR VPWR RF0.regs\[2\]\[26\] sky130_fd_sc_hd__dfrtp_1
X_5262_ clknet_leaf_11_clk _0638_ _0254_ VGND VGND VPWR VPWR RF0.regs\[5\]\[21\] sky130_fd_sc_hd__dfrtp_1
XFILLER_0_55_7 VGND VGND VPWR VPWR sky130_fd_sc_hd__decap_4
X_5193_ clknet_leaf_18_clk _0569_ _0185_ VGND VGND VPWR VPWR RF0.regs\[7\]\[16\] sky130_fd_sc_hd__dfrtp_1
X_4213_ _2240_ VGND VGND VPWR VPWR _0526_ sky130_fd_sc_hd__clkbuf_1
X_4144_ _2204_ VGND VGND VPWR VPWR _0559_ sky130_fd_sc_hd__clkbuf_1
XFILLER_0_78_513 VGND VGND VPWR VPWR sky130_fd_sc_hd__decap_4
X_4075_ _2167_ VGND VGND VPWR VPWR _0590_ sky130_fd_sc_hd__clkbuf_1
X_3026_ _1221_ VGND VGND VPWR VPWR _1222_ sky130_fd_sc_hd__clkbuf_4
X_4977_ _2486_ VGND VGND VPWR VPWR _0362_ sky130_fd_sc_hd__inv_2
Xclkload5 clknet_leaf_39_clk VGND VGND VPWR VPWR clkload5/Y sky130_fd_sc_hd__clkinv_8
X_3928_ RF0.regs\[4\]\[7\] _2086_ _2073_ VGND VGND VPWR VPWR _2087_ sky130_fd_sc_hd__mux2_1
X_3859_ _2027_ VGND VGND VPWR VPWR net29 sky130_fd_sc_hd__buf_1
XTAP_TAPCELL_ROW_6_244 VGND VPWR sky130_fd_sc_hd__tapvpwrvgnd_1
XTAP_TAPCELL_ROW_85_953 VGND VPWR sky130_fd_sc_hd__tapvpwrvgnd_1
XTAP_TAPCELL_ROW_57_699 VGND VPWR sky130_fd_sc_hd__tapvpwrvgnd_1
XFILLER_0_49_281 VGND VGND VPWR VPWR sky130_fd_sc_hd__fill_2
XFILLER_0_21_27 VPWR VGND VPWR VGND sky130_ef_sc_hd__decap_12
XFILLER_0_64_251 VGND VGND VPWR VPWR sky130_fd_sc_hd__fill_1
XFILLER_0_37_498 VGND VGND VPWR VPWR sky130_fd_sc_hd__fill_1
XFILLER_0_64_295 VGND VGND VPWR VPWR sky130_fd_sc_hd__fill_1
XFILLER_0_20_376 VGND VGND VPWR VPWR sky130_fd_sc_hd__fill_1
XFILLER_0_46_79 VGND VGND VPWR VPWR sky130_fd_sc_hd__decap_4
XTAP_TAPCELL_ROW_48_622 VGND VPWR sky130_fd_sc_hd__tapvpwrvgnd_1
XFILLER_0_87_321 VPWR VGND VPWR VGND sky130_ef_sc_hd__decap_12
XFILLER_0_1_15 VPWR VGND VPWR VGND sky130_ef_sc_hd__decap_12
XFILLER_0_75_505 VPWR VGND VPWR VGND sky130_ef_sc_hd__decap_12
X_4900_ _2477_ VGND VGND VPWR VPWR _0294_ sky130_fd_sc_hd__inv_2
XFILLER_0_62_23 VGND VGND VPWR VPWR sky130_fd_sc_hd__decap_4
XFILLER_0_87_365 VPWR VGND VPWR VGND sky130_ef_sc_hd__decap_12
X_4831_ _2470_ VGND VGND VPWR VPWR _0232_ sky130_fd_sc_hd__inv_2
XFILLER_0_28_421 VPWR VGND VPWR VGND sky130_ef_sc_hd__decap_12
X_4762_ _2463_ VGND VGND VPWR VPWR _0170_ sky130_fd_sc_hd__inv_2
X_3713_ _1007_ _1852_ _1853_ _1859_ VGND VGND VPWR VPWR _1899_ sky130_fd_sc_hd__and4_1
X_4693_ _2454_ VGND VGND VPWR VPWR _0110_ sky130_fd_sc_hd__inv_2
XFILLER_0_43_435 VGND VGND VPWR VPWR sky130_fd_sc_hd__fill_1
XFILLER_0_15_148 VGND VGND VPWR VPWR sky130_fd_sc_hd__decap_6
X_3644_ _1425_ _1427_ _1830_ VGND VGND VPWR VPWR _1831_ sky130_fd_sc_hd__and3_1
XFILLER_0_70_276 VPWR VGND VPWR VGND sky130_ef_sc_hd__decap_12
XTAP_TAPCELL_ROW_11_290 VGND VPWR sky130_fd_sc_hd__tapvpwrvgnd_1
XFILLER_0_23_181 VPWR VGND VPWR VGND sky130_ef_sc_hd__decap_12
X_3575_ _1382_ _1739_ VGND VGND VPWR VPWR _1767_ sky130_fd_sc_hd__or2_1
XFILLER_0_87_53 VGND VGND VPWR VPWR sky130_fd_sc_hd__decap_3
X_2526_ _0800_ _0803_ VGND VGND VPWR VPWR _0818_ sky130_fd_sc_hd__or2_2
X_5314_ clknet_leaf_38_clk _0690_ _0306_ VGND VGND VPWR VPWR RF0.regs\[2\]\[9\] sky130_fd_sc_hd__dfrtp_1
XFILLER_0_87_97 VPWR VGND VPWR VGND sky130_ef_sc_hd__decap_12
X_5245_ clknet_leaf_34_clk _0621_ _0237_ VGND VGND VPWR VPWR RF0.regs\[5\]\[4\] sky130_fd_sc_hd__dfrtp_1
Xhold28 RF0.regs\[7\]\[4\] VGND VGND VPWR VPWR net76 sky130_fd_sc_hd__dlygate4sd3_1
XFILLER_0_46_3 VPWR VGND VPWR VGND sky130_ef_sc_hd__decap_12
XTAP_TAPCELL_ROW_3_214 VGND VPWR sky130_fd_sc_hd__tapvpwrvgnd_1
X_5176_ clknet_leaf_2_clk _0552_ _0168_ VGND VGND VPWR VPWR RF0.regs\[10\]\[31\] sky130_fd_sc_hd__dfrtp_1
Xhold39 RF0.regs\[12\]\[15\] VGND VGND VPWR VPWR net87 sky130_fd_sc_hd__dlygate4sd3_1
X_4127_ net93 VGND VGND VPWR VPWR _2196_ sky130_fd_sc_hd__clkbuf_1
X_4058_ _2158_ VGND VGND VPWR VPWR _0598_ sky130_fd_sc_hd__clkbuf_1
XTAP_TAPCELL_ROW_82_923 VGND VPWR sky130_fd_sc_hd__tapvpwrvgnd_1
XFILLER_0_78_354 VGND VGND VPWR VPWR sky130_fd_sc_hd__fill_1
X_3009_ RF0.regs\[2\]\[4\] VGND VGND VPWR VPWR _1210_ sky130_fd_sc_hd__clkbuf_1
XFILLER_0_66_516 VGND VGND VPWR VPWR sky130_fd_sc_hd__fill_1
XFILLER_0_19_443 VGND VGND VPWR VPWR sky130_fd_sc_hd__decap_4
XFILLER_0_19_476 VGND VGND VPWR VPWR sky130_fd_sc_hd__fill_1
XFILLER_0_46_251 VGND VGND VPWR VPWR sky130_fd_sc_hd__fill_1
XFILLER_0_16_27 VGND VGND VPWR VPWR sky130_fd_sc_hd__fill_1
XFILLER_0_69_387 VGND VGND VPWR VPWR sky130_fd_sc_hd__fill_2
XTAP_TAPCELL_ROW_17_338 VGND VPWR sky130_fd_sc_hd__tapvpwrvgnd_1
XFILLER_0_57_505 VGND VGND VPWR VPWR sky130_fd_sc_hd__decap_8
XFILLER_0_32_15 VGND VGND VPWR VPWR sky130_fd_sc_hd__decap_4
XFILLER_0_84_368 VPWR VGND VPWR VGND sky130_ef_sc_hd__decap_12
XFILLER_0_25_446 VGND VGND VPWR VPWR sky130_fd_sc_hd__fill_2
XFILLER_0_40_405 VGND VGND VPWR VPWR sky130_fd_sc_hd__decap_3
X_3360_ _1250_ net26 VGND VGND VPWR VPWR _1555_ sky130_fd_sc_hd__xnor2_1
X_5030_ clknet_leaf_19_clk _0406_ _0022_ VGND VGND VPWR VPWR RF0.regs\[25\]\[13\]
+ sky130_fd_sc_hd__dfrtp_1
X_3291_ RF0.regs\[25\]\[18\] _1252_ _1254_ RF0.regs\[12\]\[18\] _1486_ VGND VGND VPWR
+ VPWR _1487_ sky130_fd_sc_hd__a221o_1
XFILLER_0_73_55 VGND VGND VPWR VPWR sky130_fd_sc_hd__fill_1
XFILLER_0_73_88 VGND VGND VPWR VPWR sky130_fd_sc_hd__decap_3
Xclkbuf_leaf_45_clk clknet_2_0__leaf_clk VGND VGND VPWR VPWR clknet_leaf_45_clk sky130_fd_sc_hd__clkbuf_8
XFILLER_0_48_516 VGND VGND VPWR VPWR sky130_fd_sc_hd__fill_1
X_4814_ _2468_ VGND VGND VPWR VPWR _0217_ sky130_fd_sc_hd__inv_2
XFILLER_0_63_508 VGND VGND VPWR VPWR sky130_fd_sc_hd__decap_8
XFILLER_0_28_273 VGND VGND VPWR VPWR sky130_fd_sc_hd__fill_1
XFILLER_0_43_210 VGND VGND VPWR VPWR sky130_fd_sc_hd__decap_6
X_4745_ _2460_ VGND VGND VPWR VPWR _0156_ sky130_fd_sc_hd__inv_2
XFILLER_0_28_295 VGND VGND VPWR VPWR sky130_fd_sc_hd__decap_3
X_4676_ _2450_ VGND VGND VPWR VPWR _0097_ sky130_fd_sc_hd__inv_2
X_3627_ RF0.regs\[4\]\[8\] _1238_ VGND VGND VPWR VPWR _1815_ sky130_fd_sc_hd__and2_1
Xoutput29 net29 VGND VGND VPWR VPWR Result[5] sky130_fd_sc_hd__buf_2
X_3558_ _0797_ _1741_ _1749_ VGND VGND VPWR VPWR _1750_ sky130_fd_sc_hd__or3_1
Xoutput18 net18 VGND VGND VPWR VPWR Result[24] sky130_fd_sc_hd__buf_2
X_2509_ _0787_ _0793_ VGND VGND VPWR VPWR _0801_ sky130_fd_sc_hd__nand2_4
X_3489_ _1482_ _1485_ VGND VGND VPWR VPWR _1682_ sky130_fd_sc_hd__nor2_1
X_5228_ clknet_leaf_12_clk _0604_ _0220_ VGND VGND VPWR VPWR RF0.regs\[6\]\[19\] sky130_fd_sc_hd__dfrtp_1
XTAP_TAPCELL_ROW_59_717 VGND VPWR sky130_fd_sc_hd__tapvpwrvgnd_1
X_5159_ clknet_leaf_20_clk _0535_ _0151_ VGND VGND VPWR VPWR RF0.regs\[10\]\[14\]
+ sky130_fd_sc_hd__dfrtp_2
XTAP_TAPCELL_ROW_67_794 VGND VPWR sky130_fd_sc_hd__tapvpwrvgnd_1
Xclkbuf_leaf_36_clk clknet_2_2__leaf_clk VGND VGND VPWR VPWR clknet_leaf_36_clk sky130_fd_sc_hd__clkbuf_8
XFILLER_0_39_505 VGND VGND VPWR VPWR sky130_fd_sc_hd__decap_3
XTAP_TAPCELL_ROW_14_319 VGND VPWR sky130_fd_sc_hd__tapvpwrvgnd_1
XFILLER_0_81_305 VPWR VGND VPWR VGND sky130_ef_sc_hd__decap_12
XTAP_TAPCELL_ROW_22_385 VGND VPWR sky130_fd_sc_hd__tapvpwrvgnd_1
XFILLER_0_34_232 VPWR VGND VPWR VGND sky130_ef_sc_hd__decap_12
XFILLER_0_27_15 VPWR VGND VPWR VGND sky130_ef_sc_hd__decap_12
Xclkbuf_leaf_27_clk clknet_2_2__leaf_clk VGND VGND VPWR VPWR clknet_leaf_27_clk sky130_fd_sc_hd__clkbuf_8
XFILLER_0_84_121 VPWR VGND VPWR VGND sky130_ef_sc_hd__decap_12
XFILLER_0_57_335 VGND VGND VPWR VPWR sky130_fd_sc_hd__fill_1
X_2860_ _1130_ VGND VGND VPWR VPWR _0755_ sky130_fd_sc_hd__clkbuf_1
X_2791_ _1080_ _1082_ _0847_ _0890_ VGND VGND VPWR VPWR _1083_ sky130_fd_sc_hd__o2bb2a_1
X_4530_ _2390_ _2397_ VGND VGND VPWR VPWR _2415_ sky130_fd_sc_hd__nor2_1
XFILLER_0_80_393 VPWR VGND VPWR VGND sky130_ef_sc_hd__decap_12
X_4461_ RF0.regs\[25\]\[13\] _2066_ _2360_ VGND VGND VPWR VPWR _2369_ sky130_fd_sc_hd__mux2_1
XFILLER_0_13_449 VGND VGND VPWR VPWR sky130_fd_sc_hd__decap_4
XFILLER_0_7_69 VPWR VGND VPWR VGND sky130_ef_sc_hd__decap_12
X_3412_ _1602_ _1605_ VGND VGND VPWR VPWR _1606_ sky130_fd_sc_hd__xnor2_1
X_4392_ net171 _2063_ _2325_ VGND VGND VPWR VPWR _2333_ sky130_fd_sc_hd__mux2_1
XFILLER_0_0_365 VPWR VGND VPWR VGND sky130_ef_sc_hd__decap_12
X_3343_ _0999_ _1536_ VGND VGND VPWR VPWR _1539_ sky130_fd_sc_hd__and2_1
X_3274_ RF0.regs\[4\]\[16\] _0836_ _1252_ RF0.regs\[25\]\[16\] VGND VGND VPWR VPWR
+ _1470_ sky130_fd_sc_hd__a22o_1
XFILLER_0_84_65 VPWR VGND VPWR VGND sky130_ef_sc_hd__decap_12
X_5013_ clknet_leaf_32_clk _0003_ VGND VGND VPWR VPWR net41 sky130_fd_sc_hd__dfxtp_1
Xclkbuf_leaf_18_clk clknet_2_3__leaf_clk VGND VGND VPWR VPWR clknet_leaf_18_clk sky130_fd_sc_hd__clkbuf_8
XPHY_EDGE_ROW_5_Right_5 VGND VGND VPWR VPWR sky130_fd_sc_hd__decap_3
XTAP_TAPCELL_ROW_64_764 VGND VPWR sky130_fd_sc_hd__tapvpwrvgnd_1
X_2989_ net164 VGND VGND VPWR VPWR _1200_ sky130_fd_sc_hd__clkbuf_1
XFILLER_0_71_360 VGND VGND VPWR VPWR sky130_fd_sc_hd__fill_1
X_4728_ _2458_ VGND VGND VPWR VPWR _0141_ sky130_fd_sc_hd__inv_2
X_4659_ _2449_ VGND VGND VPWR VPWR _0081_ sky130_fd_sc_hd__inv_2
XFILLER_0_12_471 VGND VGND VPWR VPWR sky130_fd_sc_hd__fill_1
XFILLER_0_86_419 VGND VGND VPWR VPWR sky130_fd_sc_hd__fill_1
XTAP_TAPCELL_ROW_27_433 VGND VPWR sky130_fd_sc_hd__tapvpwrvgnd_1
XFILLER_0_13_39 VPWR VGND VPWR VGND sky130_ef_sc_hd__decap_12
XFILLER_0_39_357 VGND VGND VPWR VPWR sky130_fd_sc_hd__decap_6
XFILLER_0_39_368 VPWR VGND VPWR VGND sky130_ef_sc_hd__decap_12
XFILLER_0_81_113 VGND VGND VPWR VPWR sky130_fd_sc_hd__fill_1
XFILLER_0_22_268 VGND VGND VPWR VPWR sky130_fd_sc_hd__fill_2
XFILLER_0_38_14 VGND VGND VPWR VPWR sky130_fd_sc_hd__fill_2
XTAP_TAPCELL_ROW_78_889 VGND VPWR sky130_fd_sc_hd__tapvpwrvgnd_1
XFILLER_0_77_419 VGND VGND VPWR VPWR sky130_fd_sc_hd__decap_4
XFILLER_0_54_68 VGND VGND VPWR VPWR sky130_fd_sc_hd__fill_1
X_3961_ _2107_ VGND VGND VPWR VPWR _0644_ sky130_fd_sc_hd__clkbuf_1
XFILLER_0_85_441 VGND VGND VPWR VPWR sky130_fd_sc_hd__decap_6
X_2912_ _1161_ VGND VGND VPWR VPWR _0734_ sky130_fd_sc_hd__clkbuf_1
XTAP_TAPCELL_ROW_61_734 VGND VPWR sky130_fd_sc_hd__tapvpwrvgnd_1
XFILLER_0_85_485 VPWR VGND VPWR VGND sky130_ef_sc_hd__decap_12
XFILLER_0_72_102 VGND VGND VPWR VPWR sky130_fd_sc_hd__fill_1
X_3892_ _2021_ _2056_ _2057_ VGND VGND VPWR VPWR _2058_ sky130_fd_sc_hd__and3_1
XFILLER_0_72_124 VGND VGND VPWR VPWR sky130_fd_sc_hd__decap_3
X_2843_ _1118_ net177 VGND VGND VPWR VPWR _1122_ sky130_fd_sc_hd__and2_1
XFILLER_0_72_168 VPWR VGND VPWR VGND sky130_ef_sc_hd__decap_12
X_2774_ RF0.regs\[2\]\[22\] _0880_ _1064_ _1065_ VGND VGND VPWR VPWR _1066_ sky130_fd_sc_hd__a211oi_1
X_4513_ disp.digits\[11\] _2386_ _2387_ disp.digits\[15\] VGND VGND VPWR VPWR _2402_
+ sky130_fd_sc_hd__a22o_1
XFILLER_0_53_393 VGND VGND VPWR VPWR sky130_fd_sc_hd__decap_8
Xhold103 RF0.regs\[7\]\[16\] VGND VGND VPWR VPWR net151 sky130_fd_sc_hd__dlygate4sd3_1
Xhold114 IM0.addr\[14\] VGND VGND VPWR VPWR net162 sky130_fd_sc_hd__dlygate4sd3_1
Xhold125 IM0.addr\[13\] VGND VGND VPWR VPWR net173 sky130_fd_sc_hd__dlygate4sd3_1
Xhold147 RF0.regs\[20\]\[16\] VGND VGND VPWR VPWR net195 sky130_fd_sc_hd__dlygate4sd3_1
Xhold136 IM0.addr\[29\] VGND VGND VPWR VPWR net184 sky130_fd_sc_hd__dlygate4sd3_1
Xhold158 IM0.addr\[10\] VGND VGND VPWR VPWR net206 sky130_fd_sc_hd__dlygate4sd3_1
Xclkbuf_leaf_7_clk clknet_2_1__leaf_clk VGND VGND VPWR VPWR clknet_leaf_7_clk sky130_fd_sc_hd__clkbuf_8
X_4444_ _0817_ VGND VGND VPWR VPWR _2360_ sky130_fd_sc_hd__buf_4
X_4375_ net215 _1988_ _2314_ VGND VGND VPWR VPWR _2324_ sky130_fd_sc_hd__mux2_1
Xhold169 RF0.regs\[20\]\[8\] VGND VGND VPWR VPWR net217 sky130_fd_sc_hd__dlygate4sd3_1
XTAP_TAPCELL_ROW_69_812 VGND VPWR sky130_fd_sc_hd__tapvpwrvgnd_1
XFILLER_0_0_195 VGND VGND VPWR VPWR sky130_fd_sc_hd__fill_1
X_3326_ RF0.regs\[4\]\[21\] _0837_ _1138_ RF0.regs\[12\]\[21\] _1521_ VGND VGND VPWR
+ VPWR _1522_ sky130_fd_sc_hd__a221oi_1
X_3257_ _1451_ _1452_ VGND VGND VPWR VPWR _1453_ sky130_fd_sc_hd__nor2_1
X_3188_ net65 _1293_ _1383_ VGND VGND VPWR VPWR _1384_ sky130_fd_sc_hd__and3_1
XTAP_TAPCELL_ROW_24_403 VGND VPWR sky130_fd_sc_hd__tapvpwrvgnd_1
XFILLER_0_63_102 VGND VGND VPWR VPWR sky130_fd_sc_hd__decap_8
XFILLER_0_63_113 VGND VGND VPWR VPWR sky130_fd_sc_hd__decap_4
XFILLER_0_36_349 VGND VGND VPWR VPWR sky130_fd_sc_hd__fill_2
XTAP_TAPCELL_ROW_32_480 VGND VPWR sky130_fd_sc_hd__tapvpwrvgnd_1
XFILLER_0_44_371 VPWR VGND VPWR VGND sky130_ef_sc_hd__decap_12
XFILLER_0_24_27 VGND VGND VPWR VPWR sky130_fd_sc_hd__fill_1
XFILLER_0_39_110 VGND VGND VPWR VPWR sky130_fd_sc_hd__fill_2
XFILLER_0_82_433 VPWR VGND VPWR VGND sky130_ef_sc_hd__decap_12
XFILLER_0_54_146 VGND VGND VPWR VPWR sky130_fd_sc_hd__decap_4
XFILLER_0_82_477 VPWR VGND VPWR VGND sky130_ef_sc_hd__decap_12
XFILLER_0_40_37 VGND VGND VPWR VPWR sky130_fd_sc_hd__fill_2
XFILLER_0_40_48 VGND VGND VPWR VPWR sky130_fd_sc_hd__fill_1
XFILLER_0_35_393 VGND VGND VPWR VPWR sky130_fd_sc_hd__fill_1
X_2490_ IM0.addr\[24\] IM0.addr\[26\] IM0.addr\[25\] IM0.addr\[27\] VGND VGND VPWR
+ VPWR _0782_ sky130_fd_sc_hd__or4_1
XFILLER_0_4_15 VPWR VGND VPWR VGND sky130_ef_sc_hd__decap_12
X_4160_ RF0.regs\[10\]\[30\] _1957_ _2211_ VGND VGND VPWR VPWR _2213_ sky130_fd_sc_hd__mux2_1
X_3111_ _1257_ _1306_ VGND VGND VPWR VPWR _1307_ sky130_fd_sc_hd__nand2_1
X_4091_ _2177_ net255 _2137_ VGND VGND VPWR VPWR _2178_ sky130_fd_sc_hd__mux2_1
XTAP_TAPCELL_ROW_38_528 VGND VPWR sky130_fd_sc_hd__tapvpwrvgnd_1
X_3042_ _1237_ VGND VGND VPWR VPWR _1238_ sky130_fd_sc_hd__clkbuf_4
XFILLER_0_81_55 VGND VGND VPWR VPWR sky130_fd_sc_hd__fill_1
X_4993_ _2435_ VGND VGND VPWR VPWR _2488_ sky130_fd_sc_hd__buf_4
XFILLER_0_58_441 VGND VGND VPWR VPWR sky130_fd_sc_hd__fill_2
X_3944_ RF0.regs\[4\]\[2\] _2097_ _2073_ VGND VGND VPWR VPWR _2098_ sky130_fd_sc_hd__mux2_1
X_3875_ _2037_ _2040_ _1893_ VGND VGND VPWR VPWR _2041_ sky130_fd_sc_hd__o21ba_1
X_2826_ _1112_ VGND VGND VPWR VPWR _0771_ sky130_fd_sc_hd__clkbuf_1
XFILLER_0_5_221 VGND VGND VPWR VPWR sky130_fd_sc_hd__decap_3
XFILLER_0_45_146 VPWR VGND VPWR VGND sky130_ef_sc_hd__decap_12
XFILLER_0_5_254 VPWR VGND VPWR VGND sky130_ef_sc_hd__decap_12
XFILLER_0_30_81 VGND VGND VPWR VPWR sky130_fd_sc_hd__decap_3
X_2757_ _1035_ _1037_ _1040_ _1042_ _1048_ VGND VGND VPWR VPWR _1049_ sky130_fd_sc_hd__a221o_1
XFILLER_0_76_3 VPWR VGND VPWR VGND sky130_ef_sc_hd__decap_12
X_2688_ RF0.regs\[15\]\[9\] _0853_ VGND VGND VPWR VPWR _0980_ sky130_fd_sc_hd__and2_1
X_4427_ _2351_ VGND VGND VPWR VPWR _0423_ sky130_fd_sc_hd__clkbuf_1
X_4358_ _2315_ VGND VGND VPWR VPWR _0456_ sky130_fd_sc_hd__clkbuf_1
X_4289_ _2278_ VGND VGND VPWR VPWR _2279_ sky130_fd_sc_hd__buf_4
X_3309_ RF0.regs\[4\]\[22\] _0837_ _0812_ RF0.regs\[10\]\[22\] VGND VGND VPWR VPWR
+ _1505_ sky130_fd_sc_hd__a22o_1
XTAP_TAPCELL_ROW_1_197 VGND VPWR sky130_fd_sc_hd__tapvpwrvgnd_1
XFILLER_0_24_319 VPWR VGND VPWR VGND sky130_ef_sc_hd__decap_12
XFILLER_0_17_371 VGND VGND VPWR VPWR sky130_fd_sc_hd__decap_4
XFILLER_0_10_29 VPWR VGND VPWR VGND sky130_ef_sc_hd__decap_12
XFILLER_0_20_514 VGND VGND VPWR VPWR sky130_fd_sc_hd__decap_3
XFILLER_0_19_27 VPWR VGND VPWR VGND sky130_ef_sc_hd__decap_12
XFILLER_0_27_113 VPWR VGND VPWR VGND sky130_ef_sc_hd__decap_12
XTAP_TAPCELL_ROW_43_575 VGND VPWR sky130_fd_sc_hd__tapvpwrvgnd_1
XFILLER_0_55_422 VGND VGND VPWR VPWR sky130_fd_sc_hd__decap_4
XFILLER_0_55_466 VGND VGND VPWR VPWR sky130_fd_sc_hd__fill_1
X_3660_ RF0.regs\[20\]\[5\] _1221_ _1227_ RF0.regs\[15\]\[5\] _1845_ VGND VGND VPWR
+ VPWR _1846_ sky130_fd_sc_hd__a221o_1
XFILLER_0_27_179 VPWR VGND VPWR VGND sky130_ef_sc_hd__decap_12
Xclkload23 clknet_leaf_28_clk VGND VGND VPWR VPWR clkload23/Y sky130_fd_sc_hd__bufinv_16
Xclkload12 clknet_leaf_4_clk VGND VGND VPWR VPWR clkload12/Y sky130_fd_sc_hd__clkinv_8
X_3591_ RF0.regs\[5\]\[11\] _0961_ _1139_ VGND VGND VPWR VPWR _1782_ sky130_fd_sc_hd__and3_1
X_2611_ RF0.regs\[10\]\[17\] _0884_ VGND VGND VPWR VPWR _0903_ sky130_fd_sc_hd__and2_1
Xclkload34 clknet_leaf_16_clk VGND VGND VPWR VPWR clkload34/Y sky130_fd_sc_hd__clkinv_2
X_2542_ _0831_ _0833_ VGND VGND VPWR VPWR _0834_ sky130_fd_sc_hd__nor2b_2
X_5330_ clknet_leaf_4_clk _0706_ _0322_ VGND VGND VPWR VPWR RF0.regs\[2\]\[25\] sky130_fd_sc_hd__dfrtp_1
X_5261_ clknet_leaf_13_clk _0637_ _0253_ VGND VGND VPWR VPWR RF0.regs\[5\]\[20\] sky130_fd_sc_hd__dfrtp_1
XFILLER_0_23_396 VGND VGND VPWR VPWR sky130_fd_sc_hd__decap_8
XPHY_EDGE_ROW_81_Left_169 VGND VGND VPWR VPWR sky130_fd_sc_hd__decap_3
X_4212_ RF0.regs\[10\]\[5\] _2090_ _2233_ VGND VGND VPWR VPWR _2240_ sky130_fd_sc_hd__mux2_1
X_5192_ clknet_leaf_19_clk _0568_ _0184_ VGND VGND VPWR VPWR RF0.regs\[7\]\[15\] sky130_fd_sc_hd__dfrtp_1
XFILLER_0_48_7 VGND VGND VPWR VPWR sky130_fd_sc_hd__decap_4
X_4143_ net111 VGND VGND VPWR VPWR _2204_ sky130_fd_sc_hd__clkbuf_1
X_4074_ _2090_ RF0.regs\[6\]\[5\] _2160_ VGND VGND VPWR VPWR _2167_ sky130_fd_sc_hd__mux2_1
X_3025_ _1220_ VGND VGND VPWR VPWR _1221_ sky130_fd_sc_hd__buf_4
XFILLER_0_65_208 VGND VGND VPWR VPWR sky130_fd_sc_hd__decap_4
XFILLER_0_18_102 VGND VGND VPWR VPWR sky130_fd_sc_hd__decap_4
X_4976_ _2486_ VGND VGND VPWR VPWR _0361_ sky130_fd_sc_hd__inv_2
X_3927_ _2049_ _2085_ VGND VGND VPWR VPWR _2086_ sky130_fd_sc_hd__and2b_2
XFILLER_0_18_179 VGND VGND VPWR VPWR sky130_fd_sc_hd__decap_4
Xclkload6 clknet_leaf_40_clk VGND VGND VPWR VPWR clkload6/Y sky130_fd_sc_hd__inv_6
X_3858_ _1008_ _1902_ _1903_ VGND VGND VPWR VPWR _2027_ sky130_fd_sc_hd__and3_1
XFILLER_0_33_116 VGND VGND VPWR VPWR sky130_fd_sc_hd__decap_8
XFILLER_0_46_488 VPWR VGND VPWR VGND sky130_ef_sc_hd__decap_12
XFILLER_0_33_138 VPWR VGND VPWR VGND sky130_ef_sc_hd__decap_12
X_2809_ _1084_ _1091_ _1098_ _1100_ VGND VGND VPWR VPWR _1101_ sky130_fd_sc_hd__and4_1
X_3789_ _1967_ _1970_ VGND VGND VPWR VPWR _1971_ sky130_fd_sc_hd__xor2_4
XFILLER_0_61_447 VGND VGND VPWR VPWR sky130_fd_sc_hd__fill_1
XTAP_TAPCELL_ROW_6_245 VGND VPWR sky130_fd_sc_hd__tapvpwrvgnd_1
XTAP_TAPCELL_ROW_85_954 VGND VPWR sky130_fd_sc_hd__tapvpwrvgnd_1
XFILLER_0_69_503 VGND VGND VPWR VPWR sky130_fd_sc_hd__fill_1
XFILLER_0_49_293 VGND VGND VPWR VPWR sky130_fd_sc_hd__fill_2
XFILLER_0_37_444 VGND VGND VPWR VPWR sky130_fd_sc_hd__decap_4
XFILLER_0_9_390 VGND VGND VPWR VPWR sky130_fd_sc_hd__fill_2
XFILLER_0_21_39 VPWR VGND VPWR VGND sky130_ef_sc_hd__decap_12
XTAP_TAPCELL_ROW_40_545 VGND VPWR sky130_fd_sc_hd__tapvpwrvgnd_1
XFILLER_0_24_138 VGND VGND VPWR VPWR sky130_fd_sc_hd__fill_2
XTAP_TAPCELL_ROW_48_623 VGND VPWR sky130_fd_sc_hd__tapvpwrvgnd_1
XFILLER_0_1_27 VPWR VGND VPWR VGND sky130_ef_sc_hd__decap_12
XFILLER_0_87_333 VGND VGND VPWR VPWR sky130_fd_sc_hd__decap_3
XFILLER_0_87_377 VPWR VGND VPWR VGND sky130_ef_sc_hd__decap_12
X_4830_ _2470_ VGND VGND VPWR VPWR _0231_ sky130_fd_sc_hd__inv_2
XFILLER_0_28_411 VGND VGND VPWR VPWR sky130_fd_sc_hd__decap_3
XFILLER_0_28_433 VGND VGND VPWR VPWR sky130_fd_sc_hd__decap_8
X_4761_ _2463_ VGND VGND VPWR VPWR _0169_ sky130_fd_sc_hd__inv_2
XFILLER_0_28_444 VGND VGND VPWR VPWR sky130_fd_sc_hd__decap_8
X_3712_ _1867_ _1896_ _1897_ VGND VGND VPWR VPWR _1898_ sky130_fd_sc_hd__o21bai_4
X_4692_ _2454_ VGND VGND VPWR VPWR _0109_ sky130_fd_sc_hd__inv_2
XFILLER_0_28_499 VGND VGND VPWR VPWR sky130_fd_sc_hd__fill_1
X_3643_ _1438_ _1430_ VGND VGND VPWR VPWR _1830_ sky130_fd_sc_hd__or2_1
XFILLER_0_70_288 VGND VGND VPWR VPWR sky130_fd_sc_hd__decap_8
XTAP_TAPCELL_ROW_11_291 VGND VPWR sky130_fd_sc_hd__tapvpwrvgnd_1
XFILLER_0_23_193 VGND VGND VPWR VPWR sky130_fd_sc_hd__decap_4
X_5313_ clknet_leaf_28_clk _0689_ _0305_ VGND VGND VPWR VPWR RF0.regs\[2\]\[8\] sky130_fd_sc_hd__dfrtp_1
X_3574_ _1382_ _1739_ VGND VGND VPWR VPWR _1766_ sky130_fd_sc_hd__nand2_1
X_2525_ _0816_ VGND VGND VPWR VPWR _0817_ sky130_fd_sc_hd__buf_4
X_5244_ clknet_leaf_35_clk _0620_ _0236_ VGND VGND VPWR VPWR RF0.regs\[5\]\[3\] sky130_fd_sc_hd__dfrtp_1
Xhold29 RF0.regs\[7\]\[5\] VGND VGND VPWR VPWR net77 sky130_fd_sc_hd__dlygate4sd3_1
X_5175_ clknet_leaf_2_clk _0551_ _0167_ VGND VGND VPWR VPWR RF0.regs\[10\]\[30\] sky130_fd_sc_hd__dfrtp_1
X_4126_ _2195_ VGND VGND VPWR VPWR _0568_ sky130_fd_sc_hd__clkbuf_1
XTAP_TAPCELL_ROW_3_215 VGND VPWR sky130_fd_sc_hd__tapvpwrvgnd_1
XFILLER_0_39_3 VPWR VGND VPWR VGND sky130_ef_sc_hd__decap_12
X_4057_ _2066_ net267 _2149_ VGND VGND VPWR VPWR _2158_ sky130_fd_sc_hd__mux2_1
XTAP_TAPCELL_ROW_82_924 VGND VPWR sky130_fd_sc_hd__tapvpwrvgnd_1
X_3008_ _1209_ VGND VGND VPWR VPWR _0686_ sky130_fd_sc_hd__clkbuf_1
X_4959_ _2484_ VGND VGND VPWR VPWR _0346_ sky130_fd_sc_hd__inv_2
XFILLER_0_61_277 VGND VGND VPWR VPWR sky130_fd_sc_hd__decap_3
XFILLER_0_61_299 VGND VGND VPWR VPWR sky130_fd_sc_hd__decap_3
XTAP_TAPCELL_ROW_17_339 VGND VPWR sky130_fd_sc_hd__tapvpwrvgnd_1
XFILLER_0_29_208 VGND VGND VPWR VPWR sky130_fd_sc_hd__fill_2
XFILLER_0_32_27 VGND VGND VPWR VPWR sky130_fd_sc_hd__fill_1
XFILLER_0_37_252 VGND VGND VPWR VPWR sky130_fd_sc_hd__fill_2
XTAP_TAPCELL_ROW_53_670 VGND VPWR sky130_fd_sc_hd__tapvpwrvgnd_1
XFILLER_0_25_414 VPWR VGND VPWR VGND sky130_ef_sc_hd__decap_12
X_3290_ RF0.regs\[4\]\[18\] _0836_ _0810_ RF0.regs\[10\]\[18\] VGND VGND VPWR VPWR
+ _1486_ sky130_fd_sc_hd__a22o_1
XFILLER_0_87_163 VGND VGND VPWR VPWR sky130_fd_sc_hd__decap_4
XFILLER_0_87_141 VGND VGND VPWR VPWR sky130_fd_sc_hd__fill_2
X_4813_ _2468_ VGND VGND VPWR VPWR _0216_ sky130_fd_sc_hd__inv_2
XFILLER_0_28_241 VGND VGND VPWR VPWR sky130_fd_sc_hd__decap_8
X_4744_ _2460_ VGND VGND VPWR VPWR _0155_ sky130_fd_sc_hd__inv_2
XFILLER_0_43_244 VGND VGND VPWR VPWR sky130_fd_sc_hd__decap_3
X_4675_ _2450_ VGND VGND VPWR VPWR _0096_ sky130_fd_sc_hd__inv_2
X_3626_ _1812_ net33 VGND VGND VPWR VPWR _1814_ sky130_fd_sc_hd__nor2_1
XFILLER_0_11_141 VGND VGND VPWR VPWR sky130_fd_sc_hd__decap_6
Xoutput19 net19 VGND VGND VPWR VPWR Result[25] sky130_fd_sc_hd__buf_2
X_3557_ _1374_ _1748_ VGND VGND VPWR VPWR _1749_ sky130_fd_sc_hd__nor2_1
X_2508_ IM0.addr\[0\] VGND VGND VPWR VPWR _0800_ sky130_fd_sc_hd__inv_2
X_3488_ RF0.regs\[0\]\[17\] _1218_ _1680_ VGND VGND VPWR VPWR _1681_ sky130_fd_sc_hd__o21ai_1
X_5227_ clknet_leaf_12_clk _0603_ _0219_ VGND VGND VPWR VPWR RF0.regs\[6\]\[18\] sky130_fd_sc_hd__dfrtp_1
XTAP_TAPCELL_ROW_59_718 VGND VPWR sky130_fd_sc_hd__tapvpwrvgnd_1
X_5158_ clknet_leaf_19_clk _0534_ _0150_ VGND VGND VPWR VPWR RF0.regs\[10\]\[13\]
+ sky130_fd_sc_hd__dfrtp_1
X_4109_ net72 VGND VGND VPWR VPWR _2187_ sky130_fd_sc_hd__clkbuf_1
X_5089_ clknet_leaf_28_clk _0465_ _0081_ VGND VGND VPWR VPWR RF0.regs\[15\]\[8\] sky130_fd_sc_hd__dfrtp_1
XTAP_TAPCELL_ROW_67_795 VGND VPWR sky130_fd_sc_hd__tapvpwrvgnd_1
XFILLER_0_78_141 VGND VGND VPWR VPWR sky130_fd_sc_hd__decap_8
XFILLER_0_81_317 VGND VGND VPWR VPWR sky130_fd_sc_hd__fill_1
XTAP_TAPCELL_ROW_50_640 VGND VPWR sky130_fd_sc_hd__tapvpwrvgnd_1
XFILLER_0_34_211 VGND VGND VPWR VPWR sky130_fd_sc_hd__fill_1
XTAP_TAPCELL_ROW_22_386 VGND VPWR sky130_fd_sc_hd__tapvpwrvgnd_1
XFILLER_0_34_244 VGND VGND VPWR VPWR sky130_fd_sc_hd__fill_1
XFILLER_0_34_299 VGND VGND VPWR VPWR sky130_fd_sc_hd__fill_2
XFILLER_0_30_472 VGND VGND VPWR VPWR sky130_fd_sc_hd__decap_4
XFILLER_0_27_27 VGND VGND VPWR VPWR sky130_fd_sc_hd__fill_2
XFILLER_0_27_49 VGND VGND VPWR VPWR sky130_fd_sc_hd__decap_6
XPHY_EDGE_ROW_6_Left_94 VGND VGND VPWR VPWR sky130_fd_sc_hd__decap_3
XFILLER_0_69_163 VGND VGND VPWR VPWR sky130_fd_sc_hd__decap_4
XFILLER_0_43_15 VGND VGND VPWR VPWR sky130_fd_sc_hd__decap_4
XFILLER_0_43_48 VGND VGND VPWR VPWR sky130_fd_sc_hd__fill_2
XFILLER_0_84_133 VGND VGND VPWR VPWR sky130_fd_sc_hd__decap_4
XFILLER_0_72_306 VGND VGND VPWR VPWR sky130_fd_sc_hd__fill_2
XFILLER_0_72_339 VPWR VGND VPWR VGND sky130_ef_sc_hd__decap_12
X_2790_ RF0.regs\[10\]\[2\] _0809_ _0826_ RF0.regs\[25\]\[2\] _1081_ VGND VGND VPWR
+ VPWR _1082_ sky130_fd_sc_hd__a221o_2
XFILLER_0_80_361 VGND VGND VPWR VPWR sky130_fd_sc_hd__decap_3
XFILLER_0_7_15 VPWR VGND VPWR VGND sky130_ef_sc_hd__decap_12
X_4460_ _2368_ VGND VGND VPWR VPWR _0407_ sky130_fd_sc_hd__clkbuf_1
X_4391_ _2332_ VGND VGND VPWR VPWR _0440_ sky130_fd_sc_hd__clkbuf_1
X_3411_ _1010_ _1603_ _1604_ VGND VGND VPWR VPWR _1605_ sky130_fd_sc_hd__and3_1
X_3342_ _1537_ VGND VGND VPWR VPWR _1538_ sky130_fd_sc_hd__inv_2
XFILLER_0_68_67 VPWR VGND VPWR VGND sky130_ef_sc_hd__decap_12
XFILLER_0_0_377 VPWR VGND VPWR VGND sky130_ef_sc_hd__decap_12
X_3273_ _1375_ _1380_ _1464_ _1467_ _1468_ VGND VGND VPWR VPWR _1469_ sky130_fd_sc_hd__o311a_1
X_5012_ clknet_leaf_32_clk _0002_ VGND VGND VPWR VPWR net40 sky130_fd_sc_hd__dfxtp_1
XFILLER_0_84_77 VGND VGND VPWR VPWR sky130_fd_sc_hd__decap_6
XTAP_TAPCELL_ROW_64_765 VGND VPWR sky130_fd_sc_hd__tapvpwrvgnd_1
XFILLER_0_75_122 VGND VGND VPWR VPWR sky130_fd_sc_hd__fill_1
XFILLER_0_8_477 VPWR VGND VPWR VGND sky130_ef_sc_hd__decap_12
X_2988_ _1199_ VGND VGND VPWR VPWR _0696_ sky130_fd_sc_hd__clkbuf_1
X_4727_ _2458_ VGND VGND VPWR VPWR _0140_ sky130_fd_sc_hd__inv_2
X_4658_ _2447_ VGND VGND VPWR VPWR _2449_ sky130_fd_sc_hd__clkbuf_8
X_3609_ RF0.regs\[5\]\[10\] _0865_ _1222_ RF0.regs\[20\]\[10\] _1798_ VGND VGND VPWR
+ VPWR _1799_ sky130_fd_sc_hd__a221o_1
X_4589_ _2439_ VGND VGND VPWR VPWR _0021_ sky130_fd_sc_hd__inv_2
XTAP_TAPCELL_ROW_27_434 VGND VPWR sky130_fd_sc_hd__tapvpwrvgnd_1
XPHY_EDGE_ROW_11_Right_11 VGND VGND VPWR VPWR sky130_fd_sc_hd__decap_3
XFILLER_0_81_103 VGND VGND VPWR VPWR sky130_fd_sc_hd__fill_1
XPHY_EDGE_ROW_20_Right_20 VGND VGND VPWR VPWR sky130_fd_sc_hd__decap_3
X_3960_ RF0.regs\[5\]\[27\] _1971_ _2102_ VGND VGND VPWR VPWR _2107_ sky130_fd_sc_hd__mux2_1
XFILLER_0_57_111 VGND VGND VPWR VPWR sky130_fd_sc_hd__fill_1
X_2911_ net141 VGND VGND VPWR VPWR _1161_ sky130_fd_sc_hd__clkbuf_1
XTAP_TAPCELL_ROW_61_735 VGND VPWR sky130_fd_sc_hd__tapvpwrvgnd_1
X_3891_ _1794_ _1800_ net3 VGND VGND VPWR VPWR _2057_ sky130_fd_sc_hd__nand3b_1
XFILLER_0_85_497 VGND VGND VPWR VPWR sky130_fd_sc_hd__decap_6
X_2842_ _1121_ VGND VGND VPWR VPWR _0764_ sky130_fd_sc_hd__clkbuf_1
XFILLER_0_38_380 VGND VGND VPWR VPWR sky130_fd_sc_hd__fill_1
XFILLER_0_5_447 VGND VGND VPWR VPWR sky130_fd_sc_hd__fill_1
X_2773_ RF0.regs\[4\]\[22\] _0901_ _0860_ VGND VGND VPWR VPWR _1065_ sky130_fd_sc_hd__and3_1
XFILLER_0_60_309 VGND VGND VPWR VPWR sky130_fd_sc_hd__decap_4
XFILLER_0_13_214 VGND VGND VPWR VPWR sky130_fd_sc_hd__decap_3
X_4512_ _2400_ VGND VGND VPWR VPWR _2401_ sky130_fd_sc_hd__inv_2
XFILLER_0_53_361 VGND VGND VPWR VPWR sky130_fd_sc_hd__fill_1
XFILLER_0_79_55 VGND VGND VPWR VPWR sky130_fd_sc_hd__fill_1
Xhold115 RF0.regs\[2\]\[8\] VGND VGND VPWR VPWR net163 sky130_fd_sc_hd__dlygate4sd3_1
Xhold126 RF0.regs\[20\]\[27\] VGND VGND VPWR VPWR net174 sky130_fd_sc_hd__dlygate4sd3_1
Xhold104 RF0.regs\[12\]\[25\] VGND VGND VPWR VPWR net152 sky130_fd_sc_hd__dlygate4sd3_1
Xhold137 IM0.addr\[23\] VGND VGND VPWR VPWR net185 sky130_fd_sc_hd__dlygate4sd3_1
Xhold159 IM0.addr\[15\] VGND VGND VPWR VPWR net207 sky130_fd_sc_hd__dlygate4sd3_1
Xhold148 RF0.regs\[20\]\[9\] VGND VGND VPWR VPWR net196 sky130_fd_sc_hd__dlygate4sd3_1
X_4443_ _2359_ VGND VGND VPWR VPWR _0415_ sky130_fd_sc_hd__clkbuf_1
X_4374_ _2323_ VGND VGND VPWR VPWR _0448_ sky130_fd_sc_hd__clkbuf_1
XFILLER_0_0_141 VPWR VGND VPWR VGND sky130_ef_sc_hd__decap_12
XFILLER_0_21_291 VGND VGND VPWR VPWR sky130_fd_sc_hd__decap_4
X_3325_ RF0.regs\[10\]\[21\] _0812_ _1222_ RF0.regs\[25\]\[21\] VGND VGND VPWR VPWR
+ _1521_ sky130_fd_sc_hd__a22o_1
XTAP_TAPCELL_ROW_69_813 VGND VPWR sky130_fd_sc_hd__tapvpwrvgnd_1
X_3256_ _0984_ _1450_ VGND VGND VPWR VPWR _1452_ sky130_fd_sc_hd__and2_1
XFILLER_0_21_3 VPWR VGND VPWR VGND sky130_ef_sc_hd__decap_12
X_3187_ _1291_ _1292_ _0950_ VGND VGND VPWR VPWR _1383_ sky130_fd_sc_hd__o21ai_1
XTAP_TAPCELL_ROW_24_404 VGND VPWR sky130_fd_sc_hd__tapvpwrvgnd_1
XFILLER_0_36_317 VPWR VGND VPWR VGND sky130_ef_sc_hd__decap_12
XFILLER_0_29_391 VGND VGND VPWR VPWR sky130_fd_sc_hd__fill_1
XTAP_TAPCELL_ROW_32_481 VGND VPWR sky130_fd_sc_hd__tapvpwrvgnd_1
XFILLER_0_44_350 VGND VGND VPWR VPWR sky130_fd_sc_hd__fill_1
XFILLER_0_51_309 VPWR VGND VPWR VGND sky130_ef_sc_hd__decap_12
XFILLER_0_63_169 VGND VGND VPWR VPWR sky130_fd_sc_hd__fill_1
XFILLER_0_32_512 VGND VGND VPWR VPWR sky130_fd_sc_hd__decap_4
XFILLER_0_44_383 VPWR VGND VPWR VGND sky130_ef_sc_hd__decap_12
XFILLER_0_86_217 VPWR VGND VPWR VGND sky130_ef_sc_hd__decap_12
XFILLER_0_67_442 VGND VGND VPWR VPWR sky130_fd_sc_hd__decap_6
XFILLER_0_82_445 VPWR VGND VPWR VGND sky130_ef_sc_hd__decap_12
XFILLER_0_27_328 VGND VGND VPWR VPWR sky130_fd_sc_hd__fill_1
XFILLER_0_40_16 VGND VGND VPWR VPWR sky130_fd_sc_hd__decap_8
XFILLER_0_42_309 VGND VGND VPWR VPWR sky130_fd_sc_hd__decap_6
XFILLER_0_82_489 VPWR VGND VPWR VGND sky130_ef_sc_hd__decap_12
XFILLER_0_4_27 VGND VGND VPWR VPWR sky130_fd_sc_hd__fill_1
X_3110_ RF0.regs\[5\]\[17\] _0874_ _0903_ _1305_ VGND VGND VPWR VPWR _1306_ sky130_fd_sc_hd__a211o_1
X_4090_ _1892_ _2176_ VGND VGND VPWR VPWR _2177_ sky130_fd_sc_hd__nor2_1
XFILLER_0_65_57 VGND VGND VPWR VPWR sky130_fd_sc_hd__decap_4
X_3041_ _1236_ VGND VGND VPWR VPWR _1237_ sky130_fd_sc_hd__clkbuf_4
XTAP_TAPCELL_ROW_38_529 VGND VPWR sky130_fd_sc_hd__tapvpwrvgnd_1
X_4992_ _2487_ VGND VGND VPWR VPWR _0376_ sky130_fd_sc_hd__inv_2
X_3943_ _2042_ _2096_ VGND VGND VPWR VPWR _2097_ sky130_fd_sc_hd__nor2_2
XFILLER_0_58_453 VGND VGND VPWR VPWR sky130_fd_sc_hd__fill_1
XFILLER_0_14_83 VGND VGND VPWR VPWR sky130_fd_sc_hd__fill_1
X_3874_ _0797_ _2039_ _1889_ VGND VGND VPWR VPWR _2040_ sky130_fd_sc_hd__or3b_2
X_2825_ _1108_ net165 VGND VGND VPWR VPWR _1112_ sky130_fd_sc_hd__and2_1
XFILLER_0_45_158 VGND VGND VPWR VPWR sky130_fd_sc_hd__decap_8
XFILLER_0_45_169 VPWR VGND VPWR VGND sky130_ef_sc_hd__decap_12
XFILLER_0_14_512 VGND VGND VPWR VPWR sky130_fd_sc_hd__fill_1
XFILLER_0_5_266 VGND VGND VPWR VPWR sky130_fd_sc_hd__decap_4
X_2756_ _1028_ _1030_ _1045_ _1047_ VGND VGND VPWR VPWR _1048_ sky130_fd_sc_hd__o22ai_1
X_2687_ _0976_ _0978_ VGND VGND VPWR VPWR _0979_ sky130_fd_sc_hd__xor2_1
XFILLER_0_69_3 VPWR VGND VPWR VGND sky130_ef_sc_hd__decap_12
XFILLER_0_1_461 VPWR VGND VPWR VGND sky130_ef_sc_hd__decap_12
X_4426_ RF0.regs\[25\]\[30\] _1957_ _2349_ VGND VGND VPWR VPWR _2351_ sky130_fd_sc_hd__mux2_1
X_4357_ net230 _1952_ _2314_ VGND VGND VPWR VPWR _2315_ sky130_fd_sc_hd__mux2_1
X_4288_ _0819_ _0850_ _0849_ _1219_ VGND VGND VPWR VPWR _2278_ sky130_fd_sc_hd__o211a_2
X_3308_ _1503_ _1089_ VGND VGND VPWR VPWR _1504_ sky130_fd_sc_hd__xnor2_4
X_3239_ _1042_ _1434_ VGND VGND VPWR VPWR _1435_ sky130_fd_sc_hd__nor2_1
XTAP_TAPCELL_ROW_1_198 VGND VPWR sky130_fd_sc_hd__tapvpwrvgnd_1
XFILLER_0_19_39 VPWR VGND VPWR VGND sky130_ef_sc_hd__decap_12
XTAP_TAPCELL_ROW_71_830 VGND VPWR sky130_fd_sc_hd__tapvpwrvgnd_1
XFILLER_0_27_125 VGND VGND VPWR VPWR sky130_fd_sc_hd__decap_4
XTAP_TAPCELL_ROW_43_576 VGND VPWR sky130_fd_sc_hd__tapvpwrvgnd_1
XFILLER_0_51_37 VGND VGND VPWR VPWR sky130_fd_sc_hd__decap_3
XFILLER_0_82_253 VGND VGND VPWR VPWR sky130_fd_sc_hd__decap_6
Xclkload35 clknet_leaf_17_clk VGND VGND VPWR VPWR clkload35/Y sky130_fd_sc_hd__bufinv_16
XFILLER_0_70_448 VGND VGND VPWR VPWR sky130_fd_sc_hd__fill_1
XFILLER_0_2_203 VPWR VGND VPWR VGND sky130_ef_sc_hd__decap_12
Xclkload24 clknet_leaf_29_clk VGND VGND VPWR VPWR clkload24/Y sky130_fd_sc_hd__clkinv_4
X_2610_ RF0.regs\[4\]\[17\] _0901_ _0860_ VGND VGND VPWR VPWR _0902_ sky130_fd_sc_hd__and3_1
Xclkload13 clknet_leaf_5_clk VGND VGND VPWR VPWR clkload13/Y sky130_fd_sc_hd__clkinv_8
X_3590_ _1779_ _1780_ VGND VGND VPWR VPWR _1781_ sky130_fd_sc_hd__and2_1
X_2541_ _0794_ _0832_ VGND VGND VPWR VPWR _0833_ sky130_fd_sc_hd__nor2_1
X_5260_ clknet_leaf_12_clk _0636_ _0252_ VGND VGND VPWR VPWR RF0.regs\[5\]\[19\] sky130_fd_sc_hd__dfrtp_1
XFILLER_0_2_269 VGND VGND VPWR VPWR sky130_fd_sc_hd__fill_2
X_4211_ _2239_ VGND VGND VPWR VPWR _0527_ sky130_fd_sc_hd__clkbuf_1
X_5191_ clknet_leaf_22_clk _0567_ _0183_ VGND VGND VPWR VPWR RF0.regs\[7\]\[14\] sky130_fd_sc_hd__dfrtp_1
X_4142_ _2203_ VGND VGND VPWR VPWR _0560_ sky130_fd_sc_hd__clkbuf_1
X_4073_ _2166_ VGND VGND VPWR VPWR _0591_ sky130_fd_sc_hd__clkbuf_1
X_3024_ _0818_ net65 VGND VGND VPWR VPWR _1220_ sky130_fd_sc_hd__nor2_4
X_4975_ _2486_ VGND VGND VPWR VPWR _0360_ sky130_fd_sc_hd__inv_2
X_3926_ _1834_ _1907_ VGND VGND VPWR VPWR _2085_ sky130_fd_sc_hd__nand2_1
XFILLER_0_73_231 VGND VGND VPWR VPWR sky130_fd_sc_hd__fill_1
Xclkload7 clknet_leaf_41_clk VGND VGND VPWR VPWR clkload7/Y sky130_fd_sc_hd__clkinv_1
X_3857_ _2024_ _1427_ _1431_ _1830_ _2025_ VGND VGND VPWR VPWR _2026_ sky130_fd_sc_hd__a32o_1
XFILLER_0_41_81 VGND VGND VPWR VPWR sky130_fd_sc_hd__decap_6
XFILLER_0_26_191 VGND VGND VPWR VPWR sky130_fd_sc_hd__decap_4
X_2808_ _1035_ _1037_ _1040_ _1042_ _1099_ VGND VGND VPWR VPWR _1100_ sky130_fd_sc_hd__o221a_1
X_3788_ _1602_ _1605_ _1969_ VGND VGND VPWR VPWR _1970_ sky130_fd_sc_hd__a21bo_1
X_2739_ _0935_ _0937_ _1023_ _1025_ VGND VGND VPWR VPWR _1031_ sky130_fd_sc_hd__o22ai_1
XFILLER_0_14_397 VPWR VGND VPWR VGND sky130_ef_sc_hd__decap_12
X_4409_ net211 _2088_ _2336_ VGND VGND VPWR VPWR _2342_ sky130_fd_sc_hd__mux2_1
X_5389_ clknet_leaf_44_clk _0765_ _0381_ VGND VGND VPWR VPWR IM0.addr\[20\] sky130_fd_sc_hd__dfrtp_1
XTAP_TAPCELL_ROW_6_246 VGND VPWR sky130_fd_sc_hd__tapvpwrvgnd_1
XFILLER_0_5_81 VPWR VGND VPWR VGND sky130_ef_sc_hd__decap_12
XTAP_TAPCELL_ROW_85_955 VGND VPWR sky130_fd_sc_hd__tapvpwrvgnd_1
XFILLER_0_56_209 VGND VGND VPWR VPWR sky130_fd_sc_hd__decap_4
XFILLER_0_49_272 VGND VGND VPWR VPWR sky130_fd_sc_hd__decap_3
XFILLER_0_64_253 VPWR VGND VPWR VGND sky130_ef_sc_hd__decap_12
XFILLER_0_9_380 VGND VGND VPWR VPWR sky130_fd_sc_hd__fill_1
XTAP_TAPCELL_ROW_40_546 VGND VPWR sky130_fd_sc_hd__tapvpwrvgnd_1
XFILLER_0_46_15 VGND VGND VPWR VPWR sky130_fd_sc_hd__decap_8
XTAP_TAPCELL_ROW_48_624 VGND VPWR sky130_fd_sc_hd__tapvpwrvgnd_1
XFILLER_0_1_39 VPWR VGND VPWR VGND sky130_ef_sc_hd__decap_12
XFILLER_0_87_389 VGND VGND VPWR VPWR sky130_fd_sc_hd__decap_3
XTAP_TAPCELL_ROW_56_690 VGND VPWR sky130_fd_sc_hd__tapvpwrvgnd_1
X_4760_ _2462_ VGND VGND VPWR VPWR _2463_ sky130_fd_sc_hd__buf_1
X_3711_ _1007_ _1861_ _1866_ VGND VGND VPWR VPWR _1897_ sky130_fd_sc_hd__and3_1
X_4691_ _2454_ VGND VGND VPWR VPWR _0108_ sky130_fd_sc_hd__inv_2
XFILLER_0_11_51 VGND VGND VPWR VPWR sky130_fd_sc_hd__decap_4
X_3642_ _1825_ _1826_ _1828_ _1217_ RF0.regs\[0\]\[7\] VGND VGND VPWR VPWR _1829_
+ sky130_fd_sc_hd__o32a_1
XTAP_TAPCELL_ROW_11_292 VGND VPWR sky130_fd_sc_hd__tapvpwrvgnd_1
X_3573_ RF0.regs\[0\]\[13\] _1217_ _1761_ _1764_ VGND VGND VPWR VPWR _1765_ sky130_fd_sc_hd__o22a_1
XFILLER_0_11_95 VGND VGND VPWR VPWR sky130_fd_sc_hd__fill_1
X_5312_ clknet_leaf_38_clk _0688_ _0304_ VGND VGND VPWR VPWR RF0.regs\[2\]\[7\] sky130_fd_sc_hd__dfrtp_1
XPHY_EDGE_ROW_49_Right_49 VGND VGND VPWR VPWR sky130_fd_sc_hd__decap_3
XFILLER_0_11_345 VGND VGND VPWR VPWR sky130_fd_sc_hd__fill_2
X_2524_ _0815_ VGND VGND VPWR VPWR _0816_ sky130_fd_sc_hd__clkbuf_4
XFILLER_0_60_7 VGND VGND VPWR VPWR sky130_fd_sc_hd__fill_1
X_5243_ clknet_leaf_36_clk _0619_ _0235_ VGND VGND VPWR VPWR RF0.regs\[5\]\[2\] sky130_fd_sc_hd__dfrtp_1
XFILLER_0_11_389 VGND VGND VPWR VPWR sky130_fd_sc_hd__decap_3
X_5174_ clknet_leaf_1_clk _0550_ _0166_ VGND VGND VPWR VPWR RF0.regs\[10\]\[29\] sky130_fd_sc_hd__dfrtp_2
X_4125_ net98 VGND VGND VPWR VPWR _2195_ sky130_fd_sc_hd__clkbuf_1
XTAP_TAPCELL_ROW_3_216 VGND VPWR sky130_fd_sc_hd__tapvpwrvgnd_1
X_4056_ _2157_ VGND VGND VPWR VPWR _0599_ sky130_fd_sc_hd__clkbuf_1
XPHY_EDGE_ROW_58_Right_58 VGND VGND VPWR VPWR sky130_fd_sc_hd__decap_3
XTAP_TAPCELL_ROW_82_925 VGND VPWR sky130_fd_sc_hd__tapvpwrvgnd_1
X_3007_ net109 VGND VGND VPWR VPWR _1209_ sky130_fd_sc_hd__clkbuf_1
X_4958_ _2484_ VGND VGND VPWR VPWR _0345_ sky130_fd_sc_hd__inv_2
XFILLER_0_19_456 VGND VGND VPWR VPWR sky130_fd_sc_hd__fill_2
X_4889_ _2476_ VGND VGND VPWR VPWR _0284_ sky130_fd_sc_hd__inv_2
XFILLER_0_34_404 VGND VGND VPWR VPWR sky130_fd_sc_hd__decap_8
XFILLER_0_34_415 VGND VGND VPWR VPWR sky130_fd_sc_hd__decap_4
X_3909_ _1914_ _2071_ VGND VGND VPWR VPWR _2072_ sky130_fd_sc_hd__xnor2_4
XFILLER_0_61_223 VGND VGND VPWR VPWR sky130_fd_sc_hd__fill_1
XFILLER_0_6_394 VGND VGND VPWR VPWR sky130_fd_sc_hd__decap_6
XFILLER_0_21_109 VGND VGND VPWR VPWR sky130_fd_sc_hd__decap_3
XPHY_EDGE_ROW_67_Right_67 VGND VGND VPWR VPWR sky130_fd_sc_hd__decap_3
XPHY_EDGE_ROW_76_Right_76 VGND VGND VPWR VPWR sky130_fd_sc_hd__decap_3
XFILLER_0_69_301 VGND VGND VPWR VPWR sky130_fd_sc_hd__decap_4
XFILLER_0_16_29 VPWR VGND VPWR VGND sky130_ef_sc_hd__decap_12
XFILLER_0_69_334 VGND VGND VPWR VPWR sky130_fd_sc_hd__fill_2
XFILLER_0_37_242 VGND VGND VPWR VPWR sky130_fd_sc_hd__decap_6
XFILLER_0_25_426 VPWR VGND VPWR VGND sky130_ef_sc_hd__decap_12
XPHY_EDGE_ROW_85_Right_85 VGND VGND VPWR VPWR sky130_fd_sc_hd__decap_3
XFILLER_0_52_256 VPWR VGND VPWR VGND sky130_ef_sc_hd__decap_12
XFILLER_0_73_57 VGND VGND VPWR VPWR sky130_fd_sc_hd__decap_3
XFILLER_0_87_197 VPWR VGND VPWR VGND sky130_ef_sc_hd__decap_12
X_4812_ _2468_ VGND VGND VPWR VPWR _0215_ sky130_fd_sc_hd__inv_2
XFILLER_0_28_231 VGND VGND VPWR VPWR sky130_fd_sc_hd__decap_3
XFILLER_0_28_253 VPWR VGND VPWR VGND sky130_ef_sc_hd__decap_12
X_4743_ _2457_ VGND VGND VPWR VPWR _2460_ sky130_fd_sc_hd__clkbuf_8
XFILLER_0_7_158 VGND VGND VPWR VPWR sky130_fd_sc_hd__fill_1
XFILLER_0_43_223 VGND VGND VPWR VPWR sky130_fd_sc_hd__fill_1
X_4674_ _2450_ VGND VGND VPWR VPWR _0095_ sky130_fd_sc_hd__inv_2
X_3625_ _1453_ _1802_ _1813_ VGND VGND VPWR VPWR net33 sky130_fd_sc_hd__a21oi_2
X_3556_ _1381_ _1739_ _1380_ VGND VGND VPWR VPWR _1748_ sky130_fd_sc_hd__a21oi_1
X_2507_ _0798_ VGND VGND VPWR VPWR _0799_ sky130_fd_sc_hd__buf_4
X_3487_ RF0.regs\[7\]\[17\] _1245_ _1677_ _1679_ VGND VGND VPWR VPWR _1680_ sky130_fd_sc_hd__a211o_1
X_5226_ clknet_leaf_17_clk _0602_ _0218_ VGND VGND VPWR VPWR RF0.regs\[6\]\[17\] sky130_fd_sc_hd__dfrtp_1
XTAP_TAPCELL_ROW_59_719 VGND VPWR sky130_fd_sc_hd__tapvpwrvgnd_1
X_5157_ clknet_leaf_25_clk _0533_ _0149_ VGND VGND VPWR VPWR RF0.regs\[10\]\[12\]
+ sky130_fd_sc_hd__dfrtp_1
X_5088_ clknet_leaf_28_clk _0464_ _0080_ VGND VGND VPWR VPWR RF0.regs\[15\]\[7\] sky130_fd_sc_hd__dfrtp_1
X_4108_ _2186_ VGND VGND VPWR VPWR _0577_ sky130_fd_sc_hd__clkbuf_1
X_4039_ _2148_ VGND VGND VPWR VPWR _0607_ sky130_fd_sc_hd__clkbuf_1
XTAP_TAPCELL_ROW_67_796 VGND VPWR sky130_fd_sc_hd__tapvpwrvgnd_1
XFILLER_0_66_315 VGND VGND VPWR VPWR sky130_fd_sc_hd__fill_1
XFILLER_0_66_337 VGND VGND VPWR VPWR sky130_fd_sc_hd__fill_2
XFILLER_0_19_253 VGND VGND VPWR VPWR sky130_fd_sc_hd__fill_2
XTAP_TAPCELL_ROW_50_641 VGND VPWR sky130_fd_sc_hd__tapvpwrvgnd_1
XTAP_TAPCELL_ROW_22_387 VGND VPWR sky130_fd_sc_hd__tapvpwrvgnd_1
XFILLER_0_15_481 VGND VGND VPWR VPWR sky130_fd_sc_hd__decap_4
XFILLER_0_22_418 VGND VGND VPWR VPWR sky130_fd_sc_hd__fill_2
XFILLER_0_69_197 VGND VGND VPWR VPWR sky130_fd_sc_hd__fill_1
XFILLER_0_57_337 VGND VGND VPWR VPWR sky130_fd_sc_hd__decap_8
XFILLER_0_72_318 VPWR VGND VPWR VGND sky130_ef_sc_hd__decap_12
XTAP_TAPCELL_ROW_13_310 VGND VPWR sky130_fd_sc_hd__tapvpwrvgnd_1
XFILLER_0_25_223 VGND VGND VPWR VPWR sky130_fd_sc_hd__fill_1
XFILLER_0_65_381 VGND VGND VPWR VPWR sky130_fd_sc_hd__decap_4
XFILLER_0_13_429 VGND VGND VPWR VPWR sky130_fd_sc_hd__decap_4
XFILLER_0_7_27 VPWR VGND VPWR VGND sky130_ef_sc_hd__decap_12
X_4390_ net260 _2012_ _2325_ VGND VGND VPWR VPWR _2332_ sky130_fd_sc_hd__mux2_1
X_3410_ _1356_ _1541_ _1540_ VGND VGND VPWR VPWR _1604_ sky130_fd_sc_hd__a21o_1
XFILLER_0_21_462 VGND VGND VPWR VPWR sky130_fd_sc_hd__decap_6
X_3341_ _0999_ _1536_ VGND VGND VPWR VPWR _1537_ sky130_fd_sc_hd__nor2_1
XFILLER_0_0_389 VGND VGND VPWR VPWR sky130_fd_sc_hd__decap_3
XFILLER_0_68_79 VGND VGND VPWR VPWR sky130_fd_sc_hd__decap_4
X_3272_ _0926_ _1367_ VGND VGND VPWR VPWR _1468_ sky130_fd_sc_hd__nand2_1
X_5011_ clknet_leaf_32_clk _0001_ VGND VGND VPWR VPWR net39 sky130_fd_sc_hd__dfxtp_1
XFILLER_0_75_101 VGND VGND VPWR VPWR sky130_fd_sc_hd__decap_8
XTAP_TAPCELL_ROW_64_766 VGND VPWR sky130_fd_sc_hd__tapvpwrvgnd_1
XFILLER_0_75_167 VGND VGND VPWR VPWR sky130_fd_sc_hd__fill_1
XFILLER_0_8_489 VPWR VGND VPWR VGND sky130_ef_sc_hd__decap_12
X_2987_ net147 VGND VGND VPWR VPWR _1199_ sky130_fd_sc_hd__clkbuf_1
X_4726_ _2458_ VGND VGND VPWR VPWR _0139_ sky130_fd_sc_hd__inv_2
X_4657_ _2448_ VGND VGND VPWR VPWR _0080_ sky130_fd_sc_hd__inv_2
X_3608_ RF0.regs\[10\]\[10\] _0885_ _0813_ RF0.regs\[25\]\[10\] _0795_ VGND VGND VPWR
+ VPWR _1798_ sky130_fd_sc_hd__a221o_1
X_4588_ _2439_ VGND VGND VPWR VPWR _0020_ sky130_fd_sc_hd__inv_2
X_3539_ _1727_ _1729_ VGND VGND VPWR VPWR _1731_ sky130_fd_sc_hd__or2_1
X_5209_ clknet_leaf_41_clk _0585_ _0201_ VGND VGND VPWR VPWR RF0.regs\[6\]\[0\] sky130_fd_sc_hd__dfrtp_1
XTAP_TAPCELL_ROW_27_435 VGND VPWR sky130_fd_sc_hd__tapvpwrvgnd_1
XFILLER_0_54_307 VGND VGND VPWR VPWR sky130_fd_sc_hd__fill_1
XFILLER_0_66_156 VGND VGND VPWR VPWR sky130_fd_sc_hd__decap_4
XFILLER_0_81_137 VPWR VGND VPWR VGND sky130_ef_sc_hd__decap_12
XFILLER_0_62_395 VGND VGND VPWR VPWR sky130_fd_sc_hd__fill_1
XFILLER_0_38_27 VGND VGND VPWR VPWR sky130_fd_sc_hd__fill_1
X_2910_ _1160_ VGND VGND VPWR VPWR _0735_ sky130_fd_sc_hd__clkbuf_1
XFILLER_0_57_123 VPWR VGND VPWR VGND sky130_ef_sc_hd__decap_12
XTAP_TAPCELL_ROW_61_736 VGND VPWR sky130_fd_sc_hd__tapvpwrvgnd_1
X_3890_ _0799_ _1811_ _2053_ _1814_ _2055_ VGND VGND VPWR VPWR _2056_ sky130_fd_sc_hd__o32a_1
XFILLER_0_72_137 VGND VGND VPWR VPWR sky130_fd_sc_hd__decap_3
X_2841_ _1118_ net249 VGND VGND VPWR VPWR _1121_ sky130_fd_sc_hd__and2_1
XFILLER_0_38_392 VGND VGND VPWR VPWR sky130_fd_sc_hd__decap_8
XFILLER_0_53_340 VGND VGND VPWR VPWR sky130_fd_sc_hd__decap_6
X_2772_ RF0.regs\[5\]\[22\] _0876_ _1062_ _1063_ VGND VGND VPWR VPWR _1064_ sky130_fd_sc_hd__a211o_1
X_4511_ _2390_ _2393_ VGND VGND VPWR VPWR _2400_ sky130_fd_sc_hd__and2b_1
Xhold105 RF0.regs\[7\]\[0\] VGND VGND VPWR VPWR net153 sky130_fd_sc_hd__dlygate4sd3_1
X_4442_ RF0.regs\[25\]\[22\] _1988_ _2349_ VGND VGND VPWR VPWR _2359_ sky130_fd_sc_hd__mux2_1
Xhold116 RF0.regs\[2\]\[14\] VGND VGND VPWR VPWR net164 sky130_fd_sc_hd__dlygate4sd3_1
Xhold149 RF0.regs\[6\]\[15\] VGND VGND VPWR VPWR net197 sky130_fd_sc_hd__dlygate4sd3_1
Xhold127 RF0.regs\[20\]\[1\] VGND VGND VPWR VPWR net175 sky130_fd_sc_hd__dlygate4sd3_1
Xhold138 RF0.regs\[12\]\[8\] VGND VGND VPWR VPWR net186 sky130_fd_sc_hd__dlygate4sd3_1
X_4373_ net225 _1986_ _2314_ VGND VGND VPWR VPWR _2323_ sky130_fd_sc_hd__mux2_1
XFILLER_0_0_153 VGND VGND VPWR VPWR sky130_fd_sc_hd__decap_8
XFILLER_0_21_281 VGND VGND VPWR VPWR sky130_fd_sc_hd__fill_1
XPHY_EDGE_ROW_13_Left_101 VGND VGND VPWR VPWR sky130_fd_sc_hd__decap_3
XFILLER_0_0_197 VPWR VGND VPWR VGND sky130_ef_sc_hd__decap_12
X_3324_ RF0.regs\[4\]\[20\] _0837_ _1138_ RF0.regs\[12\]\[20\] _1519_ VGND VGND VPWR
+ VPWR _1520_ sky130_fd_sc_hd__a221oi_1
XTAP_TAPCELL_ROW_69_814 VGND VPWR sky130_fd_sc_hd__tapvpwrvgnd_1
X_3255_ _1447_ _1450_ VGND VGND VPWR VPWR _1451_ sky130_fd_sc_hd__nor2_1
X_3186_ _1380_ _1381_ VGND VGND VPWR VPWR _1382_ sky130_fd_sc_hd__or2b_1
XTAP_TAPCELL_ROW_77_880 VGND VPWR sky130_fd_sc_hd__tapvpwrvgnd_1
XFILLER_0_14_3 VPWR VGND VPWR VGND sky130_ef_sc_hd__decap_12
XPHY_EDGE_ROW_22_Left_110 VGND VGND VPWR VPWR sky130_fd_sc_hd__decap_3
XTAP_TAPCELL_ROW_24_405 VGND VPWR sky130_fd_sc_hd__tapvpwrvgnd_1
XFILLER_0_36_307 VGND VGND VPWR VPWR sky130_fd_sc_hd__fill_1
XFILLER_0_8_231 VGND VGND VPWR VPWR sky130_fd_sc_hd__fill_1
XFILLER_0_29_381 VGND VGND VPWR VPWR sky130_fd_sc_hd__decap_3
XFILLER_0_36_329 VPWR VGND VPWR VGND sky130_ef_sc_hd__decap_12
XFILLER_0_44_362 VGND VGND VPWR VPWR sky130_fd_sc_hd__fill_2
X_4709_ _2455_ VGND VGND VPWR VPWR _0125_ sky130_fd_sc_hd__inv_2
XFILLER_0_44_395 VPWR VGND VPWR VGND sky130_ef_sc_hd__decap_12
XFILLER_0_12_292 VPWR VGND VPWR VGND sky130_ef_sc_hd__decap_12
XFILLER_0_86_229 VGND VGND VPWR VPWR sky130_fd_sc_hd__fill_2
XFILLER_0_24_29 VGND VGND VPWR VPWR sky130_fd_sc_hd__decap_6
XFILLER_0_82_457 VPWR VGND VPWR VGND sky130_ef_sc_hd__decap_12
XFILLER_0_62_181 VGND VGND VPWR VPWR sky130_fd_sc_hd__fill_1
XFILLER_0_49_26 VGND VGND VPWR VPWR sky130_fd_sc_hd__decap_4
X_3040_ _0800_ _0793_ _0787_ _0869_ VGND VGND VPWR VPWR _1236_ sky130_fd_sc_hd__and4_2
XFILLER_0_81_57 VPWR VGND VPWR VGND sky130_ef_sc_hd__decap_12
X_4991_ _2487_ VGND VGND VPWR VPWR _0375_ sky130_fd_sc_hd__inv_2
X_3942_ _2036_ _2041_ VGND VGND VPWR VPWR _2096_ sky130_fd_sc_hd__and2_1
XFILLER_0_58_465 VGND VGND VPWR VPWR sky130_fd_sc_hd__fill_2
XFILLER_0_85_295 VGND VGND VPWR VPWR sky130_fd_sc_hd__fill_2
X_3873_ _0959_ _2038_ VGND VGND VPWR VPWR _2039_ sky130_fd_sc_hd__xnor2_1
X_2824_ _1111_ VGND VGND VPWR VPWR _0772_ sky130_fd_sc_hd__clkbuf_1
X_2755_ RF0.regs\[10\]\[4\] _0809_ _0826_ RF0.regs\[25\]\[4\] _1046_ VGND VGND VPWR
+ VPWR _1047_ sky130_fd_sc_hd__a221o_2
XFILLER_0_53_181 VGND VGND VPWR VPWR sky130_fd_sc_hd__fill_1
X_2686_ RF0.regs\[10\]\[11\] _0810_ _0827_ RF0.regs\[25\]\[11\] _0977_ VGND VGND VPWR
+ VPWR _0978_ sky130_fd_sc_hd__a221o_2
X_4425_ _2350_ VGND VGND VPWR VPWR _0424_ sky130_fd_sc_hd__clkbuf_1
XFILLER_0_1_473 VPWR VGND VPWR VGND sky130_ef_sc_hd__decap_12
X_4356_ _1225_ VGND VGND VPWR VPWR _2314_ sky130_fd_sc_hd__buf_4
X_3307_ _1322_ _1502_ _1318_ VGND VGND VPWR VPWR _1503_ sky130_fd_sc_hd__mux2_4
X_4287_ _2277_ VGND VGND VPWR VPWR _0489_ sky130_fd_sc_hd__clkbuf_1
X_3238_ _0827_ _1432_ _1433_ VGND VGND VPWR VPWR _1434_ sky130_fd_sc_hd__or3_1
X_3169_ _1302_ VGND VGND VPWR VPWR _1365_ sky130_fd_sc_hd__inv_2
XFILLER_0_68_229 VGND VGND VPWR VPWR sky130_fd_sc_hd__fill_1
XTAP_TAPCELL_ROW_1_199 VGND VPWR sky130_fd_sc_hd__tapvpwrvgnd_1
XFILLER_0_64_457 VGND VGND VPWR VPWR sky130_fd_sc_hd__decap_3
XFILLER_0_32_365 VGND VGND VPWR VPWR sky130_fd_sc_hd__decap_4
XTAP_TAPCELL_ROW_9_266 VGND VPWR sky130_fd_sc_hd__tapvpwrvgnd_1
XFILLER_0_3_3 VPWR VGND VPWR VGND sky130_ef_sc_hd__decap_12
XFILLER_0_87_505 VPWR VGND VPWR VGND sky130_ef_sc_hd__decap_12
XTAP_TAPCELL_ROW_71_831 VGND VPWR sky130_fd_sc_hd__tapvpwrvgnd_1
XFILLER_0_82_221 VGND VGND VPWR VPWR sky130_fd_sc_hd__decap_4
XTAP_TAPCELL_ROW_43_577 VGND VPWR sky130_fd_sc_hd__tapvpwrvgnd_1
XFILLER_0_70_416 VGND VGND VPWR VPWR sky130_fd_sc_hd__decap_4
XFILLER_0_23_310 VGND VGND VPWR VPWR sky130_fd_sc_hd__fill_1
Xclkload25 clknet_leaf_30_clk VGND VGND VPWR VPWR clkload25/Y sky130_fd_sc_hd__bufinv_16
Xclkload14 clknet_leaf_6_clk VGND VGND VPWR VPWR clkload14/Y sky130_fd_sc_hd__clkinv_2
Xclkload36 clknet_leaf_19_clk VGND VGND VPWR VPWR clkload36/Y sky130_fd_sc_hd__bufinv_16
XFILLER_0_11_505 VGND VGND VPWR VPWR sky130_fd_sc_hd__decap_8
XFILLER_0_2_215 VPWR VGND VPWR VGND sky130_ef_sc_hd__decap_12
X_2540_ _0819_ net67 _0822_ VGND VGND VPWR VPWR _0832_ sky130_fd_sc_hd__a21oi_1
X_4210_ RF0.regs\[10\]\[6\] _2088_ _2233_ VGND VGND VPWR VPWR _2239_ sky130_fd_sc_hd__mux2_1
XFILLER_0_50_195 VGND VGND VPWR VPWR sky130_fd_sc_hd__fill_1
X_5190_ clknet_leaf_21_clk _0566_ _0182_ VGND VGND VPWR VPWR RF0.regs\[7\]\[13\] sky130_fd_sc_hd__dfrtp_1
X_4141_ net71 VGND VGND VPWR VPWR _2203_ sky130_fd_sc_hd__clkbuf_1
X_4072_ _2088_ net259 _2160_ VGND VGND VPWR VPWR _2166_ sky130_fd_sc_hd__mux2_1
X_3023_ _1218_ VGND VGND VPWR VPWR _1219_ sky130_fd_sc_hd__buf_4
X_4974_ _2486_ VGND VGND VPWR VPWR _0359_ sky130_fd_sc_hd__inv_2
X_3925_ _2084_ VGND VGND VPWR VPWR _0657_ sky130_fd_sc_hd__clkbuf_1
XFILLER_0_46_468 VGND VGND VPWR VPWR sky130_fd_sc_hd__fill_2
Xclkload8 clknet_leaf_42_clk VGND VGND VPWR VPWR clkload8/X sky130_fd_sc_hd__clkbuf_4
X_3856_ _1425_ _1427_ VGND VGND VPWR VPWR _2025_ sky130_fd_sc_hd__nand2_1
XFILLER_0_81_3 VPWR VGND VPWR VGND sky130_ef_sc_hd__decap_12
XFILLER_0_73_298 VGND VGND VPWR VPWR sky130_fd_sc_hd__fill_2
X_3787_ _1968_ _1936_ _1606_ _1615_ VGND VGND VPWR VPWR _1969_ sky130_fd_sc_hd__a211o_1
X_2807_ _0898_ _0900_ _1002_ _1004_ VGND VGND VPWR VPWR _1099_ sky130_fd_sc_hd__o22a_1
XFILLER_0_61_449 VPWR VGND VPWR VGND sky130_ef_sc_hd__decap_12
XFILLER_0_14_365 VGND VGND VPWR VPWR sky130_fd_sc_hd__fill_1
X_2738_ RF0.regs\[10\]\[19\] _0816_ _0830_ RF0.regs\[25\]\[19\] _1029_ VGND VGND VPWR
+ VPWR _1030_ sky130_fd_sc_hd__a221o_1
X_4408_ _2341_ VGND VGND VPWR VPWR _0432_ sky130_fd_sc_hd__clkbuf_1
X_2669_ _0901_ VGND VGND VPWR VPWR _0961_ sky130_fd_sc_hd__buf_4
X_5388_ clknet_leaf_44_clk _0764_ _0380_ VGND VGND VPWR VPWR IM0.addr\[19\] sky130_fd_sc_hd__dfrtp_1
XTAP_TAPCELL_ROW_6_247 VGND VPWR sky130_fd_sc_hd__tapvpwrvgnd_1
X_4339_ _2305_ VGND VGND VPWR VPWR _0465_ sky130_fd_sc_hd__clkbuf_1
XFILLER_0_5_93 VGND VGND VPWR VPWR sky130_fd_sc_hd__decap_6
XTAP_TAPCELL_ROW_85_956 VGND VPWR sky130_fd_sc_hd__tapvpwrvgnd_1
XFILLER_0_69_505 VPWR VGND VPWR VGND sky130_ef_sc_hd__decap_12
XFILLER_0_37_457 VGND VGND VPWR VPWR sky130_fd_sc_hd__decap_3
XFILLER_0_64_221 VPWR VGND VPWR VGND sky130_ef_sc_hd__decap_12
XTAP_TAPCELL_ROW_40_547 VGND VPWR sky130_fd_sc_hd__tapvpwrvgnd_1
XFILLER_0_64_265 VGND VGND VPWR VPWR sky130_fd_sc_hd__decap_4
XFILLER_0_32_173 VGND VGND VPWR VPWR sky130_fd_sc_hd__fill_1
XFILLER_0_32_195 VGND VGND VPWR VPWR sky130_fd_sc_hd__fill_1
XFILLER_0_46_49 VGND VGND VPWR VPWR sky130_fd_sc_hd__decap_4
XTAP_TAPCELL_ROW_48_625 VGND VPWR sky130_fd_sc_hd__tapvpwrvgnd_1
XFILLER_0_87_346 VPWR VGND VPWR VGND sky130_ef_sc_hd__decap_12
XTAP_TAPCELL_ROW_56_691 VGND VPWR sky130_fd_sc_hd__tapvpwrvgnd_1
X_3710_ _1877_ _1894_ _1895_ VGND VGND VPWR VPWR _1896_ sky130_fd_sc_hd__o21ba_2
XFILLER_0_55_232 VGND VGND VPWR VPWR sky130_fd_sc_hd__decap_4
X_4690_ _2454_ VGND VGND VPWR VPWR _0107_ sky130_fd_sc_hd__inv_2
XFILLER_0_43_405 VPWR VGND VPWR VGND sky130_ef_sc_hd__decap_12
X_3641_ RF0.regs\[4\]\[7\] _1238_ _1221_ RF0.regs\[20\]\[7\] _1827_ VGND VGND VPWR
+ VPWR _1828_ sky130_fd_sc_hd__a221o_1
XFILLER_0_36_490 VGND VGND VPWR VPWR sky130_fd_sc_hd__decap_3
X_3572_ RF0.regs\[7\]\[13\] _1244_ _1762_ _1763_ VGND VGND VPWR VPWR _1764_ sky130_fd_sc_hd__a211o_1
X_5311_ clknet_leaf_37_clk _0687_ _0303_ VGND VGND VPWR VPWR RF0.regs\[2\]\[6\] sky130_fd_sc_hd__dfrtp_1
X_2523_ _0814_ VGND VGND VPWR VPWR _0815_ sky130_fd_sc_hd__buf_4
X_5242_ clknet_leaf_40_clk _0618_ _0234_ VGND VGND VPWR VPWR RF0.regs\[5\]\[1\] sky130_fd_sc_hd__dfrtp_1
XFILLER_0_53_7 VGND VGND VPWR VPWR sky130_fd_sc_hd__fill_1
X_5173_ clknet_leaf_1_clk _0549_ _0165_ VGND VGND VPWR VPWR RF0.regs\[10\]\[28\] sky130_fd_sc_hd__dfrtp_1
X_4124_ _2194_ VGND VGND VPWR VPWR _0569_ sky130_fd_sc_hd__clkbuf_1
XTAP_TAPCELL_ROW_3_217 VGND VPWR sky130_fd_sc_hd__tapvpwrvgnd_1
Xinput1 control VGND VGND VPWR VPWR net1 sky130_fd_sc_hd__clkbuf_2
X_4055_ _2063_ net190 _2149_ VGND VGND VPWR VPWR _2157_ sky130_fd_sc_hd__mux2_1
XTAP_TAPCELL_ROW_82_926 VGND VPWR sky130_fd_sc_hd__tapvpwrvgnd_1
X_3006_ _1208_ VGND VGND VPWR VPWR _0687_ sky130_fd_sc_hd__clkbuf_1
XTAP_TAPCELL_ROW_19_360 VGND VPWR sky130_fd_sc_hd__tapvpwrvgnd_1
XFILLER_0_66_508 VGND VGND VPWR VPWR sky130_fd_sc_hd__decap_8
X_4957_ _2484_ VGND VGND VPWR VPWR _0344_ sky130_fd_sc_hd__inv_2
XFILLER_0_52_81 VGND VGND VPWR VPWR sky130_fd_sc_hd__decap_3
X_4888_ _2476_ VGND VGND VPWR VPWR _0283_ sky130_fd_sc_hd__inv_2
X_3908_ _2020_ _1794_ VGND VGND VPWR VPWR _2071_ sky130_fd_sc_hd__nor2_2
X_3839_ _2009_ VGND VGND VPWR VPWR _0665_ sky130_fd_sc_hd__clkbuf_1
XFILLER_0_34_438 VPWR VGND VPWR VGND sky130_ef_sc_hd__decap_12
XFILLER_0_42_493 VGND VGND VPWR VPWR sky130_fd_sc_hd__fill_1
Xclkbuf_leaf_39_clk clknet_2_0__leaf_clk VGND VGND VPWR VPWR clknet_leaf_39_clk sky130_fd_sc_hd__clkbuf_8
XFILLER_0_77_390 VGND VGND VPWR VPWR sky130_fd_sc_hd__fill_2
XFILLER_0_25_438 VGND VGND VPWR VPWR sky130_fd_sc_hd__decap_8
XFILLER_0_25_449 VGND VGND VPWR VPWR sky130_fd_sc_hd__fill_2
XFILLER_0_52_224 VGND VGND VPWR VPWR sky130_fd_sc_hd__fill_1
XFILLER_0_52_268 VPWR VGND VPWR VGND sky130_ef_sc_hd__decap_12
XFILLER_0_33_482 VGND VGND VPWR VPWR sky130_fd_sc_hd__decap_3
XFILLER_0_0_505 VPWR VGND VPWR VGND sky130_ef_sc_hd__decap_12
XFILLER_0_20_110 VPWR VGND VPWR VGND sky130_ef_sc_hd__decap_12
XFILLER_0_57_48 VGND VGND VPWR VPWR sky130_fd_sc_hd__decap_4
XPHY_EDGE_ROW_69_Left_157 VGND VGND VPWR VPWR sky130_fd_sc_hd__decap_3
X_4811_ _2468_ VGND VGND VPWR VPWR _0214_ sky130_fd_sc_hd__inv_2
XFILLER_0_75_327 VGND VGND VPWR VPWR sky130_fd_sc_hd__decap_3
XTAP_TAPCELL_ROW_16_330 VGND VPWR sky130_fd_sc_hd__tapvpwrvgnd_1
XFILLER_0_75_349 VGND VGND VPWR VPWR sky130_fd_sc_hd__decap_6
XFILLER_0_28_221 VGND VGND VPWR VPWR sky130_fd_sc_hd__decap_3
X_4742_ _2459_ VGND VGND VPWR VPWR _0154_ sky130_fd_sc_hd__inv_2
XFILLER_0_7_148 VGND VGND VPWR VPWR sky130_fd_sc_hd__decap_3
XFILLER_0_28_265 VGND VGND VPWR VPWR sky130_fd_sc_hd__decap_8
X_4673_ _2450_ VGND VGND VPWR VPWR _0094_ sky130_fd_sc_hd__inv_2
XFILLER_0_16_438 VGND VGND VPWR VPWR sky130_fd_sc_hd__decap_3
XFILLER_0_28_287 VGND VGND VPWR VPWR sky130_fd_sc_hd__decap_8
XFILLER_0_43_235 VGND VGND VPWR VPWR sky130_fd_sc_hd__fill_2
XPHY_EDGE_ROW_78_Left_166 VGND VGND VPWR VPWR sky130_fd_sc_hd__decap_3
X_3624_ _1453_ _1802_ _1008_ VGND VGND VPWR VPWR _1813_ sky130_fd_sc_hd__o21ai_1
X_3555_ _1746_ VGND VGND VPWR VPWR _1747_ sky130_fd_sc_hd__inv_2
X_3486_ RF0.regs\[5\]\[17\] _0866_ _1233_ RF0.regs\[6\]\[17\] _1678_ VGND VGND VPWR
+ VPWR _1679_ sky130_fd_sc_hd__a221o_1
X_2506_ _0797_ VGND VGND VPWR VPWR _0798_ sky130_fd_sc_hd__clkbuf_4
X_5225_ clknet_leaf_18_clk _0601_ _0217_ VGND VGND VPWR VPWR RF0.regs\[6\]\[16\] sky130_fd_sc_hd__dfrtp_1
XPHY_EDGE_ROW_87_Left_175 VGND VGND VPWR VPWR sky130_fd_sc_hd__decap_3
X_5156_ clknet_leaf_26_clk _0532_ _0148_ VGND VGND VPWR VPWR RF0.regs\[10\]\[11\]
+ sky130_fd_sc_hd__dfrtp_1
X_5087_ clknet_leaf_34_clk _0463_ _0079_ VGND VGND VPWR VPWR RF0.regs\[15\]\[6\] sky130_fd_sc_hd__dfrtp_1
X_4107_ net120 VGND VGND VPWR VPWR _2186_ sky130_fd_sc_hd__clkbuf_1
X_4038_ _1988_ net246 _2138_ VGND VGND VPWR VPWR _2148_ sky130_fd_sc_hd__mux2_1
XFILLER_0_2_83 VGND VGND VPWR VPWR sky130_fd_sc_hd__fill_1
XTAP_TAPCELL_ROW_50_642 VGND VPWR sky130_fd_sc_hd__tapvpwrvgnd_1
XFILLER_0_74_382 VGND VGND VPWR VPWR sky130_fd_sc_hd__fill_1
XTAP_TAPCELL_ROW_22_388 VGND VPWR sky130_fd_sc_hd__tapvpwrvgnd_1
XFILLER_0_22_408 VGND VGND VPWR VPWR sky130_fd_sc_hd__decap_4
XFILLER_0_69_143 VPWR VGND VPWR VGND sky130_ef_sc_hd__decap_12
XFILLER_0_25_202 VGND VGND VPWR VPWR sky130_fd_sc_hd__fill_1
XFILLER_0_4_107 VGND VGND VPWR VPWR sky130_fd_sc_hd__fill_2
XFILLER_0_80_374 VPWR VGND VPWR VGND sky130_ef_sc_hd__decap_12
XFILLER_0_40_216 VGND VGND VPWR VPWR sky130_fd_sc_hd__fill_1
XFILLER_0_7_39 VPWR VGND VPWR VGND sky130_ef_sc_hd__decap_12
XFILLER_0_0_335 VGND VGND VPWR VPWR sky130_fd_sc_hd__fill_1
X_3340_ _1327_ _1535_ _1324_ VGND VGND VPWR VPWR _1536_ sky130_fd_sc_hd__mux2_1
XFILLER_0_21_485 VPWR VGND VPWR VGND sky130_ef_sc_hd__decap_12
X_5010_ clknet_leaf_32_clk _0000_ VGND VGND VPWR VPWR net38 sky130_fd_sc_hd__dfxtp_1
X_3271_ _1465_ _1466_ _1373_ VGND VGND VPWR VPWR _1467_ sky130_fd_sc_hd__or3_1
XFILLER_0_17_51 VGND VGND VPWR VPWR sky130_fd_sc_hd__decap_4
XFILLER_0_17_84 VGND VGND VPWR VPWR sky130_fd_sc_hd__fill_1
XTAP_TAPCELL_ROW_64_767 VGND VPWR sky130_fd_sc_hd__tapvpwrvgnd_1
XFILLER_0_75_179 VGND VGND VPWR VPWR sky130_fd_sc_hd__decap_6
XFILLER_0_75_157 VGND VGND VPWR VPWR sky130_fd_sc_hd__fill_2
X_2986_ _1198_ VGND VGND VPWR VPWR _0697_ sky130_fd_sc_hd__clkbuf_1
X_4725_ _2458_ VGND VGND VPWR VPWR _0138_ sky130_fd_sc_hd__inv_2
X_4656_ _2448_ VGND VGND VPWR VPWR _0079_ sky130_fd_sc_hd__inv_2
X_4587_ _2439_ VGND VGND VPWR VPWR _0019_ sky130_fd_sc_hd__inv_2
X_3607_ RF0.regs\[7\]\[10\] _1243_ VGND VGND VPWR VPWR _1797_ sky130_fd_sc_hd__and2_1
X_3538_ _1727_ _1729_ VGND VGND VPWR VPWR _1730_ sky130_fd_sc_hd__nand2_1
X_3469_ _1661_ _1662_ VGND VGND VPWR VPWR _1663_ sky130_fd_sc_hd__or2_1
X_5208_ clknet_leaf_45_clk _0584_ _0200_ VGND VGND VPWR VPWR RF0.regs\[7\]\[31\] sky130_fd_sc_hd__dfrtp_1
X_5139_ clknet_leaf_6_clk _0515_ _0131_ VGND VGND VPWR VPWR RF0.regs\[12\]\[26\] sky130_fd_sc_hd__dfrtp_1
XFILLER_0_79_452 VGND VGND VPWR VPWR sky130_fd_sc_hd__fill_1
XTAP_TAPCELL_ROW_27_436 VGND VPWR sky130_fd_sc_hd__tapvpwrvgnd_1
XFILLER_0_81_149 VGND VGND VPWR VPWR sky130_fd_sc_hd__decap_3
XFILLER_0_62_363 VGND VGND VPWR VPWR sky130_fd_sc_hd__fill_1
XFILLER_0_38_39 VGND VGND VPWR VPWR sky130_fd_sc_hd__fill_2
XFILLER_0_70_15 VPWR VGND VPWR VGND sky130_ef_sc_hd__decap_12
XFILLER_0_57_135 VPWR VGND VPWR VGND sky130_ef_sc_hd__decap_12
X_2840_ _1120_ VGND VGND VPWR VPWR _0765_ sky130_fd_sc_hd__clkbuf_1
XFILLER_0_45_308 VGND VGND VPWR VPWR sky130_fd_sc_hd__fill_2
XTAP_TAPCELL_ROW_61_737 VGND VPWR sky130_fd_sc_hd__tapvpwrvgnd_1
X_2771_ RF0.regs\[15\]\[22\] _0854_ VGND VGND VPWR VPWR _1063_ sky130_fd_sc_hd__and2_1
XFILLER_0_5_405 VPWR VGND VPWR VGND sky130_ef_sc_hd__decap_12
XFILLER_0_5_449 VPWR VGND VPWR VGND sky130_ef_sc_hd__decap_12
X_4510_ disp.digits\[2\] _0777_ _2396_ VGND VGND VPWR VPWR _2399_ sky130_fd_sc_hd__o21a_1
XFILLER_0_79_57 VPWR VGND VPWR VGND sky130_ef_sc_hd__decap_12
Xhold117 IM0.addr\[26\] VGND VGND VPWR VPWR net165 sky130_fd_sc_hd__dlygate4sd3_1
Xhold106 RF0.regs\[2\]\[12\] VGND VGND VPWR VPWR net154 sky130_fd_sc_hd__dlygate4sd3_1
X_4441_ _2358_ VGND VGND VPWR VPWR _0416_ sky130_fd_sc_hd__clkbuf_1
Xhold128 IM0.addr\[30\] VGND VGND VPWR VPWR net176 sky130_fd_sc_hd__dlygate4sd3_1
XPHY_EDGE_ROW_9_Right_9 VGND VGND VPWR VPWR sky130_fd_sc_hd__decap_3
Xhold139 RF0.regs\[2\]\[21\] VGND VGND VPWR VPWR net187 sky130_fd_sc_hd__dlygate4sd3_1
X_4372_ _2322_ VGND VGND VPWR VPWR _0449_ sky130_fd_sc_hd__clkbuf_1
X_3323_ RF0.regs\[10\]\[20\] _0812_ _1221_ RF0.regs\[25\]\[20\] VGND VGND VPWR VPWR
+ _1519_ sky130_fd_sc_hd__a22o_1
X_3254_ _1448_ _1449_ _1340_ VGND VGND VPWR VPWR _1450_ sky130_fd_sc_hd__o21ba_1
X_3185_ _1377_ _1379_ VGND VGND VPWR VPWR _1381_ sky130_fd_sc_hd__nand2_2
XTAP_TAPCELL_ROW_77_881 VGND VPWR sky130_fd_sc_hd__tapvpwrvgnd_1
XFILLER_0_76_411 VGND VGND VPWR VPWR sky130_fd_sc_hd__decap_8
XTAP_TAPCELL_ROW_24_406 VGND VPWR sky130_fd_sc_hd__tapvpwrvgnd_1
XFILLER_0_48_135 VGND VGND VPWR VPWR sky130_fd_sc_hd__fill_2
XFILLER_0_76_477 VPWR VGND VPWR VGND sky130_ef_sc_hd__decap_12
X_2969_ net150 VGND VGND VPWR VPWR _1190_ sky130_fd_sc_hd__clkbuf_1
X_4708_ _2455_ VGND VGND VPWR VPWR _0124_ sky130_fd_sc_hd__inv_2
X_4639_ _2445_ VGND VGND VPWR VPWR _0065_ sky130_fd_sc_hd__inv_2
XFILLER_0_67_411 VGND VGND VPWR VPWR sky130_fd_sc_hd__decap_4
XFILLER_0_54_127 VGND VGND VPWR VPWR sky130_fd_sc_hd__decap_4
XFILLER_0_82_469 VGND VGND VPWR VPWR sky130_fd_sc_hd__decap_6
XFILLER_0_40_29 VGND VGND VPWR VPWR sky130_fd_sc_hd__fill_2
XFILLER_0_2_419 VGND VGND VPWR VPWR sky130_fd_sc_hd__fill_1
XFILLER_0_4_29 VPWR VGND VPWR VGND sky130_ef_sc_hd__decap_12
XFILLER_0_65_15 VGND VGND VPWR VPWR sky130_fd_sc_hd__fill_2
XFILLER_0_65_37 VGND VGND VPWR VPWR sky130_fd_sc_hd__fill_1
XTAP_TAPCELL_ROW_74_851 VGND VPWR sky130_fd_sc_hd__tapvpwrvgnd_1
XFILLER_0_81_69 VPWR VGND VPWR VGND sky130_ef_sc_hd__decap_12
X_4990_ _2487_ VGND VGND VPWR VPWR _0374_ sky130_fd_sc_hd__inv_2
XFILLER_0_58_433 VGND VGND VPWR VPWR sky130_fd_sc_hd__decap_8
XFILLER_0_14_41 VPWR VGND VPWR VGND sky130_ef_sc_hd__decap_12
X_3941_ _2095_ VGND VGND VPWR VPWR _0652_ sky130_fd_sc_hd__clkbuf_1
XFILLER_0_58_477 VPWR VGND VPWR VGND sky130_ef_sc_hd__decap_12
XFILLER_0_14_85 VGND VGND VPWR VPWR sky130_fd_sc_hd__fill_2
X_3872_ net67 _0957_ _1258_ VGND VGND VPWR VPWR _2038_ sky130_fd_sc_hd__mux2_1
X_2823_ _1108_ net161 VGND VGND VPWR VPWR _1111_ sky130_fd_sc_hd__and2_1
X_2754_ RF0.regs\[4\]\[4\] _0834_ _0842_ RF0.regs\[12\]\[4\] VGND VGND VPWR VPWR _1046_
+ sky130_fd_sc_hd__a22o_1
X_2685_ RF0.regs\[4\]\[11\] _0835_ _0843_ RF0.regs\[12\]\[11\] VGND VGND VPWR VPWR
+ _0977_ sky130_fd_sc_hd__a22o_1
XFILLER_0_1_441 VGND VGND VPWR VPWR sky130_fd_sc_hd__decap_6
X_4424_ RF0.regs\[25\]\[31\] _1952_ _2349_ VGND VGND VPWR VPWR _2350_ sky130_fd_sc_hd__mux2_1
X_4355_ _2313_ VGND VGND VPWR VPWR _0457_ sky130_fd_sc_hd__clkbuf_1
XFILLER_0_1_485 VPWR VGND VPWR VGND sky130_ef_sc_hd__decap_12
X_3306_ _1252_ _1322_ VGND VGND VPWR VPWR _1502_ sky130_fd_sc_hd__nor2_1
X_4286_ RF0.regs\[12\]\[0\] VGND VGND VPWR VPWR _2277_ sky130_fd_sc_hd__clkbuf_1
X_3237_ _1295_ _1296_ VGND VGND VPWR VPWR _1433_ sky130_fd_sc_hd__nor2_1
X_3168_ _1363_ VGND VGND VPWR VPWR _1364_ sky130_fd_sc_hd__inv_2
XTAP_TAPCELL_ROW_37_520 VGND VPWR sky130_fd_sc_hd__tapvpwrvgnd_1
X_3099_ net65 _1276_ _1294_ _1293_ VGND VGND VPWR VPWR _1295_ sky130_fd_sc_hd__a211oi_4
XFILLER_0_64_414 VGND VGND VPWR VPWR sky130_fd_sc_hd__decap_3
XFILLER_0_36_138 VGND VGND VPWR VPWR sky130_fd_sc_hd__fill_2
XFILLER_0_36_149 VGND VGND VPWR VPWR sky130_fd_sc_hd__fill_2
XFILLER_0_17_341 VGND VGND VPWR VPWR sky130_fd_sc_hd__fill_1
XTAP_TAPCELL_ROW_9_267 VGND VPWR sky130_fd_sc_hd__tapvpwrvgnd_1
XTAP_TAPCELL_ROW_71_832 VGND VPWR sky130_fd_sc_hd__tapvpwrvgnd_1
XTAP_TAPCELL_ROW_43_578 VGND VPWR sky130_fd_sc_hd__tapvpwrvgnd_1
XFILLER_0_55_436 VPWR VGND VPWR VGND sky130_ef_sc_hd__decap_12
Xclkload26 clknet_leaf_31_clk VGND VGND VPWR VPWR clkload26/Y sky130_fd_sc_hd__inv_8
XPHY_EDGE_ROW_41_Left_129 VGND VGND VPWR VPWR sky130_fd_sc_hd__decap_3
Xclkload15 clknet_leaf_7_clk VGND VGND VPWR VPWR clkload15/X sky130_fd_sc_hd__clkbuf_4
Xclkload37 clknet_leaf_20_clk VGND VGND VPWR VPWR clkload37/Y sky130_fd_sc_hd__clkinv_4
XFILLER_0_2_227 VPWR VGND VPWR VGND sky130_ef_sc_hd__decap_12
X_4140_ _2202_ VGND VGND VPWR VPWR _0561_ sky130_fd_sc_hd__clkbuf_1
X_4071_ _2165_ VGND VGND VPWR VPWR _0592_ sky130_fd_sc_hd__clkbuf_1
XPHY_EDGE_ROW_50_Left_138 VGND VGND VPWR VPWR sky130_fd_sc_hd__decap_3
X_3022_ _1217_ VGND VGND VPWR VPWR _1218_ sky130_fd_sc_hd__buf_4
X_4973_ _2486_ VGND VGND VPWR VPWR _0358_ sky130_fd_sc_hd__inv_2
X_3924_ RF0.regs\[4\]\[8\] _2083_ _2073_ VGND VGND VPWR VPWR _2084_ sky130_fd_sc_hd__mux2_1
XFILLER_0_58_285 VGND VGND VPWR VPWR sky130_fd_sc_hd__decap_3
XFILLER_0_18_138 VGND VGND VPWR VPWR sky130_fd_sc_hd__fill_2
Xclkload9 clknet_leaf_43_clk VGND VGND VPWR VPWR clkload9/Y sky130_fd_sc_hd__clkinv_2
X_3855_ _1438_ VGND VGND VPWR VPWR _2024_ sky130_fd_sc_hd__inv_2
X_2806_ _0892_ _0895_ _1094_ _1096_ _1097_ VGND VGND VPWR VPWR _1098_ sky130_fd_sc_hd__o221a_1
X_3786_ _1629_ _1933_ VGND VGND VPWR VPWR _1968_ sky130_fd_sc_hd__or2_1
XFILLER_0_14_344 VGND VGND VPWR VPWR sky130_fd_sc_hd__fill_2
X_2737_ RF0.regs\[4\]\[19\] _0839_ _0845_ RF0.regs\[12\]\[19\] VGND VGND VPWR VPWR
+ _1029_ sky130_fd_sc_hd__a22o_1
XFILLER_0_74_3 VPWR VGND VPWR VGND sky130_ef_sc_hd__decap_12
X_2668_ _0957_ _0959_ VGND VGND VPWR VPWR _0960_ sky130_fd_sc_hd__xor2_1
XFILLER_0_41_185 VGND VGND VPWR VPWR sky130_fd_sc_hd__fill_2
X_4407_ net219 _2086_ _2336_ VGND VGND VPWR VPWR _2341_ sky130_fd_sc_hd__mux2_1
X_5387_ clknet_leaf_44_clk _0763_ _0379_ VGND VGND VPWR VPWR IM0.addr\[18\] sky130_fd_sc_hd__dfrtp_1
X_2599_ RF0.regs\[4\]\[29\] _0838_ _0845_ RF0.regs\[12\]\[29\] VGND VGND VPWR VPWR
+ _0891_ sky130_fd_sc_hd__a22o_1
X_4338_ RF0.regs\[15\]\[8\] _2083_ _2301_ VGND VGND VPWR VPWR _2305_ sky130_fd_sc_hd__mux2_1
X_4269_ _2268_ VGND VGND VPWR VPWR _0498_ sky130_fd_sc_hd__clkbuf_1
XTAP_TAPCELL_ROW_85_957 VGND VPWR sky130_fd_sc_hd__tapvpwrvgnd_1
XFILLER_0_37_425 VGND VGND VPWR VPWR sky130_fd_sc_hd__fill_2
XFILLER_0_64_233 VPWR VGND VPWR VGND sky130_ef_sc_hd__decap_12
XTAP_TAPCELL_ROW_40_548 VGND VPWR sky130_fd_sc_hd__tapvpwrvgnd_1
XFILLER_0_32_141 VGND VGND VPWR VPWR sky130_fd_sc_hd__decap_8
XFILLER_0_32_152 VGND VGND VPWR VPWR sky130_fd_sc_hd__fill_2
XFILLER_0_20_358 VGND VGND VPWR VPWR sky130_fd_sc_hd__decap_6
XFILLER_0_87_303 VGND VGND VPWR VPWR sky130_fd_sc_hd__fill_2
XFILLER_0_62_27 VGND VGND VPWR VPWR sky130_fd_sc_hd__fill_1
XFILLER_0_87_358 VGND VGND VPWR VPWR sky130_fd_sc_hd__decap_6
XTAP_TAPCELL_ROW_56_692 VGND VPWR sky130_fd_sc_hd__tapvpwrvgnd_1
XFILLER_0_43_417 VPWR VGND VPWR VGND sky130_ef_sc_hd__decap_12
XFILLER_0_3_503 VGND VGND VPWR VPWR sky130_fd_sc_hd__fill_1
X_3640_ RF0.regs\[10\]\[7\] _0885_ _0812_ RF0.regs\[25\]\[7\] _0795_ VGND VGND VPWR
+ VPWR _1827_ sky130_fd_sc_hd__a221o_1
XFILLER_0_43_439 VGND VGND VPWR VPWR sky130_fd_sc_hd__decap_3
X_3571_ RF0.regs\[4\]\[13\] _1239_ _1232_ RF0.regs\[6\]\[13\] VGND VGND VPWR VPWR
+ _1763_ sky130_fd_sc_hd__a22o_1
X_5310_ clknet_leaf_34_clk _0686_ _0302_ VGND VGND VPWR VPWR RF0.regs\[2\]\[5\] sky130_fd_sc_hd__dfrtp_1
XFILLER_0_51_461 VGND VGND VPWR VPWR sky130_fd_sc_hd__decap_8
X_2522_ _0813_ VGND VGND VPWR VPWR _0814_ sky130_fd_sc_hd__buf_4
XFILLER_0_87_57 VPWR VGND VPWR VGND sky130_ef_sc_hd__decap_12
X_5241_ clknet_leaf_42_clk _0617_ _0233_ VGND VGND VPWR VPWR RF0.regs\[5\]\[0\] sky130_fd_sc_hd__dfrtp_1
X_5172_ clknet_leaf_1_clk _0548_ _0164_ VGND VGND VPWR VPWR RF0.regs\[10\]\[27\] sky130_fd_sc_hd__dfrtp_2
X_4123_ net151 VGND VGND VPWR VPWR _2194_ sky130_fd_sc_hd__clkbuf_1
X_4054_ _2156_ VGND VGND VPWR VPWR _0600_ sky130_fd_sc_hd__clkbuf_1
XTAP_TAPCELL_ROW_3_218 VGND VPWR sky130_fd_sc_hd__tapvpwrvgnd_1
X_3005_ net123 VGND VGND VPWR VPWR _1208_ sky130_fd_sc_hd__clkbuf_1
XTAP_TAPCELL_ROW_82_927 VGND VPWR sky130_fd_sc_hd__tapvpwrvgnd_1
XTAP_TAPCELL_ROW_19_361 VGND VPWR sky130_fd_sc_hd__tapvpwrvgnd_1
X_4956_ _2484_ VGND VGND VPWR VPWR _0343_ sky130_fd_sc_hd__inv_2
XFILLER_0_19_447 VGND VGND VPWR VPWR sky130_fd_sc_hd__fill_1
XFILLER_0_46_233 VGND VGND VPWR VPWR sky130_fd_sc_hd__fill_1
X_4887_ _2476_ VGND VGND VPWR VPWR _0282_ sky130_fd_sc_hd__inv_2
X_3907_ _2070_ VGND VGND VPWR VPWR _0661_ sky130_fd_sc_hd__clkbuf_1
X_3838_ RF0.regs\[4\]\[16\] _2008_ _1993_ VGND VGND VPWR VPWR _2009_ sky130_fd_sc_hd__mux2_1
XFILLER_0_6_341 VGND VGND VPWR VPWR sky130_fd_sc_hd__fill_2
XFILLER_0_14_141 VGND VGND VPWR VPWR sky130_fd_sc_hd__fill_2
XFILLER_0_6_385 VGND VGND VPWR VPWR sky130_fd_sc_hd__decap_6
X_3769_ _1954_ VGND VGND VPWR VPWR _0680_ sky130_fd_sc_hd__clkbuf_1
XTAP_TAPCELL_ROW_53_662 VGND VPWR sky130_fd_sc_hd__tapvpwrvgnd_1
XFILLER_0_80_501 VPWR VGND VPWR VGND sky130_ef_sc_hd__decap_12
XFILLER_0_37_277 VGND VGND VPWR VPWR sky130_fd_sc_hd__decap_3
XFILLER_0_37_299 VGND VGND VPWR VPWR sky130_fd_sc_hd__decap_3
XFILLER_0_20_100 VGND VGND VPWR VPWR sky130_fd_sc_hd__fill_1
XFILLER_0_20_122 VGND VGND VPWR VPWR sky130_fd_sc_hd__decap_4
XFILLER_0_73_15 VPWR VGND VPWR VGND sky130_ef_sc_hd__decap_12
XTAP_TAPCELL_ROW_16_331 VGND VPWR sky130_fd_sc_hd__tapvpwrvgnd_1
X_4810_ _2468_ VGND VGND VPWR VPWR _0213_ sky130_fd_sc_hd__inv_2
XFILLER_0_71_501 VGND VGND VPWR VPWR sky130_fd_sc_hd__decap_3
XFILLER_0_22_41 VGND VGND VPWR VPWR sky130_fd_sc_hd__decap_3
XFILLER_0_22_52 VPWR VGND VPWR VGND sky130_ef_sc_hd__decap_12
X_4741_ _2459_ VGND VGND VPWR VPWR _0153_ sky130_fd_sc_hd__inv_2
X_4672_ _2450_ VGND VGND VPWR VPWR _0093_ sky130_fd_sc_hd__inv_2
XFILLER_0_43_225 VGND VGND VPWR VPWR sky130_fd_sc_hd__decap_4
XFILLER_0_22_96 VGND VGND VPWR VPWR sky130_fd_sc_hd__fill_2
X_3623_ _1811_ VGND VGND VPWR VPWR _1812_ sky130_fd_sc_hd__inv_2
X_3554_ _1738_ _1745_ VGND VGND VPWR VPWR _1746_ sky130_fd_sc_hd__nand2_1
X_2505_ _0795_ _0796_ VGND VGND VPWR VPWR _0797_ sky130_fd_sc_hd__or2_4
X_3485_ RF0.regs\[25\]\[17\] _0815_ _0903_ _1246_ VGND VGND VPWR VPWR _1678_ sky130_fd_sc_hd__a211o_1
X_5224_ clknet_leaf_18_clk _0600_ _0216_ VGND VGND VPWR VPWR RF0.regs\[6\]\[15\] sky130_fd_sc_hd__dfrtp_1
XFILLER_0_11_177 VGND VGND VPWR VPWR sky130_fd_sc_hd__fill_2
X_5155_ clknet_leaf_26_clk _0531_ _0147_ VGND VGND VPWR VPWR RF0.regs\[10\]\[10\]
+ sky130_fd_sc_hd__dfrtp_1
X_5086_ clknet_leaf_34_clk _0462_ _0078_ VGND VGND VPWR VPWR RF0.regs\[15\]\[5\] sky130_fd_sc_hd__dfrtp_1
X_4106_ _2185_ VGND VGND VPWR VPWR _0578_ sky130_fd_sc_hd__clkbuf_1
X_4037_ _2147_ VGND VGND VPWR VPWR _0608_ sky130_fd_sc_hd__clkbuf_1
X_4939_ _2482_ VGND VGND VPWR VPWR _0328_ sky130_fd_sc_hd__inv_2
XTAP_TAPCELL_ROW_50_643 VGND VPWR sky130_fd_sc_hd__tapvpwrvgnd_1
XTAP_TAPCELL_ROW_22_389 VGND VPWR sky130_fd_sc_hd__tapvpwrvgnd_1
XTAP_TAPCELL_ROW_58_710 VGND VPWR sky130_fd_sc_hd__tapvpwrvgnd_1
XFILLER_0_69_100 VGND VGND VPWR VPWR sky130_fd_sc_hd__fill_2
XFILLER_0_69_155 VGND VGND VPWR VPWR sky130_fd_sc_hd__decap_3
XFILLER_0_65_350 VGND VGND VPWR VPWR sky130_fd_sc_hd__fill_2
XFILLER_0_80_386 VGND VGND VPWR VPWR sky130_fd_sc_hd__decap_3
XFILLER_0_68_15 VPWR VGND VPWR VGND sky130_ef_sc_hd__decap_12
X_3270_ _0926_ _1367_ VGND VGND VPWR VPWR _1466_ sky130_fd_sc_hd__nor2_1
XTAP_TAPCELL_ROW_64_768 VGND VPWR sky130_fd_sc_hd__tapvpwrvgnd_1
XFILLER_0_75_169 VGND VGND VPWR VPWR sky130_fd_sc_hd__decap_4
X_4724_ _2458_ VGND VGND VPWR VPWR _0137_ sky130_fd_sc_hd__inv_2
X_2985_ net85 VGND VGND VPWR VPWR _1198_ sky130_fd_sc_hd__clkbuf_1
XFILLER_0_71_331 VGND VGND VPWR VPWR sky130_fd_sc_hd__decap_4
XFILLER_0_71_353 VGND VGND VPWR VPWR sky130_fd_sc_hd__fill_1
X_4655_ _2448_ VGND VGND VPWR VPWR _0078_ sky130_fd_sc_hd__inv_2
XFILLER_0_24_280 VGND VGND VPWR VPWR sky130_fd_sc_hd__fill_1
X_4586_ _2439_ VGND VGND VPWR VPWR _0018_ sky130_fd_sc_hd__inv_2
X_3606_ RF0.regs\[6\]\[10\] _1231_ _1227_ RF0.regs\[15\]\[10\] _1795_ VGND VGND VPWR
+ VPWR _1796_ sky130_fd_sc_hd__a221o_1
X_3537_ _0798_ _1475_ _1728_ VGND VGND VPWR VPWR _1729_ sky130_fd_sc_hd__or3_1
X_3468_ _1658_ _1660_ VGND VGND VPWR VPWR _1662_ sky130_fd_sc_hd__and2_1
X_5207_ clknet_leaf_2_clk _0583_ _0199_ VGND VGND VPWR VPWR RF0.regs\[7\]\[30\] sky130_fd_sc_hd__dfrtp_1
X_3399_ RF0.regs\[4\]\[27\] _1240_ _1233_ RF0.regs\[6\]\[27\] _1592_ VGND VGND VPWR
+ VPWR _1593_ sky130_fd_sc_hd__a221o_1
X_5138_ clknet_leaf_7_clk _0514_ _0130_ VGND VGND VPWR VPWR RF0.regs\[12\]\[25\] sky130_fd_sc_hd__dfrtp_1
X_5069_ clknet_leaf_11_clk _0445_ _0061_ VGND VGND VPWR VPWR RF0.regs\[20\]\[20\]
+ sky130_fd_sc_hd__dfrtp_1
XFILLER_0_54_309 VGND VGND VPWR VPWR sky130_fd_sc_hd__decap_3
XFILLER_0_35_512 VGND VGND VPWR VPWR sky130_fd_sc_hd__fill_1
XFILLER_0_50_515 VGND VGND VPWR VPWR sky130_fd_sc_hd__fill_2
XFILLER_0_30_294 VGND VGND VPWR VPWR sky130_fd_sc_hd__decap_3
XFILLER_0_38_29 VGND VGND VPWR VPWR sky130_fd_sc_hd__fill_1
XFILLER_0_70_27 VGND VGND VPWR VPWR sky130_fd_sc_hd__fill_1
XTAP_TAPCELL_ROW_61_738 VGND VPWR sky130_fd_sc_hd__tapvpwrvgnd_1
XFILLER_0_26_512 VGND VGND VPWR VPWR sky130_fd_sc_hd__fill_1
XFILLER_0_38_361 VGND VGND VPWR VPWR sky130_fd_sc_hd__decap_3
XFILLER_0_38_372 VGND VGND VPWR VPWR sky130_fd_sc_hd__decap_8
XFILLER_0_5_417 VPWR VGND VPWR VGND sky130_ef_sc_hd__decap_12
X_2770_ RF0.regs\[10\]\[22\] _0884_ VGND VGND VPWR VPWR _1062_ sky130_fd_sc_hd__and2_1
XFILLER_0_79_69 VGND VGND VPWR VPWR sky130_fd_sc_hd__decap_6
Xhold107 RF0.regs\[7\]\[1\] VGND VGND VPWR VPWR net155 sky130_fd_sc_hd__dlygate4sd3_1
X_4440_ RF0.regs\[25\]\[23\] _1986_ _2349_ VGND VGND VPWR VPWR _2358_ sky130_fd_sc_hd__mux2_1
Xhold118 RF0.regs\[0\]\[18\] VGND VGND VPWR VPWR net166 sky130_fd_sc_hd__dlygate4sd3_1
Xhold129 IM0.addr\[18\] VGND VGND VPWR VPWR net177 sky130_fd_sc_hd__dlygate4sd3_1
X_4371_ net179 _1981_ _2314_ VGND VGND VPWR VPWR _2322_ sky130_fd_sc_hd__mux2_1
XFILLER_0_0_177 VPWR VGND VPWR VGND sky130_ef_sc_hd__decap_12
X_3322_ _1025_ _1514_ VGND VGND VPWR VPWR _1518_ sky130_fd_sc_hd__and2_1
X_3253_ _1275_ _1295_ _1296_ _1264_ VGND VGND VPWR VPWR _1449_ sky130_fd_sc_hd__a31o_1
XFILLER_0_28_51 VGND VGND VPWR VPWR sky130_fd_sc_hd__decap_8
X_3184_ _1377_ _1379_ VGND VGND VPWR VPWR _1380_ sky130_fd_sc_hd__nor2_1
XTAP_TAPCELL_ROW_77_882 VGND VPWR sky130_fd_sc_hd__tapvpwrvgnd_1
XTAP_TAPCELL_ROW_24_407 VGND VPWR sky130_fd_sc_hd__tapvpwrvgnd_1
XFILLER_0_44_83 VGND VGND VPWR VPWR sky130_fd_sc_hd__fill_1
XFILLER_0_76_445 VGND VGND VPWR VPWR sky130_fd_sc_hd__decap_4
XFILLER_0_76_489 VPWR VGND VPWR VGND sky130_ef_sc_hd__decap_12
XFILLER_0_63_117 VGND VGND VPWR VPWR sky130_fd_sc_hd__fill_1
XTAP_TAPCELL_ROW_32_473 VGND VPWR sky130_fd_sc_hd__tapvpwrvgnd_1
XFILLER_0_44_342 VGND VGND VPWR VPWR sky130_fd_sc_hd__fill_2
X_2968_ _1189_ VGND VGND VPWR VPWR _0706_ sky130_fd_sc_hd__clkbuf_1
X_4707_ _2455_ VGND VGND VPWR VPWR _0123_ sky130_fd_sc_hd__inv_2
X_4638_ _2445_ VGND VGND VPWR VPWR _0064_ sky130_fd_sc_hd__inv_2
X_2899_ net122 VGND VGND VPWR VPWR _1155_ sky130_fd_sc_hd__clkbuf_1
XFILLER_0_8_83 VGND VGND VPWR VPWR sky130_fd_sc_hd__fill_1
XFILLER_0_12_261 VGND VGND VPWR VPWR sky130_fd_sc_hd__fill_2
X_4569_ _2433_ VGND VGND VPWR VPWR net25 sky130_fd_sc_hd__buf_1
XFILLER_0_39_169 VGND VGND VPWR VPWR sky130_fd_sc_hd__decap_4
XFILLER_0_35_375 VGND VGND VPWR VPWR sky130_fd_sc_hd__fill_1
XFILLER_0_62_161 VPWR VGND VPWR VGND sky130_ef_sc_hd__decap_12
XFILLER_0_81_15 VPWR VGND VPWR VGND sky130_ef_sc_hd__decap_12
XTAP_TAPCELL_ROW_74_852 VGND VPWR sky130_fd_sc_hd__tapvpwrvgnd_1
X_3940_ RF0.regs\[4\]\[3\] _2094_ _2073_ VGND VGND VPWR VPWR _2095_ sky130_fd_sc_hd__mux2_1
XFILLER_0_14_53 VPWR VGND VPWR VGND sky130_ef_sc_hd__decap_12
XFILLER_0_73_426 VGND VGND VPWR VPWR sky130_fd_sc_hd__fill_2
XFILLER_0_73_415 VGND VGND VPWR VPWR sky130_fd_sc_hd__decap_8
X_3871_ _1893_ _1884_ VGND VGND VPWR VPWR _2037_ sky130_fd_sc_hd__or2b_2
XFILLER_0_58_489 VPWR VGND VPWR VGND sky130_ef_sc_hd__decap_12
X_2822_ _1110_ VGND VGND VPWR VPWR _0773_ sky130_fd_sc_hd__clkbuf_1
XFILLER_0_5_203 VGND VGND VPWR VPWR sky130_fd_sc_hd__decap_8
XFILLER_0_5_214 VGND VGND VPWR VPWR sky130_fd_sc_hd__fill_1
X_2753_ RF0.regs\[2\]\[4\] _0877_ _1043_ _1044_ VGND VGND VPWR VPWR _1045_ sky130_fd_sc_hd__a211oi_4
XFILLER_0_30_41 VGND VGND VPWR VPWR sky130_fd_sc_hd__fill_1
XFILLER_0_41_312 VGND VGND VPWR VPWR sky130_fd_sc_hd__decap_3
X_2684_ RF0.regs\[5\]\[11\] _0876_ _0856_ RF0.regs\[15\]\[11\] _0975_ VGND VGND VPWR
+ VPWR _0976_ sky130_fd_sc_hd__a221o_1
X_4423_ _0817_ VGND VGND VPWR VPWR _2349_ sky130_fd_sc_hd__buf_4
X_4354_ RF0.regs\[15\]\[0\] _2177_ _2278_ VGND VGND VPWR VPWR _2313_ sky130_fd_sc_hd__mux2_1
XFILLER_0_1_497 VGND VGND VPWR VPWR sky130_fd_sc_hd__decap_6
X_3305_ _1475_ _1496_ _1500_ VGND VGND VPWR VPWR _1501_ sky130_fd_sc_hd__a21oi_4
X_4285_ _2276_ VGND VGND VPWR VPWR _0490_ sky130_fd_sc_hd__clkbuf_1
X_3236_ _1295_ _1296_ VGND VGND VPWR VPWR _1432_ sky130_fd_sc_hd__and2_1
X_3167_ _0937_ _1362_ VGND VGND VPWR VPWR _1363_ sky130_fd_sc_hd__xnor2_2
X_3098_ net65 _0944_ VGND VGND VPWR VPWR _1294_ sky130_fd_sc_hd__and2_1
XTAP_TAPCELL_ROW_37_521 VGND VPWR sky130_fd_sc_hd__tapvpwrvgnd_1
XFILLER_0_68_209 VGND VGND VPWR VPWR sky130_fd_sc_hd__decap_3
XFILLER_0_76_253 VPWR VGND VPWR VGND sky130_ef_sc_hd__decap_12
XFILLER_0_49_445 VGND VGND VPWR VPWR sky130_fd_sc_hd__decap_3
XFILLER_0_17_375 VGND VGND VPWR VPWR sky130_fd_sc_hd__fill_1
XFILLER_0_44_161 VGND VGND VPWR VPWR sky130_fd_sc_hd__decap_8
XFILLER_0_44_194 VGND VGND VPWR VPWR sky130_fd_sc_hd__fill_2
XTAP_TAPCELL_ROW_9_268 VGND VPWR sky130_fd_sc_hd__tapvpwrvgnd_1
XTAP_TAPCELL_ROW_0_190 VGND VPWR sky130_fd_sc_hd__tapvpwrvgnd_1
XFILLER_0_51_18 VGND VGND VPWR VPWR sky130_fd_sc_hd__decap_3
XFILLER_0_51_29 VGND VGND VPWR VPWR sky130_fd_sc_hd__decap_8
XFILLER_0_55_426 VGND VGND VPWR VPWR sky130_fd_sc_hd__fill_1
XTAP_TAPCELL_ROW_43_579 VGND VPWR sky130_fd_sc_hd__tapvpwrvgnd_1
XFILLER_0_42_109 VGND VGND VPWR VPWR sky130_fd_sc_hd__fill_1
Xclkload16 clknet_leaf_8_clk VGND VGND VPWR VPWR clkload16/Y sky130_fd_sc_hd__clkinvlp_4
Xclkload38 clknet_leaf_21_clk VGND VGND VPWR VPWR clkload38/Y sky130_fd_sc_hd__clkinv_4
Xclkload27 clknet_leaf_33_clk VGND VGND VPWR VPWR clkload27/Y sky130_fd_sc_hd__bufinv_16
XFILLER_0_2_239 VGND VGND VPWR VPWR sky130_fd_sc_hd__fill_1
XFILLER_0_50_164 VGND VGND VPWR VPWR sky130_fd_sc_hd__fill_2
XFILLER_0_76_15 VPWR VGND VPWR VGND sky130_ef_sc_hd__decap_12
XFILLER_0_50_197 VGND VGND VPWR VPWR sky130_fd_sc_hd__decap_8
XTAP_TAPCELL_ROW_79_900 VGND VPWR sky130_fd_sc_hd__tapvpwrvgnd_1
XFILLER_0_76_59 VGND VGND VPWR VPWR sky130_fd_sc_hd__fill_1
X_4070_ _2086_ net248 _2160_ VGND VGND VPWR VPWR _2165_ sky130_fd_sc_hd__mux2_1
X_3021_ _1216_ VGND VGND VPWR VPWR _1217_ sky130_fd_sc_hd__clkbuf_4
X_4972_ _2486_ VGND VGND VPWR VPWR _0357_ sky130_fd_sc_hd__inv_2
XFILLER_0_18_106 VGND VGND VPWR VPWR sky130_fd_sc_hd__fill_1
X_3923_ _2051_ _2082_ VGND VGND VPWR VPWR _2083_ sky130_fd_sc_hd__and2_2
XFILLER_0_58_253 VPWR VGND VPWR VGND sky130_ef_sc_hd__decap_12
XFILLER_0_73_223 VGND VGND VPWR VPWR sky130_fd_sc_hd__fill_1
XFILLER_0_6_501 VPWR VGND VPWR VGND sky130_ef_sc_hd__decap_12
X_3854_ _1814_ _2022_ VGND VGND VPWR VPWR _2023_ sky130_fd_sc_hd__or2_2
X_2805_ _1094_ _1096_ _1080_ _1082_ VGND VGND VPWR VPWR _1097_ sky130_fd_sc_hd__o2bb2a_1
XFILLER_0_41_51 VGND VGND VPWR VPWR sky130_fd_sc_hd__fill_2
X_3785_ _1596_ _1597_ VGND VGND VPWR VPWR _1967_ sky130_fd_sc_hd__nor2_2
X_2736_ RF0.regs\[2\]\[19\] _0880_ _1026_ _1027_ VGND VGND VPWR VPWR _1028_ sky130_fd_sc_hd__a211oi_1
X_2667_ RF0.regs\[10\]\[0\] _0813_ _0844_ RF0.regs\[12\]\[0\] _0958_ VGND VGND VPWR
+ VPWR _0959_ sky130_fd_sc_hd__a221o_1
X_4406_ _2340_ VGND VGND VPWR VPWR _0433_ sky130_fd_sc_hd__clkbuf_1
XFILLER_0_67_3 VGND VGND VPWR VPWR sky130_fd_sc_hd__decap_8
X_5386_ clknet_leaf_44_clk _0762_ _0378_ VGND VGND VPWR VPWR IM0.addr\[17\] sky130_fd_sc_hd__dfrtp_1
X_2598_ RF0.regs\[15\]\[30\] _0856_ _0868_ RF0.regs\[4\]\[30\] _0889_ VGND VGND VPWR
+ VPWR _0890_ sky130_fd_sc_hd__a221o_1
XFILLER_0_5_51 VGND VGND VPWR VPWR sky130_fd_sc_hd__decap_4
X_4337_ _2304_ VGND VGND VPWR VPWR _0466_ sky130_fd_sc_hd__clkbuf_1
X_4268_ net209 VGND VGND VPWR VPWR _2268_ sky130_fd_sc_hd__clkbuf_1
X_3219_ RF0.regs\[25\]\[5\] _1251_ _1254_ RF0.regs\[12\]\[5\] _1414_ VGND VGND VPWR
+ VPWR _1415_ sky130_fd_sc_hd__a221o_1
XTAP_TAPCELL_ROW_85_958 VGND VPWR sky130_fd_sc_hd__tapvpwrvgnd_1
X_4199_ _0909_ VGND VGND VPWR VPWR _2233_ sky130_fd_sc_hd__buf_4
XTAP_TAPCELL_ROW_40_549 VGND VPWR sky130_fd_sc_hd__tapvpwrvgnd_1
XFILLER_0_64_245 VGND VGND VPWR VPWR sky130_fd_sc_hd__decap_6
XFILLER_0_32_197 VGND VGND VPWR VPWR sky130_fd_sc_hd__decap_4
XTAP_TAPCELL_ROW_56_693 VGND VPWR sky130_fd_sc_hd__tapvpwrvgnd_1
XFILLER_0_55_201 VGND VGND VPWR VPWR sky130_fd_sc_hd__fill_2
XFILLER_0_55_223 VGND VGND VPWR VPWR sky130_fd_sc_hd__fill_1
XFILLER_0_43_429 VGND VGND VPWR VPWR sky130_fd_sc_hd__decap_6
X_3570_ RF0.regs\[25\]\[13\] _0814_ _0915_ _1246_ VGND VGND VPWR VPWR _1762_ sky130_fd_sc_hd__a211o_1
XFILLER_0_70_248 VGND VGND VPWR VPWR sky130_fd_sc_hd__decap_4
XFILLER_0_11_87 VGND VGND VPWR VPWR sky130_fd_sc_hd__fill_1
XTAP_TAPCELL_ROW_11_284 VGND VPWR sky130_fd_sc_hd__tapvpwrvgnd_1
XFILLER_0_23_164 VGND VGND VPWR VPWR sky130_fd_sc_hd__decap_4
X_2521_ _0812_ VGND VGND VPWR VPWR _0813_ sky130_fd_sc_hd__buf_4
XFILLER_0_11_337 VGND VGND VPWR VPWR sky130_fd_sc_hd__decap_8
X_5240_ clknet_leaf_45_clk _0616_ _0232_ VGND VGND VPWR VPWR RF0.regs\[6\]\[31\] sky130_fd_sc_hd__dfrtp_1
XFILLER_0_87_69 VPWR VGND VPWR VGND sky130_ef_sc_hd__decap_12
XPHY_EDGE_ROW_18_Right_18 VGND VGND VPWR VPWR sky130_fd_sc_hd__decap_3
X_5171_ clknet_leaf_6_clk _0547_ _0163_ VGND VGND VPWR VPWR RF0.regs\[10\]\[26\] sky130_fd_sc_hd__dfrtp_1
X_4122_ _2193_ VGND VGND VPWR VPWR _0570_ sky130_fd_sc_hd__clkbuf_1
X_4053_ _2012_ net197 _2149_ VGND VGND VPWR VPWR _2156_ sky130_fd_sc_hd__mux2_1
XTAP_TAPCELL_ROW_3_219 VGND VPWR sky130_fd_sc_hd__tapvpwrvgnd_1
X_3004_ _1207_ VGND VGND VPWR VPWR _0688_ sky130_fd_sc_hd__clkbuf_1
XTAP_TAPCELL_ROW_82_928 VGND VPWR sky130_fd_sc_hd__tapvpwrvgnd_1
XFILLER_0_78_315 VPWR VGND VPWR VGND sky130_ef_sc_hd__decap_12
XFILLER_0_36_95 VGND VGND VPWR VPWR sky130_fd_sc_hd__fill_2
XTAP_TAPCELL_ROW_19_362 VGND VPWR sky130_fd_sc_hd__tapvpwrvgnd_1
X_4955_ _2484_ VGND VGND VPWR VPWR _0342_ sky130_fd_sc_hd__inv_2
XPHY_EDGE_ROW_27_Right_27 VGND VGND VPWR VPWR sky130_fd_sc_hd__decap_3
X_3906_ RF0.regs\[4\]\[12\] _2069_ _1993_ VGND VGND VPWR VPWR _2070_ sky130_fd_sc_hd__mux2_1
X_4886_ _2476_ VGND VGND VPWR VPWR _0281_ sky130_fd_sc_hd__inv_2
XFILLER_0_6_320 VGND VGND VPWR VPWR sky130_fd_sc_hd__fill_1
X_3837_ _1924_ _2007_ VGND VGND VPWR VPWR _2008_ sky130_fd_sc_hd__nor2_2
XFILLER_0_27_470 VPWR VGND VPWR VGND sky130_ef_sc_hd__decap_12
X_3768_ RF0.regs\[4\]\[31\] _1952_ _1953_ VGND VGND VPWR VPWR _1954_ sky130_fd_sc_hd__mux2_1
XFILLER_0_14_164 VGND VGND VPWR VPWR sky130_fd_sc_hd__decap_3
X_2719_ _0800_ _0801_ _1010_ _0803_ VGND VGND VPWR VPWR _1011_ sky130_fd_sc_hd__or4_1
XFILLER_0_14_197 VGND VGND VPWR VPWR sky130_fd_sc_hd__decap_3
X_3699_ RF0.regs\[4\]\[0\] _1237_ _1220_ RF0.regs\[20\]\[0\] VGND VGND VPWR VPWR _1885_
+ sky130_fd_sc_hd__a22o_1
XPHY_EDGE_ROW_36_Right_36 VGND VGND VPWR VPWR sky130_fd_sc_hd__decap_3
XFILLER_0_77_91 VGND VGND VPWR VPWR sky130_fd_sc_hd__fill_1
X_5369_ clknet_leaf_42_clk _0745_ _0361_ VGND VGND VPWR VPWR IM0.addr\[0\] sky130_fd_sc_hd__dfrtp_1
XPHY_EDGE_ROW_45_Right_45 VGND VGND VPWR VPWR sky130_fd_sc_hd__decap_3
XTAP_TAPCELL_ROW_53_663 VGND VPWR sky130_fd_sc_hd__tapvpwrvgnd_1
XFILLER_0_80_513 VGND VGND VPWR VPWR sky130_fd_sc_hd__decap_4
XPHY_EDGE_ROW_54_Right_54 VGND VGND VPWR VPWR sky130_fd_sc_hd__decap_3
XFILLER_0_73_27 VPWR VGND VPWR VGND sky130_ef_sc_hd__decap_12
XPHY_EDGE_ROW_63_Right_63 VGND VGND VPWR VPWR sky130_fd_sc_hd__decap_3
XFILLER_0_87_167 VGND VGND VPWR VPWR sky130_fd_sc_hd__fill_1
XFILLER_0_87_156 VGND VGND VPWR VPWR sky130_fd_sc_hd__fill_1
XTAP_TAPCELL_ROW_16_332 VGND VPWR sky130_fd_sc_hd__tapvpwrvgnd_1
X_4740_ _2459_ VGND VGND VPWR VPWR _0152_ sky130_fd_sc_hd__inv_2
X_4671_ _2450_ VGND VGND VPWR VPWR _0092_ sky130_fd_sc_hd__inv_2
X_3622_ RF0.regs\[0\]\[9\] _1217_ _1810_ VGND VGND VPWR VPWR _1811_ sky130_fd_sc_hd__o21ai_1
XFILLER_0_43_259 VGND VGND VPWR VPWR sky130_fd_sc_hd__fill_1
XPHY_EDGE_ROW_72_Right_72 VGND VGND VPWR VPWR sky130_fd_sc_hd__decap_3
XFILLER_0_3_345 VPWR VGND VPWR VGND sky130_ef_sc_hd__decap_12
XFILLER_0_24_473 VGND VGND VPWR VPWR sky130_fd_sc_hd__decap_3
XFILLER_0_51_281 VGND VGND VPWR VPWR sky130_fd_sc_hd__decap_6
X_3553_ _0798_ _1743_ _1744_ VGND VGND VPWR VPWR _1745_ sky130_fd_sc_hd__or3_1
X_3484_ RF0.regs\[20\]\[17\] _1223_ _1228_ RF0.regs\[15\]\[17\] _1676_ VGND VGND VPWR
+ VPWR _1677_ sky130_fd_sc_hd__a221o_1
XFILLER_0_3_389 VGND VGND VPWR VPWR sky130_fd_sc_hd__decap_3
X_2504_ IM0.addr\[1\] IM0.addr\[2\] VGND VGND VPWR VPWR _0796_ sky130_fd_sc_hd__nor2b_2
X_5223_ clknet_leaf_20_clk _0599_ _0215_ VGND VGND VPWR VPWR RF0.regs\[6\]\[14\] sky130_fd_sc_hd__dfrtp_1
X_5154_ clknet_leaf_27_clk _0530_ _0146_ VGND VGND VPWR VPWR RF0.regs\[10\]\[9\] sky130_fd_sc_hd__dfrtp_4
X_4105_ net135 VGND VGND VPWR VPWR _2185_ sky130_fd_sc_hd__clkbuf_1
XPHY_EDGE_ROW_81_Right_81 VGND VGND VPWR VPWR sky130_fd_sc_hd__decap_3
X_5085_ clknet_leaf_34_clk _0461_ _0077_ VGND VGND VPWR VPWR RF0.regs\[15\]\[4\] sky130_fd_sc_hd__dfrtp_1
X_4036_ _1986_ net242 _2138_ VGND VGND VPWR VPWR _2147_ sky130_fd_sc_hd__mux2_1
XFILLER_0_2_41 VPWR VGND VPWR VGND sky130_ef_sc_hd__decap_12
XFILLER_0_2_85 VPWR VGND VPWR VGND sky130_ef_sc_hd__decap_12
XTAP_TAPCELL_ROW_67_788 VGND VPWR sky130_fd_sc_hd__tapvpwrvgnd_1
XFILLER_0_66_329 VGND VGND VPWR VPWR sky130_fd_sc_hd__decap_8
XFILLER_0_74_340 VPWR VGND VPWR VGND sky130_ef_sc_hd__decap_12
XFILLER_0_19_245 VGND VGND VPWR VPWR sky130_fd_sc_hd__decap_8
X_4938_ _2482_ VGND VGND VPWR VPWR _0327_ sky130_fd_sc_hd__inv_2
XFILLER_0_19_267 VPWR VGND VPWR VGND sky130_ef_sc_hd__decap_12
X_4869_ _2474_ VGND VGND VPWR VPWR _0266_ sky130_fd_sc_hd__inv_2
XFILLER_0_34_248 VGND VGND VPWR VPWR sky130_fd_sc_hd__decap_4
XFILLER_0_30_421 VGND VGND VPWR VPWR sky130_fd_sc_hd__fill_2
XFILLER_0_30_443 VGND VGND VPWR VPWR sky130_fd_sc_hd__decap_3
XFILLER_0_30_454 VGND VGND VPWR VPWR sky130_fd_sc_hd__fill_1
XFILLER_0_30_487 VGND VGND VPWR VPWR sky130_fd_sc_hd__decap_4
XTAP_TAPCELL_ROW_58_711 VGND VPWR sky130_fd_sc_hd__tapvpwrvgnd_1
XFILLER_0_69_167 VGND VGND VPWR VPWR sky130_fd_sc_hd__fill_1
XTAP_TAPCELL_ROW_13_302 VGND VPWR sky130_fd_sc_hd__tapvpwrvgnd_1
XFILLER_0_80_321 VGND VGND VPWR VPWR sky130_fd_sc_hd__decap_8
XFILLER_0_33_281 VGND VGND VPWR VPWR sky130_fd_sc_hd__fill_2
XFILLER_0_0_315 VPWR VGND VPWR VGND sky130_ef_sc_hd__decap_12
XFILLER_0_0_337 VPWR VGND VPWR VGND sky130_ef_sc_hd__decap_12
XFILLER_0_21_454 VGND VGND VPWR VPWR sky130_fd_sc_hd__fill_2
XFILLER_0_68_27 VGND VGND VPWR VPWR sky130_fd_sc_hd__fill_1
XFILLER_0_84_15 VPWR VGND VPWR VGND sky130_ef_sc_hd__decap_12
XFILLER_0_48_318 VGND VGND VPWR VPWR sky130_fd_sc_hd__decap_4
XTAP_TAPCELL_ROW_64_769 VGND VPWR sky130_fd_sc_hd__tapvpwrvgnd_1
XFILLER_0_33_52 VGND VGND VPWR VPWR sky130_fd_sc_hd__fill_1
X_2984_ _1197_ VGND VGND VPWR VPWR _0698_ sky130_fd_sc_hd__clkbuf_1
XFILLER_0_8_459 VPWR VGND VPWR VGND sky130_ef_sc_hd__decap_12
XFILLER_0_33_96 VGND VGND VPWR VPWR sky130_fd_sc_hd__decap_6
X_4723_ _2457_ VGND VGND VPWR VPWR _2458_ sky130_fd_sc_hd__buf_4
X_4654_ _2448_ VGND VGND VPWR VPWR _0077_ sky130_fd_sc_hd__inv_2
XFILLER_0_71_387 VGND VGND VPWR VPWR sky130_fd_sc_hd__fill_1
X_4585_ _2439_ VGND VGND VPWR VPWR _0017_ sky130_fd_sc_hd__inv_2
X_3605_ RF0.regs\[4\]\[10\] _1239_ VGND VGND VPWR VPWR _1795_ sky130_fd_sc_hd__and2_1
XFILLER_0_12_443 VGND VGND VPWR VPWR sky130_fd_sc_hd__decap_4
XFILLER_0_3_175 VGND VGND VPWR VPWR sky130_fd_sc_hd__fill_2
X_3536_ _1461_ _1469_ _1474_ VGND VGND VPWR VPWR _1728_ sky130_fd_sc_hd__and3_1
X_3467_ _1658_ _1660_ VGND VGND VPWR VPWR _1661_ sky130_fd_sc_hd__nor2_1
XPHY_EDGE_ROW_10_Left_98 VGND VGND VPWR VPWR sky130_fd_sc_hd__decap_3
X_5206_ clknet_leaf_0_clk _0582_ _0198_ VGND VGND VPWR VPWR RF0.regs\[7\]\[29\] sky130_fd_sc_hd__dfrtp_1
X_3398_ RF0.regs\[10\]\[27\] _0887_ _0815_ RF0.regs\[25\]\[27\] _1247_ VGND VGND VPWR
+ VPWR _1592_ sky130_fd_sc_hd__a221o_1
X_5137_ clknet_leaf_7_clk _0513_ _0129_ VGND VGND VPWR VPWR RF0.regs\[12\]\[24\] sky130_fd_sc_hd__dfrtp_1
X_5068_ clknet_leaf_11_clk _0444_ _0060_ VGND VGND VPWR VPWR RF0.regs\[20\]\[19\]
+ sky130_fd_sc_hd__dfrtp_1
X_4019_ _2137_ VGND VGND VPWR VPWR _2138_ sky130_fd_sc_hd__buf_4
XFILLER_0_39_307 VGND VGND VPWR VPWR sky130_fd_sc_hd__fill_2
XPHY_EDGE_ROW_0_Right_0 VGND VGND VPWR VPWR sky130_fd_sc_hd__decap_3
XFILLER_0_47_351 VGND VGND VPWR VPWR sky130_fd_sc_hd__decap_8
XFILLER_0_62_343 VGND VGND VPWR VPWR sky130_fd_sc_hd__decap_6
XFILLER_0_7_481 VPWR VGND VPWR VGND sky130_ef_sc_hd__decap_12
XFILLER_0_15_281 VGND VGND VPWR VPWR sky130_fd_sc_hd__fill_2
XFILLER_0_22_218 VPWR VGND VPWR VGND sky130_ef_sc_hd__decap_12
XFILLER_0_30_251 VGND VGND VPWR VPWR sky130_fd_sc_hd__fill_1
XTAP_TAPCELL_ROW_61_739 VGND VPWR sky130_fd_sc_hd__tapvpwrvgnd_1
XFILLER_0_5_429 VPWR VGND VPWR VGND sky130_ef_sc_hd__decap_12
XFILLER_0_79_15 VPWR VGND VPWR VGND sky130_ef_sc_hd__decap_12
XFILLER_0_41_516 VGND VGND VPWR VPWR sky130_fd_sc_hd__fill_1
XFILLER_0_80_195 VGND VGND VPWR VPWR sky130_fd_sc_hd__fill_1
Xhold108 RF0.regs\[0\]\[1\] VGND VGND VPWR VPWR net156 sky130_fd_sc_hd__dlygate4sd3_1
Xhold119 RF0.regs\[2\]\[28\] VGND VGND VPWR VPWR net167 sky130_fd_sc_hd__dlygate4sd3_1
X_4370_ _2321_ VGND VGND VPWR VPWR _0450_ sky130_fd_sc_hd__clkbuf_1
X_3321_ _1501_ _1516_ _1509_ _1504_ VGND VGND VPWR VPWR _1517_ sky130_fd_sc_hd__or4_4
XTAP_TAPCELL_ROW_69_806 VGND VPWR sky130_fd_sc_hd__tapvpwrvgnd_1
XFILLER_0_0_189 VGND VGND VPWR VPWR sky130_fd_sc_hd__decap_6
XFILLER_0_28_41 VGND VGND VPWR VPWR sky130_fd_sc_hd__fill_1
X_3252_ _1295_ _1296_ _1275_ VGND VGND VPWR VPWR _1448_ sky130_fd_sc_hd__a21oi_1
X_3183_ _1361_ _1378_ _1369_ _0828_ VGND VGND VPWR VPWR _1379_ sky130_fd_sc_hd__a211o_1
XFILLER_0_28_85 VGND VGND VPWR VPWR sky130_fd_sc_hd__fill_1
XTAP_TAPCELL_ROW_77_883 VGND VPWR sky130_fd_sc_hd__tapvpwrvgnd_1
XTAP_TAPCELL_ROW_24_408 VGND VPWR sky130_fd_sc_hd__tapvpwrvgnd_1
XFILLER_0_48_126 VGND VGND VPWR VPWR sky130_fd_sc_hd__fill_2
XFILLER_0_29_373 VGND VGND VPWR VPWR sky130_fd_sc_hd__decap_8
XFILLER_0_8_256 VGND VGND VPWR VPWR sky130_fd_sc_hd__decap_6
XTAP_TAPCELL_ROW_32_474 VGND VPWR sky130_fd_sc_hd__tapvpwrvgnd_1
X_2967_ net244 VGND VGND VPWR VPWR _1189_ sky130_fd_sc_hd__clkbuf_1
XFILLER_0_60_83 VGND VGND VPWR VPWR sky130_fd_sc_hd__fill_1
X_2898_ _1154_ VGND VGND VPWR VPWR _0741_ sky130_fd_sc_hd__clkbuf_1
XFILLER_0_32_516 VGND VGND VPWR VPWR sky130_fd_sc_hd__fill_1
XFILLER_0_44_365 VGND VGND VPWR VPWR sky130_fd_sc_hd__fill_2
X_4706_ _2455_ VGND VGND VPWR VPWR _0122_ sky130_fd_sc_hd__inv_2
X_4637_ _2445_ VGND VGND VPWR VPWR _0063_ sky130_fd_sc_hd__inv_2
X_4568_ _1149_ _1550_ _1562_ VGND VGND VPWR VPWR _2433_ sky130_fd_sc_hd__and3_1
X_3519_ RF0.regs\[20\]\[18\] _1223_ _1232_ RF0.regs\[6\]\[18\] _1710_ VGND VGND VPWR
+ VPWR _1711_ sky130_fd_sc_hd__a221o_1
X_4499_ disp.digits\[9\] _2386_ _2387_ disp.digits\[13\] VGND VGND VPWR VPWR _2388_
+ sky130_fd_sc_hd__a22o_1
XFILLER_0_67_457 VGND VGND VPWR VPWR sky130_fd_sc_hd__fill_1
XFILLER_0_82_416 VGND VGND VPWR VPWR sky130_fd_sc_hd__decap_4
Xclkbuf_leaf_20_clk clknet_2_3__leaf_clk VGND VGND VPWR VPWR clknet_leaf_20_clk sky130_fd_sc_hd__clkbuf_8
XFILLER_0_23_516 VGND VGND VPWR VPWR sky130_fd_sc_hd__fill_1
XFILLER_0_62_173 VGND VGND VPWR VPWR sky130_fd_sc_hd__decap_8
XFILLER_0_50_368 VPWR VGND VPWR VGND sky130_ef_sc_hd__decap_12
XFILLER_0_85_210 VGND VGND VPWR VPWR sky130_fd_sc_hd__fill_1
XFILLER_0_81_27 VPWR VGND VPWR VGND sky130_ef_sc_hd__decap_12
XTAP_TAPCELL_ROW_74_853 VGND VPWR sky130_fd_sc_hd__tapvpwrvgnd_1
XFILLER_0_58_402 VGND VGND VPWR VPWR sky130_fd_sc_hd__decap_4
XTAP_TAPCELL_ROW_46_599 VGND VPWR sky130_fd_sc_hd__tapvpwrvgnd_1
XFILLER_0_14_65 VPWR VGND VPWR VGND sky130_ef_sc_hd__decap_12
X_3870_ _1877_ _1895_ VGND VGND VPWR VPWR _2036_ sky130_fd_sc_hd__or2_1
X_2821_ _1108_ net268 VGND VGND VPWR VPWR _1110_ sky130_fd_sc_hd__and2_1
Xclkbuf_leaf_11_clk clknet_2_1__leaf_clk VGND VGND VPWR VPWR clknet_leaf_11_clk sky130_fd_sc_hd__clkbuf_8
X_2752_ RF0.regs\[15\]\[4\] _0853_ _0862_ RF0.regs\[4\]\[4\] VGND VGND VPWR VPWR _1044_
+ sky130_fd_sc_hd__a22o_1
XFILLER_0_26_365 VGND VGND VPWR VPWR sky130_fd_sc_hd__fill_1
XFILLER_0_41_302 VGND VGND VPWR VPWR sky130_fd_sc_hd__fill_2
XFILLER_0_53_162 VGND VGND VPWR VPWR sky130_fd_sc_hd__decap_6
X_4422_ _2348_ VGND VGND VPWR VPWR _0425_ sky130_fd_sc_hd__clkbuf_1
XFILLER_0_30_75 VGND VGND VPWR VPWR sky130_fd_sc_hd__decap_3
X_2683_ RF0.regs\[4\]\[11\] _0867_ _0879_ RF0.regs\[2\]\[11\] _0974_ VGND VGND VPWR
+ VPWR _0975_ sky130_fd_sc_hd__a221o_1
X_4353_ _2312_ VGND VGND VPWR VPWR _0458_ sky130_fd_sc_hd__clkbuf_1
X_4284_ net130 VGND VGND VPWR VPWR _2276_ sky130_fd_sc_hd__clkbuf_1
X_3304_ _1480_ _1492_ _1497_ _1498_ _1499_ VGND VGND VPWR VPWR _1500_ sky130_fd_sc_hd__a311o_1
X_3235_ _0946_ _1423_ _1430_ VGND VGND VPWR VPWR _1431_ sky130_fd_sc_hd__a21oi_2
X_3166_ net52 _1267_ _1361_ _0841_ VGND VGND VPWR VPWR _1362_ sky130_fd_sc_hd__o211a_1
X_3097_ _0825_ _0950_ _1292_ _1291_ VGND VGND VPWR VPWR _1293_ sky130_fd_sc_hd__a211o_4
XTAP_TAPCELL_ROW_37_522 VGND VPWR sky130_fd_sc_hd__tapvpwrvgnd_1
XFILLER_0_12_3 VPWR VGND VPWR VGND sky130_ef_sc_hd__decap_12
XFILLER_0_49_457 VGND VGND VPWR VPWR sky130_fd_sc_hd__fill_2
XFILLER_0_76_265 VGND VGND VPWR VPWR sky130_fd_sc_hd__decap_6
X_3999_ _2127_ VGND VGND VPWR VPWR _0626_ sky130_fd_sc_hd__clkbuf_1
XFILLER_0_64_449 VGND VGND VPWR VPWR sky130_fd_sc_hd__decap_8
XFILLER_0_29_192 VGND VGND VPWR VPWR sky130_fd_sc_hd__fill_1
XTAP_TAPCELL_ROW_9_269 VGND VPWR sky130_fd_sc_hd__tapvpwrvgnd_1
XTAP_TAPCELL_ROW_0_180 VGND VPWR sky130_fd_sc_hd__tapvpwrvgnd_1
XFILLER_0_67_221 VGND VGND VPWR VPWR sky130_fd_sc_hd__decap_3
XTAP_TAPCELL_ROW_0_191 VGND VPWR sky130_fd_sc_hd__tapvpwrvgnd_1
XFILLER_0_55_405 VPWR VGND VPWR VGND sky130_ef_sc_hd__decap_12
XFILLER_0_27_129 VGND VGND VPWR VPWR sky130_fd_sc_hd__fill_1
XFILLER_0_55_449 VGND VGND VPWR VPWR sky130_fd_sc_hd__decap_8
XFILLER_0_82_279 VGND VGND VPWR VPWR sky130_fd_sc_hd__decap_4
Xclkload17 clknet_leaf_9_clk VGND VGND VPWR VPWR clkload17/Y sky130_fd_sc_hd__inv_6
Xclkload39 clknet_leaf_22_clk VGND VGND VPWR VPWR clkload39/Y sky130_fd_sc_hd__bufinv_16
Xclkload28 clknet_leaf_34_clk VGND VGND VPWR VPWR clkload28/Y sky130_fd_sc_hd__bufinv_16
XFILLER_0_31_390 VGND VGND VPWR VPWR sky130_fd_sc_hd__fill_2
XFILLER_0_50_187 VGND VGND VPWR VPWR sky130_fd_sc_hd__decap_8
XTAP_TAPCELL_ROW_79_901 VGND VPWR sky130_fd_sc_hd__tapvpwrvgnd_1
XFILLER_0_76_27 VGND VGND VPWR VPWR sky130_fd_sc_hd__fill_1
X_3020_ _1215_ VGND VGND VPWR VPWR _1216_ sky130_fd_sc_hd__buf_4
Xclkbuf_leaf_0_clk clknet_2_0__leaf_clk VGND VGND VPWR VPWR clknet_leaf_0_clk sky130_fd_sc_hd__clkbuf_8
X_4971_ _2480_ VGND VGND VPWR VPWR _2486_ sky130_fd_sc_hd__buf_4
X_3922_ _1823_ _1909_ VGND VGND VPWR VPWR _2082_ sky130_fd_sc_hd__or2_1
XFILLER_0_58_265 VPWR VGND VPWR VGND sky130_ef_sc_hd__decap_12
X_3853_ _1812_ net33 VGND VGND VPWR VPWR _2022_ sky130_fd_sc_hd__and2_1
XFILLER_0_6_513 VGND VGND VPWR VPWR sky130_fd_sc_hd__decap_4
X_2804_ RF0.regs\[10\]\[28\] _0815_ _0829_ RF0.regs\[25\]\[28\] _1095_ VGND VGND VPWR
+ VPWR _1096_ sky130_fd_sc_hd__a221o_2
X_3784_ _1966_ VGND VGND VPWR VPWR _0677_ sky130_fd_sc_hd__clkbuf_1
XFILLER_0_41_96 VGND VGND VPWR VPWR sky130_fd_sc_hd__fill_1
XFILLER_0_54_460 VPWR VGND VPWR VGND sky130_ef_sc_hd__decap_12
XFILLER_0_26_195 VGND VGND VPWR VPWR sky130_fd_sc_hd__fill_1
X_2735_ RF0.regs\[10\]\[19\] _0884_ _0854_ RF0.regs\[15\]\[19\] VGND VGND VPWR VPWR
+ _1027_ sky130_fd_sc_hd__a22o_1
X_2666_ RF0.regs\[4\]\[0\] _0837_ _0828_ RF0.regs\[25\]\[0\] VGND VGND VPWR VPWR _0958_
+ sky130_fd_sc_hd__a22o_1
X_5385_ clknet_leaf_44_clk _0761_ _0377_ VGND VGND VPWR VPWR IM0.addr\[16\] sky130_fd_sc_hd__dfrtp_1
X_4405_ net217 _2083_ _2336_ VGND VGND VPWR VPWR _2340_ sky130_fd_sc_hd__mux2_1
X_2597_ RF0.regs\[5\]\[30\] _0876_ _0880_ RF0.regs\[2\]\[30\] _0888_ VGND VGND VPWR
+ VPWR _0889_ sky130_fd_sc_hd__a221o_1
X_4336_ RF0.regs\[15\]\[9\] _2080_ _2301_ VGND VGND VPWR VPWR _2304_ sky130_fd_sc_hd__mux2_1
XTAP_TAPCELL_ROW_6_239 VGND VPWR sky130_fd_sc_hd__tapvpwrvgnd_1
X_4267_ _2267_ VGND VGND VPWR VPWR _0499_ sky130_fd_sc_hd__clkbuf_1
X_3218_ RF0.regs\[4\]\[5\] _0834_ _0809_ RF0.regs\[10\]\[5\] VGND VGND VPWR VPWR _1414_
+ sky130_fd_sc_hd__a22o_1
X_4198_ _2232_ VGND VGND VPWR VPWR _0533_ sky130_fd_sc_hd__clkbuf_1
XFILLER_0_66_82 VGND VGND VPWR VPWR sky130_fd_sc_hd__fill_2
X_3149_ _0892_ _1344_ VGND VGND VPWR VPWR _1345_ sky130_fd_sc_hd__or2_1
XFILLER_0_49_210 VGND VGND VPWR VPWR sky130_fd_sc_hd__fill_1
XFILLER_0_37_438 VGND VGND VPWR VPWR sky130_fd_sc_hd__decap_3
XFILLER_0_37_449 VGND VGND VPWR VPWR sky130_fd_sc_hd__decap_8
XFILLER_0_13_390 VGND VGND VPWR VPWR sky130_fd_sc_hd__fill_2
XFILLER_0_1_3 VPWR VGND VPWR VGND sky130_ef_sc_hd__decap_12
XTAP_TAPCELL_ROW_48_617 VGND VPWR sky130_fd_sc_hd__tapvpwrvgnd_1
XTAP_TAPCELL_ROW_56_694 VGND VPWR sky130_fd_sc_hd__tapvpwrvgnd_1
XFILLER_0_36_482 VGND VGND VPWR VPWR sky130_fd_sc_hd__decap_8
XFILLER_0_55_279 VGND VGND VPWR VPWR sky130_fd_sc_hd__fill_1
XFILLER_0_11_55 VGND VGND VPWR VPWR sky130_fd_sc_hd__fill_1
XFILLER_0_3_505 VPWR VGND VPWR VGND sky130_ef_sc_hd__decap_12
XFILLER_0_87_15 VPWR VGND VPWR VGND sky130_ef_sc_hd__decap_12
XFILLER_0_11_305 VGND VGND VPWR VPWR sky130_fd_sc_hd__decap_6
XTAP_TAPCELL_ROW_11_285 VGND VPWR sky130_fd_sc_hd__tapvpwrvgnd_1
X_2520_ _0811_ VGND VGND VPWR VPWR _0812_ sky130_fd_sc_hd__buf_4
XFILLER_0_51_474 VPWR VGND VPWR VGND sky130_ef_sc_hd__decap_12
X_5170_ clknet_leaf_8_clk _0546_ _0162_ VGND VGND VPWR VPWR RF0.regs\[10\]\[25\] sky130_fd_sc_hd__dfrtp_1
X_4121_ net108 VGND VGND VPWR VPWR _2193_ sky130_fd_sc_hd__clkbuf_1
X_4052_ _2155_ VGND VGND VPWR VPWR _0601_ sky130_fd_sc_hd__clkbuf_1
X_3003_ net106 VGND VGND VPWR VPWR _1207_ sky130_fd_sc_hd__clkbuf_1
XFILLER_0_36_74 VGND VGND VPWR VPWR sky130_fd_sc_hd__fill_1
XTAP_TAPCELL_ROW_82_929 VGND VPWR sky130_fd_sc_hd__tapvpwrvgnd_1
XTAP_TAPCELL_ROW_19_363 VGND VPWR sky130_fd_sc_hd__tapvpwrvgnd_1
Xclkbuf_2_1__f_clk clknet_0_clk VGND VGND VPWR VPWR clknet_2_1__leaf_clk sky130_fd_sc_hd__clkbuf_16
X_4954_ _2484_ VGND VGND VPWR VPWR _0341_ sky130_fd_sc_hd__inv_2
XFILLER_0_19_449 VGND VGND VPWR VPWR sky130_fd_sc_hd__decap_4
X_3905_ _2060_ _2068_ VGND VGND VPWR VPWR _2069_ sky130_fd_sc_hd__nor2_2
X_4885_ _2471_ VGND VGND VPWR VPWR _2476_ sky130_fd_sc_hd__clkbuf_8
X_3836_ _1747_ _1923_ _1732_ VGND VGND VPWR VPWR _2007_ sky130_fd_sc_hd__o21a_1
XFILLER_0_34_419 VGND VGND VPWR VPWR sky130_fd_sc_hd__fill_1
X_3767_ _1241_ VGND VGND VPWR VPWR _1953_ sky130_fd_sc_hd__buf_4
XFILLER_0_27_482 VGND VGND VPWR VPWR sky130_fd_sc_hd__decap_4
XFILLER_0_61_249 VGND VGND VPWR VPWR sky130_fd_sc_hd__decap_4
XFILLER_0_14_154 VGND VGND VPWR VPWR sky130_fd_sc_hd__fill_2
X_2718_ _1009_ VGND VGND VPWR VPWR _1010_ sky130_fd_sc_hd__clkbuf_4
XFILLER_0_42_474 VGND VGND VPWR VPWR sky130_fd_sc_hd__fill_2
X_3698_ _1007_ _1878_ _1883_ VGND VGND VPWR VPWR _1884_ sky130_fd_sc_hd__a21o_1
X_2649_ _0847_ _0890_ _0892_ _0895_ _0940_ VGND VGND VPWR VPWR _0941_ sky130_fd_sc_hd__a221o_1
X_5368_ clknet_leaf_45_clk _0744_ _0360_ VGND VGND VPWR VPWR RF0.regs\[0\]\[31\] sky130_fd_sc_hd__dfrtp_1
X_4319_ RF0.regs\[15\]\[17\] _2005_ _2290_ VGND VGND VPWR VPWR _2295_ sky130_fd_sc_hd__mux2_1
X_5299_ clknet_leaf_6_clk _0675_ _0291_ VGND VGND VPWR VPWR RF0.regs\[4\]\[26\] sky130_fd_sc_hd__dfrtp_1
XTAP_TAPCELL_ROW_53_664 VGND VPWR sky130_fd_sc_hd__tapvpwrvgnd_1
XFILLER_0_52_205 VGND VGND VPWR VPWR sky130_fd_sc_hd__decap_4
XFILLER_0_33_430 VGND VGND VPWR VPWR sky130_fd_sc_hd__decap_6
XFILLER_0_33_474 VGND VGND VPWR VPWR sky130_fd_sc_hd__decap_8
XFILLER_0_20_179 VGND VGND VPWR VPWR sky130_fd_sc_hd__fill_1
XPHY_EDGE_ROW_29_Left_117 VGND VGND VPWR VPWR sky130_fd_sc_hd__decap_3
XFILLER_0_73_39 VPWR VGND VPWR VGND sky130_ef_sc_hd__decap_12
XFILLER_0_87_113 VPWR VGND VPWR VGND sky130_ef_sc_hd__decap_12
XPHY_EDGE_ROW_38_Left_126 VGND VGND VPWR VPWR sky130_fd_sc_hd__decap_3
XTAP_TAPCELL_ROW_16_333 VGND VPWR sky130_fd_sc_hd__tapvpwrvgnd_1
XFILLER_0_7_118 VGND VGND VPWR VPWR sky130_fd_sc_hd__fill_2
X_4670_ _2450_ VGND VGND VPWR VPWR _0091_ sky130_fd_sc_hd__inv_2
XFILLER_0_43_216 VGND VGND VPWR VPWR sky130_fd_sc_hd__fill_1
XFILLER_0_36_290 VGND VGND VPWR VPWR sky130_fd_sc_hd__decap_4
X_3621_ RF0.regs\[20\]\[9\] _1222_ _1806_ _1809_ VGND VGND VPWR VPWR _1810_ sky130_fd_sc_hd__a211o_1
XFILLER_0_3_335 VGND VGND VPWR VPWR sky130_fd_sc_hd__fill_1
X_3552_ net50 _1742_ VGND VGND VPWR VPWR _1744_ sky130_fd_sc_hd__and2_1
XFILLER_0_11_113 VGND VGND VPWR VPWR sky130_fd_sc_hd__decap_6
XFILLER_0_3_357 VPWR VGND VPWR VGND sky130_ef_sc_hd__decap_12
X_2503_ _0794_ VGND VGND VPWR VPWR _0795_ sky130_fd_sc_hd__clkbuf_4
X_3483_ RF0.regs\[4\]\[17\] _1240_ VGND VGND VPWR VPWR _1676_ sky130_fd_sc_hd__and2_1
XPHY_EDGE_ROW_47_Left_135 VGND VGND VPWR VPWR sky130_fd_sc_hd__decap_3
X_5222_ clknet_leaf_21_clk _0598_ _0214_ VGND VGND VPWR VPWR RF0.regs\[6\]\[13\] sky130_fd_sc_hd__dfrtp_1
XFILLER_0_51_7 VGND VGND VPWR VPWR sky130_fd_sc_hd__decap_3
X_5153_ clknet_leaf_27_clk _0529_ _0145_ VGND VGND VPWR VPWR RF0.regs\[10\]\[8\] sky130_fd_sc_hd__dfrtp_1
X_4104_ _2184_ VGND VGND VPWR VPWR _0579_ sky130_fd_sc_hd__clkbuf_1
X_5084_ clknet_leaf_35_clk _0460_ _0076_ VGND VGND VPWR VPWR RF0.regs\[15\]\[3\] sky130_fd_sc_hd__dfrtp_1
XFILLER_0_47_84 VGND VGND VPWR VPWR sky130_fd_sc_hd__decap_4
X_4035_ _2146_ VGND VGND VPWR VPWR _0609_ sky130_fd_sc_hd__clkbuf_1
XFILLER_0_78_124 VPWR VGND VPWR VGND sky130_ef_sc_hd__decap_12
XFILLER_0_2_53 VPWR VGND VPWR VGND sky130_ef_sc_hd__decap_12
XPHY_EDGE_ROW_56_Left_144 VGND VGND VPWR VPWR sky130_fd_sc_hd__decap_3
XTAP_TAPCELL_ROW_67_789 VGND VPWR sky130_fd_sc_hd__tapvpwrvgnd_1
XFILLER_0_2_97 VGND VGND VPWR VPWR sky130_fd_sc_hd__decap_6
XFILLER_0_66_319 VGND VGND VPWR VPWR sky130_fd_sc_hd__decap_3
X_4937_ _2482_ VGND VGND VPWR VPWR _0326_ sky130_fd_sc_hd__inv_2
XFILLER_0_74_374 VGND VGND VPWR VPWR sky130_fd_sc_hd__decap_8
XFILLER_0_74_352 VPWR VGND VPWR VGND sky130_ef_sc_hd__decap_12
X_4868_ _2474_ VGND VGND VPWR VPWR _0265_ sky130_fd_sc_hd__inv_2
XFILLER_0_19_279 VGND VGND VPWR VPWR sky130_fd_sc_hd__fill_1
X_3819_ _1994_ VGND VGND VPWR VPWR _0670_ sky130_fd_sc_hd__clkbuf_1
X_4799_ _2467_ VGND VGND VPWR VPWR _0203_ sky130_fd_sc_hd__inv_2
XPHY_EDGE_ROW_65_Left_153 VGND VGND VPWR VPWR sky130_fd_sc_hd__decap_3
XFILLER_0_30_477 VGND VGND VPWR VPWR sky130_fd_sc_hd__fill_2
XFILLER_0_30_499 VGND VGND VPWR VPWR sky130_fd_sc_hd__fill_1
XTAP_TAPCELL_ROW_58_712 VGND VPWR sky130_fd_sc_hd__tapvpwrvgnd_1
XPHY_EDGE_ROW_74_Left_162 VGND VGND VPWR VPWR sky130_fd_sc_hd__decap_3
XFILLER_0_69_113 VGND VGND VPWR VPWR sky130_fd_sc_hd__decap_4
XTAP_TAPCELL_ROW_13_303 VGND VPWR sky130_fd_sc_hd__tapvpwrvgnd_1
XFILLER_0_65_385 VGND VGND VPWR VPWR sky130_fd_sc_hd__fill_1
XPHY_EDGE_ROW_83_Left_171 VGND VGND VPWR VPWR sky130_fd_sc_hd__decap_3
XFILLER_0_80_355 VGND VGND VPWR VPWR sky130_fd_sc_hd__decap_3
XTAP_TAPCELL_ROW_21_380 VGND VPWR sky130_fd_sc_hd__tapvpwrvgnd_1
XFILLER_0_33_271 VGND VGND VPWR VPWR sky130_fd_sc_hd__decap_8
XFILLER_0_0_305 VGND VGND VPWR VPWR sky130_fd_sc_hd__decap_3
XFILLER_0_0_327 VGND VGND VPWR VPWR sky130_fd_sc_hd__decap_8
XFILLER_0_21_444 VGND VGND VPWR VPWR sky130_fd_sc_hd__fill_1
XFILLER_0_0_349 VPWR VGND VPWR VGND sky130_ef_sc_hd__decap_12
XFILLER_0_84_27 VGND VGND VPWR VPWR sky130_fd_sc_hd__fill_1
XFILLER_0_8_427 VGND VGND VPWR VPWR sky130_fd_sc_hd__decap_6
XFILLER_0_8_405 VPWR VGND VPWR VGND sky130_ef_sc_hd__decap_12
X_2983_ net148 VGND VGND VPWR VPWR _1197_ sky130_fd_sc_hd__clkbuf_1
X_4722_ _2435_ VGND VGND VPWR VPWR _2457_ sky130_fd_sc_hd__buf_1
XFILLER_0_44_514 VGND VGND VPWR VPWR sky130_fd_sc_hd__decap_3
XFILLER_0_83_193 VGND VGND VPWR VPWR sky130_fd_sc_hd__fill_2
XFILLER_0_16_249 VGND VGND VPWR VPWR sky130_fd_sc_hd__decap_3
XFILLER_0_16_227 VGND VGND VPWR VPWR sky130_fd_sc_hd__fill_1
X_4653_ _2448_ VGND VGND VPWR VPWR _0076_ sky130_fd_sc_hd__inv_2
X_4584_ _2437_ VGND VGND VPWR VPWR _2439_ sky130_fd_sc_hd__clkbuf_8
X_3604_ _1787_ net4 VGND VGND VPWR VPWR _1794_ sky130_fd_sc_hd__nor2_1
X_3535_ RF0.regs\[0\]\[16\] _1218_ _1726_ VGND VGND VPWR VPWR _1727_ sky130_fd_sc_hd__o21ai_1
X_3466_ _1009_ _1631_ _1659_ VGND VGND VPWR VPWR _1660_ sky130_fd_sc_hd__and3_1
X_5205_ clknet_leaf_0_clk _0581_ _0197_ VGND VGND VPWR VPWR RF0.regs\[7\]\[28\] sky130_fd_sc_hd__dfrtp_1
XFILLER_0_58_72 VPWR VGND VPWR VGND sky130_ef_sc_hd__decap_12
XFILLER_0_42_3 VGND VGND VPWR VPWR sky130_fd_sc_hd__decap_8
X_3397_ RF0.regs\[20\]\[27\] _1224_ _1229_ RF0.regs\[15\]\[27\] _1590_ VGND VGND VPWR
+ VPWR _1591_ sky130_fd_sc_hd__a221o_1
X_5136_ clknet_leaf_5_clk _0512_ _0128_ VGND VGND VPWR VPWR RF0.regs\[12\]\[23\] sky130_fd_sc_hd__dfrtp_1
X_5067_ clknet_leaf_12_clk _0443_ _0059_ VGND VGND VPWR VPWR RF0.regs\[20\]\[18\]
+ sky130_fd_sc_hd__dfrtp_1
XFILLER_0_74_82 VGND VGND VPWR VPWR sky130_fd_sc_hd__fill_2
X_4018_ _0821_ _1219_ VGND VGND VPWR VPWR _2137_ sky130_fd_sc_hd__nand2_4
XTAP_TAPCELL_ROW_27_428 VGND VPWR sky130_fd_sc_hd__tapvpwrvgnd_1
XFILLER_0_7_493 VGND VGND VPWR VPWR sky130_fd_sc_hd__decap_8
XFILLER_0_30_274 VPWR VGND VPWR VGND sky130_ef_sc_hd__decap_12
XFILLER_0_85_447 VGND VGND VPWR VPWR sky130_fd_sc_hd__fill_1
XFILLER_0_80_141 VGND VGND VPWR VPWR sky130_fd_sc_hd__decap_3
XFILLER_0_79_27 VPWR VGND VPWR VGND sky130_ef_sc_hd__decap_12
XFILLER_0_53_377 VPWR VGND VPWR VGND sky130_ef_sc_hd__decap_12
Xhold109 RF0.regs\[2\]\[0\] VGND VGND VPWR VPWR net157 sky130_fd_sc_hd__dlygate4sd3_1
XFILLER_0_0_113 VPWR VGND VPWR VGND sky130_ef_sc_hd__decap_12
X_3320_ _1512_ _1515_ VGND VGND VPWR VPWR _1516_ sky130_fd_sc_hd__or2_1
XTAP_TAPCELL_ROW_69_807 VGND VPWR sky130_fd_sc_hd__tapvpwrvgnd_1
X_3251_ RF0.regs\[4\]\[9\] _0835_ _1137_ RF0.regs\[12\]\[9\] _1446_ VGND VGND VPWR
+ VPWR _1447_ sky130_fd_sc_hd__a221o_1
X_3182_ _1268_ VGND VGND VPWR VPWR _1378_ sky130_fd_sc_hd__inv_2
XTAP_TAPCELL_ROW_77_884 VGND VPWR sky130_fd_sc_hd__tapvpwrvgnd_1
XFILLER_0_44_41 VGND VGND VPWR VPWR sky130_fd_sc_hd__decap_4
XTAP_TAPCELL_ROW_24_409 VGND VPWR sky130_fd_sc_hd__tapvpwrvgnd_1
XTAP_TAPCELL_ROW_32_475 VGND VPWR sky130_fd_sc_hd__tapvpwrvgnd_1
XFILLER_0_44_333 VGND VGND VPWR VPWR sky130_fd_sc_hd__decap_6
X_2966_ _1188_ VGND VGND VPWR VPWR _0707_ sky130_fd_sc_hd__clkbuf_1
XFILLER_0_56_171 VGND VGND VPWR VPWR sky130_fd_sc_hd__decap_3
X_2897_ net192 VGND VGND VPWR VPWR _1154_ sky130_fd_sc_hd__clkbuf_1
X_4705_ _2455_ VGND VGND VPWR VPWR _0121_ sky130_fd_sc_hd__inv_2
X_4636_ _2445_ VGND VGND VPWR VPWR _0062_ sky130_fd_sc_hd__inv_2
XFILLER_0_8_41 VPWR VGND VPWR VGND sky130_ef_sc_hd__decap_12
X_4567_ _2432_ VGND VGND VPWR VPWR net23 sky130_fd_sc_hd__clkbuf_2
X_3518_ RF0.regs\[4\]\[18\] _1239_ VGND VGND VPWR VPWR _1710_ sky130_fd_sc_hd__and2_1
X_4498_ _2387_ VGND VGND VPWR VPWR _0780_ sky130_fd_sc_hd__inv_2
X_3449_ RF0.regs\[6\]\[22\] _1232_ _1228_ RF0.regs\[15\]\[22\] _1642_ VGND VGND VPWR
+ VPWR _1643_ sky130_fd_sc_hd__a221o_1
XFILLER_0_85_81 VPWR VGND VPWR VGND sky130_ef_sc_hd__decap_12
X_5119_ clknet_leaf_37_clk _0495_ _0111_ VGND VGND VPWR VPWR RF0.regs\[12\]\[6\] sky130_fd_sc_hd__dfrtp_1
XFILLER_0_79_241 VGND VGND VPWR VPWR sky130_fd_sc_hd__fill_2
XFILLER_0_79_274 VGND VGND VPWR VPWR sky130_fd_sc_hd__decap_3
XFILLER_0_47_160 VGND VGND VPWR VPWR sky130_fd_sc_hd__decap_4
XFILLER_0_35_399 VGND VGND VPWR VPWR sky130_fd_sc_hd__decap_8
XFILLER_0_50_303 VGND VGND VPWR VPWR sky130_fd_sc_hd__fill_2
XFILLER_0_50_336 VGND VGND VPWR VPWR sky130_fd_sc_hd__decap_8
XFILLER_0_81_39 VPWR VGND VPWR VGND sky130_ef_sc_hd__decap_12
XTAP_TAPCELL_ROW_74_854 VGND VPWR sky130_fd_sc_hd__tapvpwrvgnd_1
XFILLER_0_14_77 VGND VGND VPWR VPWR sky130_fd_sc_hd__decap_6
XFILLER_0_45_108 VGND VGND VPWR VPWR sky130_fd_sc_hd__decap_4
X_2820_ _1109_ VGND VGND VPWR VPWR _0774_ sky130_fd_sc_hd__clkbuf_1
XFILLER_0_14_506 VGND VGND VPWR VPWR sky130_fd_sc_hd__decap_6
X_2751_ RF0.regs\[10\]\[4\] _0882_ _0873_ RF0.regs\[5\]\[4\] VGND VGND VPWR VPWR _1043_
+ sky130_fd_sc_hd__a22o_1
XFILLER_0_81_461 VPWR VGND VPWR VGND sky130_ef_sc_hd__decap_12
X_2682_ RF0.regs\[10\]\[11\] _0883_ VGND VGND VPWR VPWR _0974_ sky130_fd_sc_hd__and2_1
X_4421_ net183 _2177_ _1225_ VGND VGND VPWR VPWR _2348_ sky130_fd_sc_hd__mux2_1
XFILLER_0_53_196 VGND VGND VPWR VPWR sky130_fd_sc_hd__fill_2
X_4352_ RF0.regs\[15\]\[1\] _2099_ _2278_ VGND VGND VPWR VPWR _2312_ sky130_fd_sc_hd__mux2_1
X_4283_ _2275_ VGND VGND VPWR VPWR _0491_ sky130_fd_sc_hd__clkbuf_1
X_3303_ _1477_ _1479_ VGND VGND VPWR VPWR _1499_ sky130_fd_sc_hd__nor2_1
X_3234_ _0914_ _1429_ VGND VGND VPWR VPWR _1430_ sky130_fd_sc_hd__and2_1
XFILLER_0_55_51 VGND VGND VPWR VPWR sky130_fd_sc_hd__decap_4
X_3165_ net52 _1267_ VGND VGND VPWR VPWR _1361_ sky130_fd_sc_hd__nand2_1
X_3096_ _1263_ _1045_ VGND VGND VPWR VPWR _1292_ sky130_fd_sc_hd__nor2_1
XTAP_TAPCELL_ROW_37_523 VGND VPWR sky130_fd_sc_hd__tapvpwrvgnd_1
XFILLER_0_49_425 VGND VGND VPWR VPWR sky130_fd_sc_hd__decap_4
XFILLER_0_71_72 VGND VGND VPWR VPWR sky130_fd_sc_hd__fill_1
X_3998_ RF0.regs\[5\]\[9\] _2080_ _2124_ VGND VGND VPWR VPWR _2127_ sky130_fd_sc_hd__mux2_1
X_2949_ net137 VGND VGND VPWR VPWR _1180_ sky130_fd_sc_hd__clkbuf_1
XFILLER_0_44_141 VGND VGND VPWR VPWR sky130_fd_sc_hd__decap_3
X_4619_ _2443_ VGND VGND VPWR VPWR _0047_ sky130_fd_sc_hd__inv_2
XFILLER_0_32_369 VGND VGND VPWR VPWR sky130_fd_sc_hd__fill_1
XTAP_TAPCELL_ROW_71_824 VGND VPWR sky130_fd_sc_hd__tapvpwrvgnd_1
XTAP_TAPCELL_ROW_0_181 VGND VPWR sky130_fd_sc_hd__tapvpwrvgnd_1
XFILLER_0_67_233 VGND VGND VPWR VPWR sky130_fd_sc_hd__decap_3
XTAP_TAPCELL_ROW_0_192 VGND VPWR sky130_fd_sc_hd__tapvpwrvgnd_1
XFILLER_0_55_417 VGND VGND VPWR VPWR sky130_fd_sc_hd__fill_2
XFILLER_0_35_174 VPWR VGND VPWR VGND sky130_ef_sc_hd__decap_12
Xclkload18 clknet_leaf_10_clk VGND VGND VPWR VPWR clkload18/Y sky130_fd_sc_hd__clkinv_4
Xclkload29 clknet_leaf_35_clk VGND VGND VPWR VPWR clkload29/X sky130_fd_sc_hd__clkbuf_4
XFILLER_0_23_325 VGND VGND VPWR VPWR sky130_fd_sc_hd__decap_3
XFILLER_0_50_144 VPWR VGND VPWR VGND sky130_ef_sc_hd__decap_12
XTAP_TAPCELL_ROW_79_902 VGND VPWR sky130_fd_sc_hd__tapvpwrvgnd_1
XFILLER_0_25_87 VGND VGND VPWR VPWR sky130_fd_sc_hd__decap_4
X_4970_ _2485_ VGND VGND VPWR VPWR _0356_ sky130_fd_sc_hd__inv_2
X_3921_ _2081_ VGND VGND VPWR VPWR _0658_ sky130_fd_sc_hd__clkbuf_1
XFILLER_0_58_244 VGND VGND VPWR VPWR sky130_fd_sc_hd__decap_8
XFILLER_0_73_225 VGND VGND VPWR VPWR sky130_fd_sc_hd__decap_6
XFILLER_0_73_203 VPWR VGND VPWR VGND sky130_ef_sc_hd__decap_12
XFILLER_0_41_31 VPWR VGND VPWR VGND sky130_ef_sc_hd__decap_12
X_3852_ _2020_ VGND VGND VPWR VPWR _2021_ sky130_fd_sc_hd__inv_2
XFILLER_0_58_277 VGND VGND VPWR VPWR sky130_fd_sc_hd__decap_8
X_2803_ RF0.regs\[4\]\[28\] _0838_ _0845_ RF0.regs\[12\]\[28\] VGND VGND VPWR VPWR
+ _1095_ sky130_fd_sc_hd__a22o_1
XTAP_TAPCELL_ROW_42_570 VGND VPWR sky130_fd_sc_hd__tapvpwrvgnd_1
X_3783_ RF0.regs\[4\]\[28\] _1965_ _1953_ VGND VGND VPWR VPWR _1966_ sky130_fd_sc_hd__mux2_1
XFILLER_0_54_472 VGND VGND VPWR VPWR sky130_fd_sc_hd__decap_4
X_2734_ RF0.regs\[5\]\[19\] _0875_ _0864_ RF0.regs\[4\]\[19\] VGND VGND VPWR VPWR
+ _1026_ sky130_fd_sc_hd__a22o_1
X_2665_ RF0.regs\[4\]\[0\] _0865_ _0879_ RF0.regs\[2\]\[0\] _0956_ VGND VGND VPWR
+ VPWR _0957_ sky130_fd_sc_hd__a221o_1
X_5384_ clknet_leaf_42_clk _0760_ _0376_ VGND VGND VPWR VPWR IM0.addr\[15\] sky130_fd_sc_hd__dfrtp_1
XFILLER_0_22_380 VGND VGND VPWR VPWR sky130_fd_sc_hd__fill_1
X_2596_ RF0.regs\[10\]\[30\] _0887_ VGND VGND VPWR VPWR _0888_ sky130_fd_sc_hd__and2_1
X_4404_ _2339_ VGND VGND VPWR VPWR _0434_ sky130_fd_sc_hd__clkbuf_1
X_4335_ _2303_ VGND VGND VPWR VPWR _0467_ sky130_fd_sc_hd__clkbuf_1
X_4266_ net75 VGND VGND VPWR VPWR _2267_ sky130_fd_sc_hd__clkbuf_1
X_3217_ _1406_ _1411_ _1412_ VGND VGND VPWR VPWR _1413_ sky130_fd_sc_hd__a21o_1
X_4197_ RF0.regs\[10\]\[12\] _2069_ _2222_ VGND VGND VPWR VPWR _2232_ sky130_fd_sc_hd__mux2_1
X_3148_ _1337_ _1343_ VGND VGND VPWR VPWR _1344_ sky130_fd_sc_hd__nor2_1
XFILLER_0_82_93 VGND VGND VPWR VPWR sky130_fd_sc_hd__decap_8
X_3079_ RF0.regs\[10\]\[9\] _0883_ _0863_ RF0.regs\[4\]\[9\] _1274_ VGND VGND VPWR
+ VPWR _1275_ sky130_fd_sc_hd__a221oi_4
XFILLER_0_49_222 VGND VGND VPWR VPWR sky130_fd_sc_hd__fill_2
XFILLER_0_49_266 VGND VGND VPWR VPWR sky130_fd_sc_hd__decap_3
XFILLER_0_17_130 VPWR VGND VPWR VGND sky130_ef_sc_hd__decap_12
XFILLER_0_72_280 VPWR VGND VPWR VGND sky130_ef_sc_hd__decap_12
XFILLER_0_32_100 VPWR VGND VPWR VGND sky130_ef_sc_hd__decap_12
XFILLER_0_60_464 VGND VGND VPWR VPWR sky130_fd_sc_hd__fill_1
XFILLER_0_60_475 VGND VGND VPWR VPWR sky130_fd_sc_hd__fill_1
XTAP_TAPCELL_ROW_48_618 VGND VPWR sky130_fd_sc_hd__tapvpwrvgnd_1
XFILLER_0_28_406 VGND VGND VPWR VPWR sky130_fd_sc_hd__fill_2
XTAP_TAPCELL_ROW_56_695 VGND VPWR sky130_fd_sc_hd__tapvpwrvgnd_1
XFILLER_0_28_417 VGND VGND VPWR VPWR sky130_fd_sc_hd__decap_3
XFILLER_0_36_461 VGND VGND VPWR VPWR sky130_fd_sc_hd__fill_2
XTAP_TAPCELL_ROW_11_286 VGND VPWR sky130_fd_sc_hd__tapvpwrvgnd_1
XFILLER_0_87_27 VGND VGND VPWR VPWR sky130_fd_sc_hd__fill_1
X_4120_ _2192_ VGND VGND VPWR VPWR _0571_ sky130_fd_sc_hd__clkbuf_1
X_4051_ _2008_ net193 _2149_ VGND VGND VPWR VPWR _2155_ sky130_fd_sc_hd__mux2_1
X_3002_ _1206_ VGND VGND VPWR VPWR _0689_ sky130_fd_sc_hd__clkbuf_1
XFILLER_0_36_64 VGND VGND VPWR VPWR sky130_fd_sc_hd__fill_1
XTAP_TAPCELL_ROW_19_364 VGND VPWR sky130_fd_sc_hd__tapvpwrvgnd_1
X_4953_ _2484_ VGND VGND VPWR VPWR _0340_ sky130_fd_sc_hd__inv_2
XFILLER_0_86_361 VGND VGND VPWR VPWR sky130_fd_sc_hd__decap_3
XFILLER_0_74_501 VPWR VGND VPWR VGND sky130_ef_sc_hd__decap_12
X_3904_ _1781_ _1918_ VGND VGND VPWR VPWR _2068_ sky130_fd_sc_hd__nor2_1
X_4884_ _2475_ VGND VGND VPWR VPWR _0280_ sky130_fd_sc_hd__inv_2
XFILLER_0_52_85 VPWR VGND VPWR VGND sky130_ef_sc_hd__decap_12
X_3835_ _2006_ VGND VGND VPWR VPWR _0666_ sky130_fd_sc_hd__clkbuf_1
X_3766_ _1555_ _1951_ VGND VGND VPWR VPWR _1952_ sky130_fd_sc_hd__xor2_2
X_2717_ _1008_ VGND VGND VPWR VPWR _1009_ sky130_fd_sc_hd__buf_4
XFILLER_0_72_3 VPWR VGND VPWR VGND sky130_ef_sc_hd__decap_12
X_3697_ RF0.regs\[0\]\[1\] _1216_ _1880_ _1882_ VGND VGND VPWR VPWR _1883_ sky130_fd_sc_hd__o22a_1
X_2648_ _0898_ _0900_ _0908_ _0921_ _0939_ VGND VGND VPWR VPWR _0940_ sky130_fd_sc_hd__a2111o_1
X_5367_ clknet_leaf_43_clk _0743_ _0359_ VGND VGND VPWR VPWR RF0.regs\[0\]\[30\] sky130_fd_sc_hd__dfrtp_1
X_2579_ _0869_ _0870_ VGND VGND VPWR VPWR _0871_ sky130_fd_sc_hd__and2b_2
X_4318_ _2294_ VGND VGND VPWR VPWR _0475_ sky130_fd_sc_hd__clkbuf_1
X_5298_ clknet_leaf_7_clk _0674_ _0290_ VGND VGND VPWR VPWR RF0.regs\[4\]\[25\] sky130_fd_sc_hd__dfrtp_1
X_4249_ _2258_ VGND VGND VPWR VPWR _0508_ sky130_fd_sc_hd__clkbuf_1
XTAP_TAPCELL_ROW_2_210 VGND VPWR sky130_fd_sc_hd__tapvpwrvgnd_1
XFILLER_0_77_350 VGND VGND VPWR VPWR sky130_fd_sc_hd__fill_1
XFILLER_0_37_214 VGND VGND VPWR VPWR sky130_fd_sc_hd__decap_4
XTAP_TAPCELL_ROW_53_665 VGND VPWR sky130_fd_sc_hd__tapvpwrvgnd_1
XFILLER_0_37_269 VGND VGND VPWR VPWR sky130_fd_sc_hd__decap_8
XFILLER_0_87_125 VPWR VGND VPWR VGND sky130_ef_sc_hd__decap_12
XTAP_TAPCELL_ROW_16_334 VGND VPWR sky130_fd_sc_hd__tapvpwrvgnd_1
XFILLER_0_56_512 VGND VGND VPWR VPWR sky130_fd_sc_hd__fill_1
XFILLER_0_83_331 VGND VGND VPWR VPWR sky130_fd_sc_hd__fill_2
XFILLER_0_22_88 VGND VGND VPWR VPWR sky130_fd_sc_hd__decap_8
X_3620_ RF0.regs\[7\]\[9\] _1243_ _1808_ VGND VGND VPWR VPWR _1809_ sky130_fd_sc_hd__a21o_1
X_3551_ net50 _1742_ VGND VGND VPWR VPWR _1743_ sky130_fd_sc_hd__nor2_1
XFILLER_0_3_369 VPWR VGND VPWR VGND sky130_ef_sc_hd__decap_12
X_2502_ _0781_ _0787_ _0793_ VGND VGND VPWR VPWR _0794_ sky130_fd_sc_hd__nand3b_4
X_3482_ _1652_ _1663_ _1674_ VGND VGND VPWR VPWR _1675_ sky130_fd_sc_hd__or3_1
X_5221_ clknet_leaf_22_clk _0597_ _0213_ VGND VGND VPWR VPWR RF0.regs\[6\]\[12\] sky130_fd_sc_hd__dfrtp_1
X_5152_ clknet_leaf_38_clk _0528_ _0144_ VGND VGND VPWR VPWR RF0.regs\[10\]\[7\] sky130_fd_sc_hd__dfrtp_1
X_4103_ net144 VGND VGND VPWR VPWR _2184_ sky130_fd_sc_hd__clkbuf_1
X_5083_ clknet_leaf_41_clk _0459_ _0075_ VGND VGND VPWR VPWR RF0.regs\[15\]\[2\] sky130_fd_sc_hd__dfrtp_1
X_4034_ _1981_ net262 _2138_ VGND VGND VPWR VPWR _2146_ sky130_fd_sc_hd__mux2_1
XFILLER_0_78_136 VGND VGND VPWR VPWR sky130_fd_sc_hd__decap_4
XFILLER_0_2_65 VPWR VGND VPWR VGND sky130_ef_sc_hd__decap_12
XFILLER_0_63_51 VGND VGND VPWR VPWR sky130_fd_sc_hd__decap_4
XFILLER_0_63_73 VGND VGND VPWR VPWR sky130_fd_sc_hd__fill_1
XFILLER_0_66_309 VGND VGND VPWR VPWR sky130_fd_sc_hd__decap_6
XFILLER_0_59_383 VGND VGND VPWR VPWR sky130_fd_sc_hd__decap_3
XFILLER_0_19_225 VGND VGND VPWR VPWR sky130_fd_sc_hd__fill_1
X_4936_ _2482_ VGND VGND VPWR VPWR _0325_ sky130_fd_sc_hd__inv_2
X_4867_ _2474_ VGND VGND VPWR VPWR _0264_ sky130_fd_sc_hd__inv_2
XTAP_TAPCELL_ROW_50_635 VGND VPWR sky130_fd_sc_hd__tapvpwrvgnd_1
X_3818_ RF0.regs\[4\]\[21\] _1992_ _1993_ VGND VGND VPWR VPWR _1994_ sky130_fd_sc_hd__mux2_1
XFILLER_0_6_141 VGND VGND VPWR VPWR sky130_fd_sc_hd__decap_6
X_4798_ _2467_ VGND VGND VPWR VPWR _0202_ sky130_fd_sc_hd__inv_2
XFILLER_0_6_174 VGND VGND VPWR VPWR sky130_fd_sc_hd__fill_2
XFILLER_0_42_250 VGND VGND VPWR VPWR sky130_fd_sc_hd__fill_2
X_3749_ _1607_ _1608_ VGND VGND VPWR VPWR _1935_ sky130_fd_sc_hd__nand2_1
X_5419_ clknet_leaf_32_clk _0777_ VGND VGND VPWR VPWR net34 sky130_fd_sc_hd__dfxtp_1
XTAP_TAPCELL_ROW_58_713 VGND VPWR sky130_fd_sc_hd__tapvpwrvgnd_1
Xmax_cap45 _1924_ VGND VGND VPWR VPWR net45 sky130_fd_sc_hd__clkbuf_2
XFILLER_0_69_169 VGND VGND VPWR VPWR sky130_fd_sc_hd__fill_1
XTAP_TAPCELL_ROW_13_304 VGND VPWR sky130_fd_sc_hd__tapvpwrvgnd_1
XFILLER_0_18_280 VGND VGND VPWR VPWR sky130_fd_sc_hd__decap_8
XFILLER_0_25_239 VGND VGND VPWR VPWR sky130_fd_sc_hd__fill_2
XTAP_TAPCELL_ROW_21_381 VGND VPWR sky130_fd_sc_hd__tapvpwrvgnd_1
XFILLER_0_68_29 VGND VGND VPWR VPWR sky130_fd_sc_hd__fill_1
XFILLER_0_17_55 VGND VGND VPWR VPWR sky130_fd_sc_hd__fill_1
XFILLER_0_17_88 VPWR VGND VPWR VGND sky130_ef_sc_hd__decap_12
X_2982_ _1196_ VGND VGND VPWR VPWR _0699_ sky130_fd_sc_hd__clkbuf_1
XFILLER_0_8_417 VGND VGND VPWR VPWR sky130_fd_sc_hd__decap_3
X_4721_ _2456_ VGND VGND VPWR VPWR _0136_ sky130_fd_sc_hd__inv_2
XFILLER_0_83_172 VGND VGND VPWR VPWR sky130_fd_sc_hd__fill_1
X_4652_ _2448_ VGND VGND VPWR VPWR _0075_ sky130_fd_sc_hd__inv_2
X_3603_ _0797_ _1793_ VGND VGND VPWR VPWR net4 sky130_fd_sc_hd__nor2_1
XFILLER_0_12_401 VGND VGND VPWR VPWR sky130_fd_sc_hd__decap_4
XFILLER_0_3_144 VGND VGND VPWR VPWR sky130_fd_sc_hd__fill_2
XFILLER_0_24_250 VGND VGND VPWR VPWR sky130_fd_sc_hd__fill_2
X_4583_ _2438_ VGND VGND VPWR VPWR _0016_ sky130_fd_sc_hd__inv_2
X_3534_ RF0.regs\[20\]\[16\] _1224_ _1722_ _1725_ VGND VGND VPWR VPWR _1726_ sky130_fd_sc_hd__a211o_1
XFILLER_0_3_166 VGND VGND VPWR VPWR sky130_fd_sc_hd__fill_2
X_3465_ _1501_ _1512_ VGND VGND VPWR VPWR _1659_ sky130_fd_sc_hd__nand2_1
X_5204_ clknet_leaf_7_clk _0580_ _0196_ VGND VGND VPWR VPWR RF0.regs\[7\]\[27\] sky130_fd_sc_hd__dfrtp_1
X_3396_ RF0.regs\[5\]\[27\] _0961_ _1139_ VGND VGND VPWR VPWR _1590_ sky130_fd_sc_hd__and3_1
XFILLER_0_58_95 VPWR VGND VPWR VGND sky130_ef_sc_hd__decap_12
X_5135_ clknet_leaf_5_clk _0511_ _0127_ VGND VGND VPWR VPWR RF0.regs\[12\]\[22\] sky130_fd_sc_hd__dfrtp_1
X_5066_ clknet_leaf_18_clk _0442_ _0058_ VGND VGND VPWR VPWR RF0.regs\[20\]\[17\]
+ sky130_fd_sc_hd__dfrtp_1
X_4017_ _2136_ VGND VGND VPWR VPWR _0617_ sky130_fd_sc_hd__clkbuf_1
XFILLER_0_79_456 VPWR VGND VPWR VGND sky130_ef_sc_hd__decap_12
XTAP_TAPCELL_ROW_27_429 VGND VPWR sky130_fd_sc_hd__tapvpwrvgnd_1
XFILLER_0_59_180 VGND VGND VPWR VPWR sky130_fd_sc_hd__fill_1
XTAP_TAPCELL_ROW_63_760 VGND VPWR sky130_fd_sc_hd__tapvpwrvgnd_1
X_4919_ _2481_ VGND VGND VPWR VPWR _0309_ sky130_fd_sc_hd__inv_2
XFILLER_0_15_250 VPWR VGND VPWR VGND sky130_ef_sc_hd__decap_12
XFILLER_0_30_286 VGND VGND VPWR VPWR sky130_fd_sc_hd__decap_8
XFILLER_0_65_172 VGND VGND VPWR VPWR sky130_fd_sc_hd__decap_6
XFILLER_0_80_120 VGND VGND VPWR VPWR sky130_fd_sc_hd__fill_1
XFILLER_0_79_39 VPWR VGND VPWR VGND sky130_ef_sc_hd__decap_12
XFILLER_0_53_389 VGND VGND VPWR VPWR sky130_fd_sc_hd__decap_3
XFILLER_0_80_197 VPWR VGND VPWR VGND sky130_ef_sc_hd__decap_12
XFILLER_0_0_125 VPWR VGND VPWR VGND sky130_ef_sc_hd__decap_12
XFILLER_0_0_169 VGND VGND VPWR VPWR sky130_fd_sc_hd__fill_2
XTAP_TAPCELL_ROW_69_808 VGND VPWR sky130_fd_sc_hd__tapvpwrvgnd_1
X_3250_ RF0.regs\[10\]\[9\] _0809_ _1220_ RF0.regs\[25\]\[9\] VGND VGND VPWR VPWR
+ _1446_ sky130_fd_sc_hd__a22o_1
X_3181_ RF0.regs\[10\]\[13\] _0811_ _1254_ RF0.regs\[12\]\[13\] _1376_ VGND VGND VPWR
+ VPWR _1377_ sky130_fd_sc_hd__a221o_1
XTAP_TAPCELL_ROW_77_885 VGND VPWR sky130_fd_sc_hd__tapvpwrvgnd_1
XFILLER_0_48_106 VPWR VGND VPWR VGND sky130_ef_sc_hd__decap_12
XTAP_TAPCELL_ROW_60_730 VGND VPWR sky130_fd_sc_hd__tapvpwrvgnd_1
X_2965_ net114 VGND VGND VPWR VPWR _1188_ sky130_fd_sc_hd__clkbuf_1
X_4704_ _2455_ VGND VGND VPWR VPWR _0120_ sky130_fd_sc_hd__inv_2
X_2896_ _1153_ VGND VGND VPWR VPWR _0742_ sky130_fd_sc_hd__clkbuf_1
XTAP_TAPCELL_ROW_32_476 VGND VPWR sky130_fd_sc_hd__tapvpwrvgnd_1
XFILLER_0_60_85 VGND VGND VPWR VPWR sky130_fd_sc_hd__decap_4
X_4635_ _2445_ VGND VGND VPWR VPWR _0061_ sky130_fd_sc_hd__inv_2
XFILLER_0_71_164 VGND VGND VPWR VPWR sky130_fd_sc_hd__decap_4
XFILLER_0_8_53 VPWR VGND VPWR VGND sky130_ef_sc_hd__decap_12
XFILLER_0_4_475 VGND VGND VPWR VPWR sky130_fd_sc_hd__fill_1
X_4566_ _1571_ _1548_ _1149_ VGND VGND VPWR VPWR _2432_ sky130_fd_sc_hd__and3_1
XFILLER_0_12_253 VGND VGND VPWR VPWR sky130_fd_sc_hd__decap_8
X_3517_ _1703_ _1709_ _1704_ _1577_ _1217_ VGND VGND VPWR VPWR net11 sky130_fd_sc_hd__o2111a_1
X_4497_ disp.digit_select\[0\] disp.digit_select\[1\] VGND VGND VPWR VPWR _2387_ sky130_fd_sc_hd__and2_2
X_3448_ RF0.regs\[4\]\[22\] _1240_ VGND VGND VPWR VPWR _1642_ sky130_fd_sc_hd__and2_1
X_3379_ _1096_ _1346_ VGND VGND VPWR VPWR _1574_ sky130_fd_sc_hd__or2_1
XFILLER_0_85_93 VPWR VGND VPWR VGND sky130_ef_sc_hd__decap_12
X_5118_ clknet_leaf_28_clk _0494_ _0110_ VGND VGND VPWR VPWR RF0.regs\[12\]\[5\] sky130_fd_sc_hd__dfrtp_1
X_5049_ clknet_leaf_41_clk _0425_ _0041_ VGND VGND VPWR VPWR RF0.regs\[20\]\[0\] sky130_fd_sc_hd__dfrtp_1
XFILLER_0_67_415 VGND VGND VPWR VPWR sky130_fd_sc_hd__fill_1
XFILLER_0_54_109 VGND VGND VPWR VPWR sky130_fd_sc_hd__decap_3
XFILLER_0_35_301 VGND VGND VPWR VPWR sky130_fd_sc_hd__decap_6
XFILLER_0_35_334 VGND VGND VPWR VPWR sky130_fd_sc_hd__fill_2
XFILLER_0_62_197 VGND VGND VPWR VPWR sky130_fd_sc_hd__fill_2
XTAP_TAPCELL_ROW_74_855 VGND VPWR sky130_fd_sc_hd__tapvpwrvgnd_1
XFILLER_0_85_223 VGND VGND VPWR VPWR sky130_fd_sc_hd__fill_1
XFILLER_0_26_323 VPWR VGND VPWR VGND sky130_ef_sc_hd__decap_12
XFILLER_0_38_183 VPWR VGND VPWR VGND sky130_ef_sc_hd__decap_12
X_2750_ RF0.regs\[10\]\[8\] _0810_ _0827_ RF0.regs\[25\]\[8\] _1041_ VGND VGND VPWR
+ VPWR _1042_ sky130_fd_sc_hd__a221o_2
XFILLER_0_53_131 VGND VGND VPWR VPWR sky130_fd_sc_hd__decap_8
XFILLER_0_81_473 VPWR VGND VPWR VGND sky130_ef_sc_hd__decap_12
X_2681_ _0970_ _0972_ VGND VGND VPWR VPWR _0973_ sky130_fd_sc_hd__xor2_1
X_4420_ _2347_ VGND VGND VPWR VPWR _0426_ sky130_fd_sc_hd__clkbuf_1
XFILLER_0_41_337 VGND VGND VPWR VPWR sky130_fd_sc_hd__decap_8
X_4351_ _2311_ VGND VGND VPWR VPWR _0459_ sky130_fd_sc_hd__clkbuf_1
X_4282_ net82 VGND VGND VPWR VPWR _2275_ sky130_fd_sc_hd__clkbuf_1
X_3302_ _1477_ _1479_ _1491_ VGND VGND VPWR VPWR _1498_ sky130_fd_sc_hd__a21oi_1
X_3233_ _1257_ _1428_ _0827_ VGND VGND VPWR VPWR _1429_ sky130_fd_sc_hd__a21o_1
X_3164_ _1359_ VGND VGND VPWR VPWR _1360_ sky130_fd_sc_hd__inv_2
X_3095_ _1286_ _1282_ _1278_ _1290_ VGND VGND VPWR VPWR _1291_ sky130_fd_sc_hd__or4b_4
XTAP_TAPCELL_ROW_37_524 VGND VPWR sky130_fd_sc_hd__tapvpwrvgnd_1
XFILLER_0_76_234 VPWR VGND VPWR VGND sky130_ef_sc_hd__decap_12
XTAP_TAPCELL_ROW_45_590 VGND VPWR sky130_fd_sc_hd__tapvpwrvgnd_1
X_3997_ _2126_ VGND VGND VPWR VPWR _0627_ sky130_fd_sc_hd__clkbuf_1
X_2948_ _1179_ VGND VGND VPWR VPWR _0716_ sky130_fd_sc_hd__clkbuf_1
XFILLER_0_44_131 VGND VGND VPWR VPWR sky130_fd_sc_hd__decap_8
XFILLER_0_32_315 VGND VGND VPWR VPWR sky130_fd_sc_hd__fill_1
X_4618_ _2443_ VGND VGND VPWR VPWR _0046_ sky130_fd_sc_hd__inv_2
X_2879_ _1108_ _1138_ _1141_ _1142_ VGND VGND VPWR VPWR _0748_ sky130_fd_sc_hd__o31a_1
XFILLER_0_44_197 VGND VGND VPWR VPWR sky130_fd_sc_hd__decap_4
X_4549_ _0799_ _1475_ _1728_ VGND VGND VPWR VPWR net9 sky130_fd_sc_hd__nor3_1
XTAP_TAPCELL_ROW_71_825 VGND VPWR sky130_fd_sc_hd__tapvpwrvgnd_1
XTAP_TAPCELL_ROW_0_182 VGND VPWR sky130_fd_sc_hd__tapvpwrvgnd_1
XTAP_TAPCELL_ROW_0_193 VGND VPWR sky130_fd_sc_hd__tapvpwrvgnd_1
XFILLER_0_67_245 VGND VGND VPWR VPWR sky130_fd_sc_hd__fill_2
XFILLER_0_27_109 VGND VGND VPWR VPWR sky130_fd_sc_hd__decap_3
XFILLER_0_23_304 VGND VGND VPWR VPWR sky130_fd_sc_hd__decap_6
XFILLER_0_35_153 VGND VGND VPWR VPWR sky130_fd_sc_hd__decap_6
Xclkload19 clknet_leaf_12_clk VGND VGND VPWR VPWR clkload19/Y sky130_fd_sc_hd__clkinvlp_4
XFILLER_0_35_186 VPWR VGND VPWR VGND sky130_ef_sc_hd__decap_12
XFILLER_0_50_156 VGND VGND VPWR VPWR sky130_fd_sc_hd__decap_8
XFILLER_0_76_29 VPWR VGND VPWR VGND sky130_ef_sc_hd__decap_12
XTAP_TAPCELL_ROW_79_903 VGND VPWR sky130_fd_sc_hd__tapvpwrvgnd_1
XTAP_TAPCELL_ROW_8_260 VGND VPWR sky130_fd_sc_hd__tapvpwrvgnd_1
XTAP_TAPCELL_ROW_87_980 VGND VPWR sky130_fd_sc_hd__tapvpwrvgnd_1
X_3920_ RF0.regs\[4\]\[9\] _2080_ _2073_ VGND VGND VPWR VPWR _2081_ sky130_fd_sc_hd__mux2_1
XFILLER_0_73_215 VGND VGND VPWR VPWR sky130_fd_sc_hd__decap_8
X_3851_ _1787_ net4 VGND VGND VPWR VPWR _2020_ sky130_fd_sc_hd__and2_1
X_3782_ _1960_ _1964_ VGND VGND VPWR VPWR _1965_ sky130_fd_sc_hd__and2_1
X_2802_ RF0.regs\[2\]\[28\] _0879_ _1092_ _1093_ VGND VGND VPWR VPWR _1094_ sky130_fd_sc_hd__a211oi_2
XFILLER_0_41_43 VGND VGND VPWR VPWR sky130_fd_sc_hd__decap_8
XTAP_TAPCELL_ROW_42_571 VGND VPWR sky130_fd_sc_hd__tapvpwrvgnd_1
X_2733_ RF0.regs\[10\]\[21\] _0812_ _0828_ RF0.regs\[25\]\[21\] _1024_ VGND VGND VPWR
+ VPWR _1025_ sky130_fd_sc_hd__a221oi_4
XFILLER_0_81_281 VPWR VGND VPWR VGND sky130_ef_sc_hd__decap_12
XFILLER_0_26_197 VGND VGND VPWR VPWR sky130_fd_sc_hd__decap_4
X_2664_ RF0.regs\[15\]\[0\] _0855_ _0954_ _0955_ VGND VGND VPWR VPWR _0956_ sky130_fd_sc_hd__a211o_1
XFILLER_0_41_167 VGND VGND VPWR VPWR sky130_fd_sc_hd__fill_1
X_5383_ clknet_leaf_42_clk _0759_ _0375_ VGND VGND VPWR VPWR IM0.addr\[14\] sky130_fd_sc_hd__dfrtp_1
X_4403_ net196 _2080_ _2336_ VGND VGND VPWR VPWR _2339_ sky130_fd_sc_hd__mux2_1
X_2595_ _0886_ VGND VGND VPWR VPWR _0887_ sky130_fd_sc_hd__clkbuf_4
X_4334_ RF0.regs\[15\]\[10\] _2077_ _2301_ VGND VGND VPWR VPWR _2303_ sky130_fd_sc_hd__mux2_1
X_4265_ _2266_ VGND VGND VPWR VPWR _0500_ sky130_fd_sc_hd__clkbuf_1
X_4196_ _2231_ VGND VGND VPWR VPWR _0534_ sky130_fd_sc_hd__clkbuf_1
X_3216_ _1408_ _1410_ VGND VGND VPWR VPWR _1412_ sky130_fd_sc_hd__nor2_1
X_3147_ _1335_ _1336_ _0841_ VGND VGND VPWR VPWR _1343_ sky130_fd_sc_hd__o21ai_1
XFILLER_0_82_83 VGND VGND VPWR VPWR sky130_fd_sc_hd__fill_1
X_3078_ RF0.regs\[2\]\[9\] _1236_ _0873_ RF0.regs\[5\]\[9\] _0980_ VGND VGND VPWR
+ VPWR _1274_ sky130_fd_sc_hd__a221o_1
XFILLER_0_37_407 VGND VGND VPWR VPWR sky130_fd_sc_hd__decap_8
XFILLER_0_49_234 VPWR VGND VPWR VGND sky130_ef_sc_hd__decap_12
XFILLER_0_49_278 VGND VGND VPWR VPWR sky130_fd_sc_hd__fill_2
XFILLER_0_17_142 VGND VGND VPWR VPWR sky130_fd_sc_hd__fill_1
XFILLER_0_72_292 VGND VGND VPWR VPWR sky130_fd_sc_hd__decap_3
XFILLER_0_32_112 VPWR VGND VPWR VGND sky130_ef_sc_hd__decap_12
XFILLER_0_60_421 VGND VGND VPWR VPWR sky130_fd_sc_hd__decap_6
XFILLER_0_60_410 VGND VGND VPWR VPWR sky130_fd_sc_hd__fill_1
XFILLER_0_20_307 VGND VGND VPWR VPWR sky130_fd_sc_hd__fill_1
XFILLER_0_20_318 VGND VGND VPWR VPWR sky130_fd_sc_hd__decap_6
XFILLER_0_20_329 VGND VGND VPWR VPWR sky130_fd_sc_hd__decap_8
XFILLER_0_32_167 VGND VGND VPWR VPWR sky130_fd_sc_hd__decap_6
XTAP_TAPCELL_ROW_5_230 VGND VPWR sky130_fd_sc_hd__tapvpwrvgnd_1
XTAP_TAPCELL_ROW_48_619 VGND VPWR sky130_fd_sc_hd__tapvpwrvgnd_1
XTAP_TAPCELL_ROW_56_696 VGND VPWR sky130_fd_sc_hd__tapvpwrvgnd_1
XFILLER_0_11_57 VPWR VGND VPWR VGND sky130_ef_sc_hd__decap_12
XFILLER_0_51_421 VGND VGND VPWR VPWR sky130_fd_sc_hd__decap_6
XTAP_TAPCELL_ROW_11_287 VGND VPWR sky130_fd_sc_hd__tapvpwrvgnd_1
X_4050_ _2154_ VGND VGND VPWR VPWR _0602_ sky130_fd_sc_hd__clkbuf_1
X_3001_ net163 VGND VGND VPWR VPWR _1206_ sky130_fd_sc_hd__clkbuf_1
X_4952_ _2484_ VGND VGND VPWR VPWR _0339_ sky130_fd_sc_hd__inv_2
X_3903_ _2067_ VGND VGND VPWR VPWR _0662_ sky130_fd_sc_hd__clkbuf_1
XFILLER_0_74_513 VGND VGND VPWR VPWR sky130_fd_sc_hd__decap_4
X_4883_ _2475_ VGND VGND VPWR VPWR _0279_ sky130_fd_sc_hd__inv_2
X_3834_ RF0.regs\[4\]\[17\] _2005_ _1993_ VGND VGND VPWR VPWR _2006_ sky130_fd_sc_hd__mux2_1
XFILLER_0_52_97 VGND VGND VPWR VPWR sky130_fd_sc_hd__decap_8
X_3765_ _1564_ _1573_ _1949_ _1950_ VGND VGND VPWR VPWR _1951_ sky130_fd_sc_hd__o31a_1
X_3696_ RF0.regs\[4\]\[1\] _1237_ _1242_ RF0.regs\[7\]\[1\] _1881_ VGND VGND VPWR
+ VPWR _1882_ sky130_fd_sc_hd__a221o_1
X_2716_ _1007_ VGND VGND VPWR VPWR _1008_ sky130_fd_sc_hd__clkbuf_4
X_2647_ _0924_ _0926_ _0929_ _0932_ _0938_ VGND VGND VPWR VPWR _0939_ sky130_fd_sc_hd__a221o_1
XFILLER_0_65_3 VPWR VGND VPWR VGND sky130_ef_sc_hd__decap_12
X_5366_ clknet_leaf_45_clk _0742_ _0358_ VGND VGND VPWR VPWR RF0.regs\[0\]\[29\] sky130_fd_sc_hd__dfrtp_1
X_2578_ _0821_ _0796_ _0858_ VGND VGND VPWR VPWR _0870_ sky130_fd_sc_hd__or3_4
X_4317_ RF0.regs\[15\]\[18\] _2002_ _2290_ VGND VGND VPWR VPWR _2294_ sky130_fd_sc_hd__mux2_1
X_5297_ clknet_leaf_7_clk _0673_ _0289_ VGND VGND VPWR VPWR RF0.regs\[4\]\[24\] sky130_fd_sc_hd__dfrtp_1
X_4248_ RF0.regs\[12\]\[19\] VGND VGND VPWR VPWR _2258_ sky130_fd_sc_hd__clkbuf_1
XTAP_TAPCELL_ROW_2_211 VGND VPWR sky130_fd_sc_hd__tapvpwrvgnd_1
X_4179_ RF0.regs\[10\]\[21\] _1992_ _2222_ VGND VGND VPWR VPWR _2223_ sky130_fd_sc_hd__mux2_1
XTAP_TAPCELL_ROW_81_920 VGND VPWR sky130_fd_sc_hd__tapvpwrvgnd_1
XTAP_TAPCELL_ROW_53_666 VGND VPWR sky130_fd_sc_hd__tapvpwrvgnd_1
XFILLER_0_37_248 VGND VGND VPWR VPWR sky130_fd_sc_hd__fill_1
XPHY_EDGE_ROW_14_Right_14 VGND VGND VPWR VPWR sky130_fd_sc_hd__decap_3
XFILLER_0_20_104 VGND VGND VPWR VPWR sky130_fd_sc_hd__decap_3
XPHY_EDGE_ROW_23_Right_23 VGND VGND VPWR VPWR sky130_fd_sc_hd__decap_3
XFILLER_0_87_137 VGND VGND VPWR VPWR sky130_fd_sc_hd__decap_3
XTAP_TAPCELL_ROW_16_335 VGND VPWR sky130_fd_sc_hd__tapvpwrvgnd_1
XPHY_EDGE_ROW_32_Right_32 VGND VGND VPWR VPWR sky130_fd_sc_hd__decap_3
XFILLER_0_71_505 VPWR VGND VPWR VGND sky130_ef_sc_hd__decap_12
X_3550_ _1465_ _1373_ _1741_ VGND VGND VPWR VPWR _1742_ sky130_fd_sc_hd__o21bai_1
X_2501_ _0792_ VGND VGND VPWR VPWR _0793_ sky130_fd_sc_hd__buf_6
X_3481_ _1669_ net15 VGND VGND VPWR VPWR _1674_ sky130_fd_sc_hd__xnor2_2
X_5220_ clknet_leaf_24_clk _0596_ _0212_ VGND VGND VPWR VPWR RF0.regs\[6\]\[11\] sky130_fd_sc_hd__dfrtp_1
XPHY_EDGE_ROW_41_Right_41 VGND VGND VPWR VPWR sky130_fd_sc_hd__decap_3
X_5151_ clknet_leaf_37_clk _0527_ _0143_ VGND VGND VPWR VPWR RF0.regs\[10\]\[6\] sky130_fd_sc_hd__dfrtp_1
X_5082_ clknet_leaf_40_clk _0458_ _0074_ VGND VGND VPWR VPWR RF0.regs\[15\]\[1\] sky130_fd_sc_hd__dfrtp_1
X_4102_ _2183_ VGND VGND VPWR VPWR _0580_ sky130_fd_sc_hd__clkbuf_1
X_4033_ _2145_ VGND VGND VPWR VPWR _0610_ sky130_fd_sc_hd__clkbuf_1
XFILLER_0_47_75 VGND VGND VPWR VPWR sky130_fd_sc_hd__fill_1
XFILLER_0_2_77 VGND VGND VPWR VPWR sky130_fd_sc_hd__decap_6
XPHY_EDGE_ROW_50_Right_50 VGND VGND VPWR VPWR sky130_fd_sc_hd__decap_3
XFILLER_0_59_351 VGND VGND VPWR VPWR sky130_fd_sc_hd__fill_2
X_4935_ _2482_ VGND VGND VPWR VPWR _0324_ sky130_fd_sc_hd__inv_2
XFILLER_0_74_365 VGND VGND VPWR VPWR sky130_fd_sc_hd__decap_6
X_4866_ _2474_ VGND VGND VPWR VPWR _0263_ sky130_fd_sc_hd__inv_2
XTAP_TAPCELL_ROW_50_636 VGND VPWR sky130_fd_sc_hd__tapvpwrvgnd_1
XFILLER_0_62_505 VPWR VGND VPWR VGND sky130_ef_sc_hd__decap_12
XFILLER_0_74_398 VGND VGND VPWR VPWR sky130_fd_sc_hd__decap_6
X_4797_ _2467_ VGND VGND VPWR VPWR _0201_ sky130_fd_sc_hd__inv_2
XFILLER_0_27_281 VPWR VGND VPWR VGND sky130_ef_sc_hd__decap_12
X_3817_ _1241_ VGND VGND VPWR VPWR _1993_ sky130_fd_sc_hd__buf_4
XFILLER_0_42_240 VGND VGND VPWR VPWR sky130_fd_sc_hd__fill_2
X_3748_ _1607_ _1608_ VGND VGND VPWR VPWR _1934_ sky130_fd_sc_hd__or2_1
XFILLER_0_15_498 VGND VGND VPWR VPWR sky130_fd_sc_hd__decap_6
X_3679_ RF0.regs\[4\]\[3\] _1237_ net47 RF0.regs\[7\]\[3\] _1864_ VGND VGND VPWR VPWR
+ _1865_ sky130_fd_sc_hd__a221o_1
X_5418_ clknet_leaf_30_clk _0008_ VGND VGND VPWR VPWR disp.digit_select\[1\] sky130_fd_sc_hd__dfxtp_1
X_5349_ clknet_leaf_22_clk _0725_ _0341_ VGND VGND VPWR VPWR RF0.regs\[0\]\[12\] sky130_fd_sc_hd__dfrtp_1
XTAP_TAPCELL_ROW_58_714 VGND VPWR sky130_fd_sc_hd__tapvpwrvgnd_1
XFILLER_0_69_126 VGND VGND VPWR VPWR sky130_fd_sc_hd__fill_1
Xmax_cap46 _1299_ VGND VGND VPWR VPWR net46 sky130_fd_sc_hd__clkbuf_2
XTAP_TAPCELL_ROW_66_780 VGND VPWR sky130_fd_sc_hd__tapvpwrvgnd_1
XFILLER_0_38_513 VGND VGND VPWR VPWR sky130_fd_sc_hd__decap_4
XFILLER_0_77_181 VGND VGND VPWR VPWR sky130_fd_sc_hd__fill_1
XTAP_TAPCELL_ROW_13_305 VGND VPWR sky130_fd_sc_hd__tapvpwrvgnd_1
XFILLER_0_65_321 VPWR VGND VPWR VGND sky130_ef_sc_hd__decap_12
XFILLER_0_53_516 VGND VGND VPWR VPWR sky130_fd_sc_hd__fill_1
XTAP_TAPCELL_ROW_21_382 VGND VPWR sky130_fd_sc_hd__tapvpwrvgnd_1
XFILLER_0_33_295 VGND VGND VPWR VPWR sky130_fd_sc_hd__fill_1
XFILLER_0_21_468 VGND VGND VPWR VPWR sky130_fd_sc_hd__fill_1
XFILLER_0_84_29 VPWR VGND VPWR VGND sky130_ef_sc_hd__decap_12
XFILLER_0_29_502 VGND VGND VPWR VPWR sky130_fd_sc_hd__fill_2
X_2981_ net89 VGND VGND VPWR VPWR _1196_ sky130_fd_sc_hd__clkbuf_1
Xclkbuf_leaf_41_clk clknet_2_0__leaf_clk VGND VGND VPWR VPWR clknet_leaf_41_clk sky130_fd_sc_hd__clkbuf_8
X_4720_ _2456_ VGND VGND VPWR VPWR _0135_ sky130_fd_sc_hd__inv_2
XFILLER_0_56_365 VGND VGND VPWR VPWR sky130_fd_sc_hd__decap_3
X_4651_ _2448_ VGND VGND VPWR VPWR _0074_ sky130_fd_sc_hd__inv_2
XFILLER_0_71_335 VGND VGND VPWR VPWR sky130_fd_sc_hd__fill_1
X_3602_ net60 _1792_ VGND VGND VPWR VPWR _1793_ sky130_fd_sc_hd__xnor2_1
XFILLER_0_71_379 VGND VGND VPWR VPWR sky130_fd_sc_hd__decap_8
XFILLER_0_24_240 VGND VGND VPWR VPWR sky130_fd_sc_hd__decap_4
XFILLER_0_24_262 VPWR VGND VPWR VGND sky130_ef_sc_hd__decap_12
X_4582_ _2438_ VGND VGND VPWR VPWR _0015_ sky130_fd_sc_hd__inv_2
X_3533_ RF0.regs\[7\]\[16\] _1244_ _1723_ _1724_ VGND VGND VPWR VPWR _1725_ sky130_fd_sc_hd__a211o_1
X_3464_ RF0.regs\[0\]\[20\] _1218_ _1654_ _1657_ VGND VGND VPWR VPWR _1658_ sky130_fd_sc_hd__o22a_1
X_5203_ clknet_leaf_6_clk _0579_ _0195_ VGND VGND VPWR VPWR RF0.regs\[7\]\[26\] sky130_fd_sc_hd__dfrtp_1
X_3395_ _1542_ _1588_ VGND VGND VPWR VPWR _1589_ sky130_fd_sc_hd__xnor2_1
XFILLER_0_58_85 VGND VGND VPWR VPWR sky130_fd_sc_hd__fill_2
X_5134_ clknet_leaf_14_clk _0510_ _0126_ VGND VGND VPWR VPWR RF0.regs\[12\]\[21\]
+ sky130_fd_sc_hd__dfrtp_1
X_5065_ clknet_leaf_18_clk _0441_ _0057_ VGND VGND VPWR VPWR RF0.regs\[20\]\[16\]
+ sky130_fd_sc_hd__dfrtp_1
XFILLER_0_79_402 VPWR VGND VPWR VGND sky130_ef_sc_hd__decap_12
X_4016_ net203 VGND VGND VPWR VPWR _2136_ sky130_fd_sc_hd__clkbuf_1
XFILLER_0_28_3 VPWR VGND VPWR VGND sky130_ef_sc_hd__decap_12
XFILLER_0_79_468 VPWR VGND VPWR VGND sky130_ef_sc_hd__decap_12
XFILLER_0_47_310 VGND VGND VPWR VPWR sky130_fd_sc_hd__decap_3
Xclkbuf_leaf_32_clk clknet_2_2__leaf_clk VGND VGND VPWR VPWR clknet_leaf_32_clk sky130_fd_sc_hd__clkbuf_8
X_4918_ _2480_ VGND VGND VPWR VPWR _2481_ sky130_fd_sc_hd__buf_4
X_4849_ _2472_ VGND VGND VPWR VPWR _0248_ sky130_fd_sc_hd__inv_2
XFILLER_0_15_262 VGND VGND VPWR VPWR sky130_fd_sc_hd__decap_4
XFILLER_0_62_379 VPWR VGND VPWR VGND sky130_ef_sc_hd__decap_12
XFILLER_0_15_295 VPWR VGND VPWR VGND sky130_ef_sc_hd__decap_12
XFILLER_0_85_405 VPWR VGND VPWR VGND sky130_ef_sc_hd__decap_12
XFILLER_0_85_449 VPWR VGND VPWR VGND sky130_ef_sc_hd__decap_12
Xclkbuf_leaf_23_clk clknet_2_3__leaf_clk VGND VGND VPWR VPWR clknet_leaf_23_clk sky130_fd_sc_hd__clkbuf_8
XFILLER_0_38_387 VGND VGND VPWR VPWR sky130_fd_sc_hd__fill_2
XFILLER_0_80_187 VGND VGND VPWR VPWR sky130_fd_sc_hd__decap_8
XFILLER_0_0_137 VGND VGND VPWR VPWR sky130_fd_sc_hd__decap_3
XTAP_TAPCELL_ROW_69_809 VGND VPWR sky130_fd_sc_hd__tapvpwrvgnd_1
X_3180_ RF0.regs\[4\]\[13\] _0836_ _1252_ RF0.regs\[25\]\[13\] VGND VGND VPWR VPWR
+ _1376_ sky130_fd_sc_hd__a22o_1
XTAP_TAPCELL_ROW_77_886 VGND VPWR sky130_fd_sc_hd__tapvpwrvgnd_1
XFILLER_0_44_65 VPWR VGND VPWR VGND sky130_ef_sc_hd__decap_12
XFILLER_0_29_321 VPWR VGND VPWR VGND sky130_ef_sc_hd__decap_12
XFILLER_0_48_118 VGND VGND VPWR VPWR sky130_fd_sc_hd__decap_8
XFILLER_0_17_505 VGND VGND VPWR VPWR sky130_fd_sc_hd__decap_8
X_2964_ _1187_ VGND VGND VPWR VPWR _0708_ sky130_fd_sc_hd__clkbuf_1
XTAP_TAPCELL_ROW_60_731 VGND VPWR sky130_fd_sc_hd__tapvpwrvgnd_1
XFILLER_0_29_387 VGND VGND VPWR VPWR sky130_fd_sc_hd__decap_4
XFILLER_0_44_324 VGND VGND VPWR VPWR sky130_fd_sc_hd__decap_3
Xclkbuf_leaf_14_clk clknet_2_1__leaf_clk VGND VGND VPWR VPWR clknet_leaf_14_clk sky130_fd_sc_hd__clkbuf_8
X_4703_ _2455_ VGND VGND VPWR VPWR _0119_ sky130_fd_sc_hd__inv_2
X_2895_ net180 VGND VGND VPWR VPWR _1153_ sky130_fd_sc_hd__clkbuf_1
XTAP_TAPCELL_ROW_32_477 VGND VPWR sky130_fd_sc_hd__tapvpwrvgnd_1
XFILLER_0_56_195 VGND VGND VPWR VPWR sky130_fd_sc_hd__fill_1
X_4634_ _2445_ VGND VGND VPWR VPWR _0060_ sky130_fd_sc_hd__inv_2
XFILLER_0_4_421 VPWR VGND VPWR VGND sky130_ef_sc_hd__decap_12
XFILLER_0_8_65 VPWR VGND VPWR VGND sky130_ef_sc_hd__decap_12
X_4565_ _0799_ _1939_ VGND VGND VPWR VPWR net21 sky130_fd_sc_hd__nor2_1
X_3516_ _1475_ _1702_ _1683_ VGND VGND VPWR VPWR _1709_ sky130_fd_sc_hd__o21a_1
XPHY_EDGE_ROW_4_Right_4 VGND VGND VPWR VPWR sky130_fd_sc_hd__decap_3
X_4496_ _2386_ VGND VGND VPWR VPWR _0779_ sky130_fd_sc_hd__inv_2
X_3447_ _1010_ _1633_ _1634_ _1640_ VGND VGND VPWR VPWR _1641_ sky130_fd_sc_hd__a31oi_1
X_3378_ _1570_ _1572_ VGND VGND VPWR VPWR _1573_ sky130_fd_sc_hd__nor2_1
X_5117_ clknet_leaf_37_clk _0493_ _0109_ VGND VGND VPWR VPWR RF0.regs\[12\]\[4\] sky130_fd_sc_hd__dfrtp_1
X_5048_ clknet_leaf_45_clk _0424_ _0040_ VGND VGND VPWR VPWR RF0.regs\[25\]\[31\]
+ sky130_fd_sc_hd__dfrtp_1
XFILLER_0_67_449 VGND VGND VPWR VPWR sky130_fd_sc_hd__decap_8
XTAP_TAPCELL_ROW_23_400 VGND VPWR sky130_fd_sc_hd__tapvpwrvgnd_1
XFILLER_0_50_327 VGND VGND VPWR VPWR sky130_fd_sc_hd__decap_6
XTAP_TAPCELL_ROW_74_856 VGND VPWR sky130_fd_sc_hd__tapvpwrvgnd_1
XFILLER_0_85_279 VGND VGND VPWR VPWR sky130_fd_sc_hd__fill_1
XFILLER_0_66_471 VGND VGND VPWR VPWR sky130_fd_sc_hd__decap_4
XFILLER_0_26_335 VGND VGND VPWR VPWR sky130_fd_sc_hd__decap_6
XFILLER_0_30_23 VGND VGND VPWR VPWR sky130_fd_sc_hd__decap_4
XFILLER_0_38_195 VGND VGND VPWR VPWR sky130_fd_sc_hd__fill_1
X_2680_ RF0.regs\[10\]\[10\] _0810_ _0827_ RF0.regs\[25\]\[10\] _0971_ VGND VGND VPWR
+ VPWR _0972_ sky130_fd_sc_hd__a221o_2
XFILLER_0_81_485 VPWR VGND VPWR VGND sky130_ef_sc_hd__decap_12
XFILLER_0_30_67 VGND VGND VPWR VPWR sky130_fd_sc_hd__decap_8
X_4350_ RF0.regs\[15\]\[2\] _2097_ _2301_ VGND VGND VPWR VPWR _2311_ sky130_fd_sc_hd__mux2_1
X_3301_ _1471_ _1473_ _1485_ _1482_ VGND VGND VPWR VPWR _1497_ sky130_fd_sc_hd__a22o_1
X_4281_ _2274_ VGND VGND VPWR VPWR _0492_ sky130_fd_sc_hd__clkbuf_1
X_3232_ _1276_ _1421_ _1295_ VGND VGND VPWR VPWR _1428_ sky130_fd_sc_hd__a21o_1
Xclkbuf_leaf_3_clk clknet_2_0__leaf_clk VGND VGND VPWR VPWR clknet_leaf_3_clk sky130_fd_sc_hd__clkbuf_8
X_3163_ _1004_ _1358_ VGND VGND VPWR VPWR _1359_ sky130_fd_sc_hd__and2_1
X_3094_ _0825_ _1288_ _1289_ VGND VGND VPWR VPWR _1290_ sky130_fd_sc_hd__a21oi_1
XTAP_TAPCELL_ROW_37_525 VGND VPWR sky130_fd_sc_hd__tapvpwrvgnd_1
XFILLER_0_49_405 VPWR VGND VPWR VGND sky130_ef_sc_hd__decap_12
XFILLER_0_76_213 VGND VGND VPWR VPWR sky130_fd_sc_hd__fill_1
XFILLER_0_49_449 VGND VGND VPWR VPWR sky130_fd_sc_hd__decap_8
XFILLER_0_76_246 VGND VGND VPWR VPWR sky130_fd_sc_hd__decap_6
XFILLER_0_76_279 VPWR VGND VPWR VGND sky130_ef_sc_hd__decap_12
XFILLER_0_29_151 VGND VGND VPWR VPWR sky130_fd_sc_hd__fill_1
XTAP_TAPCELL_ROW_45_591 VGND VPWR sky130_fd_sc_hd__tapvpwrvgnd_1
X_3996_ RF0.regs\[5\]\[10\] _2077_ _2124_ VGND VGND VPWR VPWR _2126_ sky130_fd_sc_hd__mux2_1
XFILLER_0_17_335 VGND VGND VPWR VPWR sky130_fd_sc_hd__fill_1
X_2947_ net121 VGND VGND VPWR VPWR _1179_ sky130_fd_sc_hd__clkbuf_1
X_4617_ _2443_ VGND VGND VPWR VPWR _0045_ sky130_fd_sc_hd__inv_2
XFILLER_0_4_251 VGND VGND VPWR VPWR sky130_fd_sc_hd__fill_1
X_2878_ net1 _0821_ VGND VGND VPWR VPWR _1142_ sky130_fd_sc_hd__or2_1
XFILLER_0_25_390 VGND VGND VPWR VPWR sky130_fd_sc_hd__fill_2
XFILLER_0_40_360 VGND VGND VPWR VPWR sky130_fd_sc_hd__decap_4
X_4548_ _0799_ _1743_ _1744_ VGND VGND VPWR VPWR net8 sky130_fd_sc_hd__nor3_1
X_4479_ _2378_ VGND VGND VPWR VPWR _0398_ sky130_fd_sc_hd__clkbuf_1
XPHY_EDGE_ROW_79_Right_79 VGND VGND VPWR VPWR sky130_fd_sc_hd__decap_3
XTAP_TAPCELL_ROW_71_826 VGND VPWR sky130_fd_sc_hd__tapvpwrvgnd_1
XTAP_TAPCELL_ROW_0_183 VGND VPWR sky130_fd_sc_hd__tapvpwrvgnd_1
XFILLER_0_67_268 VPWR VGND VPWR VGND sky130_ef_sc_hd__decap_12
XFILLER_0_48_460 VGND VGND VPWR VPWR sky130_fd_sc_hd__decap_3
XFILLER_0_75_290 VGND VGND VPWR VPWR sky130_fd_sc_hd__decap_6
XFILLER_0_63_463 VGND VGND VPWR VPWR sky130_fd_sc_hd__fill_1
XFILLER_0_35_198 VGND VGND VPWR VPWR sky130_fd_sc_hd__fill_1
XTAP_TAPCELL_ROW_79_904 VGND VPWR sky130_fd_sc_hd__tapvpwrvgnd_1
XTAP_TAPCELL_ROW_8_261 VGND VPWR sky130_fd_sc_hd__tapvpwrvgnd_1
XTAP_TAPCELL_ROW_87_981 VGND VPWR sky130_fd_sc_hd__tapvpwrvgnd_1
XTAP_TAPCELL_ROW_87_970 VGND VPWR sky130_fd_sc_hd__tapvpwrvgnd_1
XFILLER_0_25_12 VPWR VGND VPWR VGND sky130_ef_sc_hd__decap_12
X_3850_ _1781_ VGND VGND VPWR VPWR _2019_ sky130_fd_sc_hd__inv_2
X_3781_ _1587_ _1947_ VGND VGND VPWR VPWR _1964_ sky130_fd_sc_hd__nand2_1
X_2801_ RF0.regs\[10\]\[28\] _0886_ _0866_ RF0.regs\[4\]\[28\] VGND VGND VPWR VPWR
+ _1093_ sky130_fd_sc_hd__a22o_1
X_2732_ RF0.regs\[4\]\[21\] _0837_ _0844_ RF0.regs\[12\]\[21\] VGND VGND VPWR VPWR
+ _1024_ sky130_fd_sc_hd__a22o_1
XFILLER_0_41_113 VGND VGND VPWR VPWR sky130_fd_sc_hd__fill_1
X_2663_ RF0.regs\[5\]\[0\] _0901_ _0871_ VGND VGND VPWR VPWR _0955_ sky130_fd_sc_hd__and3_1
X_5382_ clknet_leaf_42_clk _0758_ _0374_ VGND VGND VPWR VPWR IM0.addr\[13\] sky130_fd_sc_hd__dfrtp_1
X_2594_ _0885_ VGND VGND VPWR VPWR _0886_ sky130_fd_sc_hd__buf_4
X_4402_ _2338_ VGND VGND VPWR VPWR _0435_ sky130_fd_sc_hd__clkbuf_1
X_4333_ _2302_ VGND VGND VPWR VPWR _0468_ sky130_fd_sc_hd__clkbuf_1
X_4264_ net115 VGND VGND VPWR VPWR _2266_ sky130_fd_sc_hd__clkbuf_1
XFILLER_0_5_55 VGND VGND VPWR VPWR sky130_fd_sc_hd__fill_1
X_3215_ _1408_ _1410_ VGND VGND VPWR VPWR _1411_ sky130_fd_sc_hd__xor2_1
X_4195_ RF0.regs\[10\]\[13\] _2066_ _2222_ VGND VGND VPWR VPWR _2231_ sky130_fd_sc_hd__mux2_1
XFILLER_0_5_99 VGND VGND VPWR VPWR sky130_fd_sc_hd__fill_1
XFILLER_0_66_85 VGND VGND VPWR VPWR sky130_fd_sc_hd__fill_1
X_3146_ _1256_ _1341_ VGND VGND VPWR VPWR _1342_ sky130_fd_sc_hd__nand2_1
X_3077_ RF0.regs\[15\]\[11\] _1270_ _1272_ VGND VGND VPWR VPWR _1273_ sky130_fd_sc_hd__a21o_1
XFILLER_0_10_3 VPWR VGND VPWR VGND sky130_ef_sc_hd__decap_12
XFILLER_0_49_246 VPWR VGND VPWR VGND sky130_ef_sc_hd__decap_12
XFILLER_0_17_121 VGND VGND VPWR VPWR sky130_fd_sc_hd__decap_6
X_3979_ RF0.regs\[5\]\[18\] _2002_ _2113_ VGND VGND VPWR VPWR _2117_ sky130_fd_sc_hd__mux2_1
XFILLER_0_17_176 VPWR VGND VPWR VGND sky130_ef_sc_hd__decap_12
XFILLER_0_32_124 VGND VGND VPWR VPWR sky130_fd_sc_hd__fill_1
XFILLER_0_60_400 VGND VGND VPWR VPWR sky130_fd_sc_hd__fill_1
XFILLER_0_32_157 VGND VGND VPWR VPWR sky130_fd_sc_hd__fill_2
XFILLER_0_60_477 VPWR VGND VPWR VGND sky130_ef_sc_hd__decap_12
XFILLER_0_13_393 VGND VGND VPWR VPWR sky130_fd_sc_hd__fill_1
XTAP_TAPCELL_ROW_5_231 VGND VPWR sky130_fd_sc_hd__tapvpwrvgnd_1
XTAP_TAPCELL_ROW_56_697 VGND VPWR sky130_fd_sc_hd__tapvpwrvgnd_1
XFILLER_0_83_503 VGND VGND VPWR VPWR sky130_fd_sc_hd__fill_1
XTAP_TAPCELL_ROW_11_288 VGND VPWR sky130_fd_sc_hd__tapvpwrvgnd_1
XFILLER_0_11_69 VPWR VGND VPWR VGND sky130_ef_sc_hd__decap_12
XFILLER_0_87_29 VPWR VGND VPWR VGND sky130_ef_sc_hd__decap_12
X_3000_ _1205_ VGND VGND VPWR VPWR _0690_ sky130_fd_sc_hd__clkbuf_1
XFILLER_0_59_500 VGND VGND VPWR VPWR sky130_fd_sc_hd__decap_4
X_4951_ _2484_ VGND VGND VPWR VPWR _0338_ sky130_fd_sc_hd__inv_2
XFILLER_0_52_32 VGND VGND VPWR VPWR sky130_fd_sc_hd__decap_3
X_4882_ _2475_ VGND VGND VPWR VPWR _0278_ sky130_fd_sc_hd__inv_2
X_3902_ RF0.regs\[4\]\[13\] _2066_ _1993_ VGND VGND VPWR VPWR _2067_ sky130_fd_sc_hd__mux2_1
XFILLER_0_19_408 VGND VGND VPWR VPWR sky130_fd_sc_hd__fill_1
X_3833_ _1691_ _2004_ VGND VGND VPWR VPWR _2005_ sky130_fd_sc_hd__xnor2_2
X_3764_ _1561_ _1563_ VGND VGND VPWR VPWR _1950_ sky130_fd_sc_hd__or2_1
X_2715_ _1006_ VGND VGND VPWR VPWR _1007_ sky130_fd_sc_hd__buf_2
X_3695_ RF0.regs\[25\]\[1\] _0807_ _1069_ _0794_ VGND VGND VPWR VPWR _1881_ sky130_fd_sc_hd__a211o_1
XFILLER_0_42_477 VPWR VGND VPWR VGND sky130_ef_sc_hd__decap_12
X_2646_ _0924_ _0926_ _0935_ _0937_ VGND VGND VPWR VPWR _0938_ sky130_fd_sc_hd__a2bb2o_1
XFILLER_0_77_51 VGND VGND VPWR VPWR sky130_fd_sc_hd__decap_4
XFILLER_0_10_363 VGND VGND VPWR VPWR sky130_fd_sc_hd__fill_1
X_5365_ clknet_leaf_45_clk _0741_ _0357_ VGND VGND VPWR VPWR RF0.regs\[0\]\[28\] sky130_fd_sc_hd__dfrtp_1
X_2577_ _0821_ _0819_ IM0.addr\[1\] VGND VGND VPWR VPWR _0869_ sky130_fd_sc_hd__and3b_1
XFILLER_0_58_3 VGND VGND VPWR VPWR sky130_fd_sc_hd__decap_4
X_4316_ _2293_ VGND VGND VPWR VPWR _0476_ sky130_fd_sc_hd__clkbuf_1
X_5296_ clknet_leaf_9_clk _0672_ _0288_ VGND VGND VPWR VPWR RF0.regs\[4\]\[23\] sky130_fd_sc_hd__dfrtp_4
XFILLER_0_10_396 VGND VGND VPWR VPWR sky130_fd_sc_hd__fill_2
X_4247_ _2257_ VGND VGND VPWR VPWR _0509_ sky130_fd_sc_hd__clkbuf_1
X_4178_ _0909_ VGND VGND VPWR VPWR _2222_ sky130_fd_sc_hd__buf_4
X_3129_ RF0.regs\[2\]\[25\] _1239_ _0855_ RF0.regs\[15\]\[25\] VGND VGND VPWR VPWR
+ _1325_ sky130_fd_sc_hd__a22o_1
XTAP_TAPCELL_ROW_81_921 VGND VPWR sky130_fd_sc_hd__tapvpwrvgnd_1
XTAP_TAPCELL_ROW_53_667 VGND VPWR sky130_fd_sc_hd__tapvpwrvgnd_1
XFILLER_0_5_390 VGND VGND VPWR VPWR sky130_fd_sc_hd__fill_2
XFILLER_0_33_466 VGND VGND VPWR VPWR sky130_fd_sc_hd__fill_2
XFILLER_0_20_138 VGND VGND VPWR VPWR sky130_fd_sc_hd__fill_2
XFILLER_0_20_149 VPWR VGND VPWR VGND sky130_ef_sc_hd__decap_12
XFILLER_0_87_149 VGND VGND VPWR VPWR sky130_fd_sc_hd__fill_1
XFILLER_0_68_341 VGND VGND VPWR VPWR sky130_fd_sc_hd__fill_2
XTAP_TAPCELL_ROW_16_336 VGND VPWR sky130_fd_sc_hd__tapvpwrvgnd_1
XFILLER_0_28_249 VGND VGND VPWR VPWR sky130_fd_sc_hd__decap_3
X_3480_ _1673_ VGND VGND VPWR VPWR net15 sky130_fd_sc_hd__dlymetal6s2s_1
X_2500_ _0791_ _0789_ _0790_ _0788_ VGND VGND VPWR VPWR _0792_ sky130_fd_sc_hd__nor4_4
X_5150_ clknet_leaf_34_clk _0526_ _0142_ VGND VGND VPWR VPWR RF0.regs\[10\]\[5\] sky130_fd_sc_hd__dfrtp_1
XPHY_EDGE_ROW_16_Left_104 VGND VGND VPWR VPWR sky130_fd_sc_hd__decap_3
X_5081_ clknet_leaf_41_clk _0457_ _0073_ VGND VGND VPWR VPWR RF0.regs\[15\]\[0\] sky130_fd_sc_hd__dfrtp_1
X_4101_ net159 VGND VGND VPWR VPWR _2183_ sky130_fd_sc_hd__clkbuf_1
X_4032_ _1978_ net274 _2138_ VGND VGND VPWR VPWR _2145_ sky130_fd_sc_hd__mux2_1
XFILLER_0_78_149 VGND VGND VPWR VPWR sky130_fd_sc_hd__fill_2
X_4934_ _2482_ VGND VGND VPWR VPWR _0323_ sky130_fd_sc_hd__inv_2
XFILLER_0_6_110 VPWR VGND VPWR VGND sky130_ef_sc_hd__decap_12
XPHY_EDGE_ROW_25_Left_113 VGND VGND VPWR VPWR sky130_fd_sc_hd__decap_3
X_4865_ _2474_ VGND VGND VPWR VPWR _0262_ sky130_fd_sc_hd__inv_2
XTAP_TAPCELL_ROW_50_637 VGND VPWR sky130_fd_sc_hd__tapvpwrvgnd_1
X_3816_ _1674_ _1991_ VGND VGND VPWR VPWR _1992_ sky130_fd_sc_hd__xnor2_2
X_4796_ _2462_ VGND VGND VPWR VPWR _2467_ sky130_fd_sc_hd__buf_4
X_3747_ _1675_ _1928_ _1930_ _1652_ _1932_ VGND VGND VPWR VPWR _1933_ sky130_fd_sc_hd__o221a_4
XFILLER_0_15_433 VGND VGND VPWR VPWR sky130_fd_sc_hd__fill_1
XFILLER_0_6_165 VGND VGND VPWR VPWR sky130_fd_sc_hd__decap_4
XFILLER_0_27_293 VGND VGND VPWR VPWR sky130_fd_sc_hd__decap_8
X_3678_ RF0.regs\[25\]\[3\] _0807_ _0989_ _0794_ VGND VGND VPWR VPWR _1864_ sky130_fd_sc_hd__a211o_1
X_5417_ clknet_leaf_30_clk _0007_ VGND VGND VPWR VPWR disp.digit_select\[0\] sky130_fd_sc_hd__dfxtp_1
X_2629_ _0912_ _0914_ _0917_ _0920_ VGND VGND VPWR VPWR _0921_ sky130_fd_sc_hd__a2bb2o_1
XPHY_EDGE_ROW_34_Left_122 VGND VGND VPWR VPWR sky130_fd_sc_hd__decap_3
X_5348_ clknet_leaf_23_clk _0724_ _0340_ VGND VGND VPWR VPWR RF0.regs\[0\]\[11\] sky130_fd_sc_hd__dfrtp_1
XFILLER_0_10_193 VGND VGND VPWR VPWR sky130_fd_sc_hd__decap_3
X_5279_ clknet_leaf_28_clk _0655_ _0271_ VGND VGND VPWR VPWR RF0.regs\[4\]\[6\] sky130_fd_sc_hd__dfrtp_1
XTAP_TAPCELL_ROW_58_715 VGND VPWR sky130_fd_sc_hd__tapvpwrvgnd_1
XFILLER_0_69_105 VGND VGND VPWR VPWR sky130_fd_sc_hd__decap_4
Xmax_cap47 _1242_ VGND VGND VPWR VPWR net47 sky130_fd_sc_hd__clkbuf_2
XTAP_TAPCELL_ROW_66_781 VGND VPWR sky130_fd_sc_hd__tapvpwrvgnd_1
XPHY_EDGE_ROW_43_Left_131 VGND VGND VPWR VPWR sky130_fd_sc_hd__decap_3
XFILLER_0_77_193 VGND VGND VPWR VPWR sky130_fd_sc_hd__fill_2
XTAP_TAPCELL_ROW_13_306 VGND VPWR sky130_fd_sc_hd__tapvpwrvgnd_1
XFILLER_0_80_303 VGND VGND VPWR VPWR sky130_fd_sc_hd__decap_4
XFILLER_0_80_347 VGND VGND VPWR VPWR sky130_fd_sc_hd__decap_8
XFILLER_0_21_436 VGND VGND VPWR VPWR sky130_fd_sc_hd__fill_2
XPHY_EDGE_ROW_52_Left_140 VGND VGND VPWR VPWR sky130_fd_sc_hd__decap_3
XTAP_TAPCELL_ROW_29_450 VGND VPWR sky130_fd_sc_hd__tapvpwrvgnd_1
X_2980_ _1195_ VGND VGND VPWR VPWR _0700_ sky130_fd_sc_hd__clkbuf_1
XFILLER_0_56_344 VPWR VGND VPWR VGND sky130_ef_sc_hd__decap_12
XFILLER_0_16_219 VGND VGND VPWR VPWR sky130_fd_sc_hd__decap_8
X_4650_ _2448_ VGND VGND VPWR VPWR _0073_ sky130_fd_sc_hd__inv_2
X_3601_ _0972_ _1444_ _1791_ VGND VGND VPWR VPWR _1792_ sky130_fd_sc_hd__a21bo_1
X_4581_ _2438_ VGND VGND VPWR VPWR _0014_ sky130_fd_sc_hd__inv_2
X_3532_ RF0.regs\[4\]\[16\] _1240_ _1232_ RF0.regs\[6\]\[16\] VGND VGND VPWR VPWR
+ _1724_ sky130_fd_sc_hd__a22o_1
XFILLER_0_12_414 VGND VGND VPWR VPWR sky130_fd_sc_hd__decap_6
XFILLER_0_24_274 VGND VGND VPWR VPWR sky130_fd_sc_hd__decap_6
X_3463_ RF0.regs\[7\]\[20\] _1244_ _1656_ VGND VGND VPWR VPWR _1657_ sky130_fd_sc_hd__a21o_1
XFILLER_0_12_447 VGND VGND VPWR VPWR sky130_fd_sc_hd__fill_1
X_5202_ clknet_leaf_9_clk _0578_ _0194_ VGND VGND VPWR VPWR RF0.regs\[7\]\[25\] sky130_fd_sc_hd__dfrtp_1
X_3394_ _1544_ _1352_ VGND VGND VPWR VPWR _1588_ sky130_fd_sc_hd__nor2b_1
X_5133_ clknet_leaf_14_clk _0509_ _0125_ VGND VGND VPWR VPWR RF0.regs\[12\]\[20\]
+ sky130_fd_sc_hd__dfrtp_1
X_5064_ clknet_leaf_18_clk _0440_ _0056_ VGND VGND VPWR VPWR RF0.regs\[20\]\[15\]
+ sky130_fd_sc_hd__dfrtp_1
XFILLER_0_74_41 VPWR VGND VPWR VGND sky130_ef_sc_hd__decap_12
XFILLER_0_74_85 VPWR VGND VPWR VGND sky130_ef_sc_hd__decap_12
X_4015_ _2135_ VGND VGND VPWR VPWR _0618_ sky130_fd_sc_hd__clkbuf_1
XFILLER_0_74_141 VGND VGND VPWR VPWR sky130_fd_sc_hd__fill_1
X_4917_ reset VGND VGND VPWR VPWR _2480_ sky130_fd_sc_hd__clkbuf_4
XFILLER_0_47_333 VGND VGND VPWR VPWR sky130_fd_sc_hd__decap_3
XFILLER_0_47_344 VGND VGND VPWR VPWR sky130_fd_sc_hd__decap_4
X_4848_ _2472_ VGND VGND VPWR VPWR _0247_ sky130_fd_sc_hd__inv_2
XFILLER_0_47_388 VGND VGND VPWR VPWR sky130_fd_sc_hd__fill_1
XFILLER_0_62_303 VGND VGND VPWR VPWR sky130_fd_sc_hd__decap_4
X_4779_ _2465_ VGND VGND VPWR VPWR _0185_ sky130_fd_sc_hd__inv_2
XFILLER_0_15_241 VGND VGND VPWR VPWR sky130_fd_sc_hd__fill_1
XFILLER_0_85_417 VPWR VGND VPWR VGND sky130_ef_sc_hd__decap_12
XTAP_TAPCELL_ROW_26_420 VGND VPWR sky130_fd_sc_hd__tapvpwrvgnd_1
XFILLER_0_65_141 VGND VGND VPWR VPWR sky130_fd_sc_hd__fill_1
XFILLER_0_65_152 VGND VGND VPWR VPWR sky130_fd_sc_hd__decap_4
XPHY_EDGE_ROW_5_Left_93 VGND VGND VPWR VPWR sky130_fd_sc_hd__decap_3
XFILLER_0_76_406 VGND VGND VPWR VPWR sky130_fd_sc_hd__fill_2
XFILLER_0_29_333 VGND VGND VPWR VPWR sky130_fd_sc_hd__decap_3
X_2963_ net204 VGND VGND VPWR VPWR _1187_ sky130_fd_sc_hd__clkbuf_1
XFILLER_0_56_130 VGND VGND VPWR VPWR sky130_fd_sc_hd__decap_6
XFILLER_0_56_141 VGND VGND VPWR VPWR sky130_fd_sc_hd__fill_2
XTAP_TAPCELL_ROW_60_732 VGND VPWR sky130_fd_sc_hd__tapvpwrvgnd_1
X_4702_ _2455_ VGND VGND VPWR VPWR _0118_ sky130_fd_sc_hd__inv_2
X_2894_ _1152_ VGND VGND VPWR VPWR _0743_ sky130_fd_sc_hd__clkbuf_1
XTAP_TAPCELL_ROW_32_478 VGND VPWR sky130_fd_sc_hd__tapvpwrvgnd_1
X_4633_ _2445_ VGND VGND VPWR VPWR _0059_ sky130_fd_sc_hd__inv_2
XFILLER_0_4_433 VPWR VGND VPWR VGND sky130_ef_sc_hd__decap_12
XFILLER_0_71_177 VGND VGND VPWR VPWR sky130_fd_sc_hd__fill_1
XFILLER_0_12_200 VGND VGND VPWR VPWR sky130_fd_sc_hd__fill_2
X_4564_ _2431_ VGND VGND VPWR VPWR net20 sky130_fd_sc_hd__buf_1
X_3515_ _1697_ _1707_ VGND VGND VPWR VPWR _1708_ sky130_fd_sc_hd__xnor2_1
XFILLER_0_12_233 VGND VGND VPWR VPWR sky130_fd_sc_hd__fill_2
XFILLER_0_8_77 VGND VGND VPWR VPWR sky130_fd_sc_hd__decap_6
XFILLER_0_4_477 VPWR VGND VPWR VGND sky130_ef_sc_hd__decap_12
X_4495_ _0007_ disp.digit_select\[1\] VGND VGND VPWR VPWR _2386_ sky130_fd_sc_hd__and2_2
X_3446_ _1636_ _1637_ _1639_ _1218_ RF0.regs\[0\]\[23\] VGND VGND VPWR VPWR _1640_
+ sky130_fd_sc_hd__o32a_1
XFILLER_0_85_51 VGND VGND VPWR VPWR sky130_fd_sc_hd__decap_4
X_3377_ _1148_ _1548_ _1571_ VGND VGND VPWR VPWR _1572_ sky130_fd_sc_hd__and3_1
XFILLER_0_40_3 VGND VGND VPWR VPWR sky130_fd_sc_hd__decap_6
X_5116_ clknet_leaf_38_clk _0492_ _0108_ VGND VGND VPWR VPWR RF0.regs\[12\]\[3\] sky130_fd_sc_hd__dfrtp_1
X_5047_ clknet_leaf_2_clk _0423_ _0039_ VGND VGND VPWR VPWR RF0.regs\[25\]\[30\] sky130_fd_sc_hd__dfrtp_1
XFILLER_0_47_174 VGND VGND VPWR VPWR sky130_fd_sc_hd__fill_1
XFILLER_0_35_325 VGND VGND VPWR VPWR sky130_fd_sc_hd__fill_1
XTAP_TAPCELL_ROW_74_857 VGND VPWR sky130_fd_sc_hd__tapvpwrvgnd_1
XFILLER_0_26_303 VGND VGND VPWR VPWR sky130_fd_sc_hd__decap_4
XFILLER_0_38_141 VPWR VGND VPWR VGND sky130_ef_sc_hd__decap_12
XFILLER_0_66_450 VGND VGND VPWR VPWR sky130_fd_sc_hd__fill_1
XFILLER_0_26_358 VGND VGND VPWR VPWR sky130_fd_sc_hd__decap_3
XFILLER_0_81_497 VGND VGND VPWR VPWR sky130_fd_sc_hd__decap_6
XFILLER_0_34_380 VPWR VGND VPWR VGND sky130_ef_sc_hd__decap_12
XFILLER_0_1_447 VGND VGND VPWR VPWR sky130_fd_sc_hd__fill_1
X_3300_ _1480_ _1492_ _1495_ VGND VGND VPWR VPWR _1496_ sky130_fd_sc_hd__and3_1
X_4280_ RF0.regs\[12\]\[3\] VGND VGND VPWR VPWR _2274_ sky130_fd_sc_hd__clkbuf_1
X_3231_ _1386_ _1420_ _1426_ VGND VGND VPWR VPWR _1427_ sky130_fd_sc_hd__a21o_2
XFILLER_0_39_99 VGND VGND VPWR VPWR sky130_fd_sc_hd__fill_2
X_3162_ _1357_ _1323_ _1324_ _0841_ VGND VGND VPWR VPWR _1358_ sky130_fd_sc_hd__o211ai_1
X_3093_ _0801_ _0849_ _1262_ VGND VGND VPWR VPWR _1289_ sky130_fd_sc_hd__and3b_1
XTAP_TAPCELL_ROW_37_526 VGND VPWR sky130_fd_sc_hd__tapvpwrvgnd_1
XFILLER_0_9_503 VGND VGND VPWR VPWR sky130_fd_sc_hd__fill_1
XTAP_TAPCELL_ROW_45_592 VGND VPWR sky130_fd_sc_hd__tapvpwrvgnd_1
X_3995_ _2125_ VGND VGND VPWR VPWR _0628_ sky130_fd_sc_hd__clkbuf_1
X_2946_ _1178_ VGND VGND VPWR VPWR _0717_ sky130_fd_sc_hd__clkbuf_1
XFILLER_0_44_100 VGND VGND VPWR VPWR sky130_fd_sc_hd__decap_8
XFILLER_0_72_475 VGND VGND VPWR VPWR sky130_fd_sc_hd__fill_1
X_2877_ _1139_ _1140_ _1102_ _0805_ VGND VGND VPWR VPWR _1141_ sky130_fd_sc_hd__o211a_1
XFILLER_0_32_306 VGND VGND VPWR VPWR sky130_fd_sc_hd__fill_2
X_4616_ _2443_ VGND VGND VPWR VPWR _0044_ sky130_fd_sc_hd__inv_2
X_4547_ _1750_ VGND VGND VPWR VPWR net7 sky130_fd_sc_hd__inv_2
X_4478_ RF0.regs\[25\]\[5\] _2090_ _2371_ VGND VGND VPWR VPWR _2378_ sky130_fd_sc_hd__mux2_1
X_3429_ RF0.regs\[4\]\[24\] _1241_ _1245_ RF0.regs\[7\]\[24\] _1622_ VGND VGND VPWR
+ VPWR _1623_ sky130_fd_sc_hd__a221o_1
XFILLER_0_67_225 VGND VGND VPWR VPWR sky130_fd_sc_hd__decap_8
XTAP_TAPCELL_ROW_71_827 VGND VPWR sky130_fd_sc_hd__tapvpwrvgnd_1
XTAP_TAPCELL_ROW_0_184 VGND VPWR sky130_fd_sc_hd__tapvpwrvgnd_1
XFILLER_0_48_450 VGND VGND VPWR VPWR sky130_fd_sc_hd__decap_3
XFILLER_0_35_122 VGND VGND VPWR VPWR sky130_fd_sc_hd__fill_2
XFILLER_0_23_317 VGND VGND VPWR VPWR sky130_fd_sc_hd__decap_8
XFILLER_0_50_169 VGND VGND VPWR VPWR sky130_fd_sc_hd__decap_4
XTAP_TAPCELL_ROW_8_262 VGND VPWR sky130_fd_sc_hd__tapvpwrvgnd_1
XTAP_TAPCELL_ROW_87_982 VGND VPWR sky130_fd_sc_hd__tapvpwrvgnd_1
XTAP_TAPCELL_ROW_87_971 VGND VPWR sky130_fd_sc_hd__tapvpwrvgnd_1
XFILLER_0_25_24 VPWR VGND VPWR VGND sky130_ef_sc_hd__decap_12
XFILLER_0_86_501 VPWR VGND VPWR VGND sky130_ef_sc_hd__decap_12
XFILLER_0_26_100 VGND VGND VPWR VPWR sky130_fd_sc_hd__decap_3
X_3780_ _1963_ VGND VGND VPWR VPWR _0678_ sky130_fd_sc_hd__clkbuf_1
X_2800_ RF0.regs\[5\]\[28\] _0875_ _0855_ RF0.regs\[15\]\[28\] VGND VGND VPWR VPWR
+ _1092_ sky130_fd_sc_hd__a22o_1
X_2731_ RF0.regs\[10\]\[21\] _0909_ _0856_ RF0.regs\[15\]\[21\] _1022_ VGND VGND VPWR
+ VPWR _1023_ sky130_fd_sc_hd__a221o_1
X_2662_ RF0.regs\[10\]\[0\] _0882_ VGND VGND VPWR VPWR _0954_ sky130_fd_sc_hd__and2_1
X_4401_ net221 _2077_ _2336_ VGND VGND VPWR VPWR _2338_ sky130_fd_sc_hd__mux2_1
XFILLER_0_10_512 VGND VGND VPWR VPWR sky130_fd_sc_hd__decap_4
X_5381_ clknet_leaf_42_clk _0757_ _0373_ VGND VGND VPWR VPWR IM0.addr\[12\] sky130_fd_sc_hd__dfrtp_1
X_2593_ _0884_ VGND VGND VPWR VPWR _0885_ sky130_fd_sc_hd__buf_4
XFILLER_0_41_169 VGND VGND VPWR VPWR sky130_fd_sc_hd__decap_4
XFILLER_0_1_266 VPWR VGND VPWR VGND sky130_ef_sc_hd__decap_12
X_4332_ RF0.regs\[15\]\[11\] _2072_ _2301_ VGND VGND VPWR VPWR _2302_ sky130_fd_sc_hd__mux2_1
X_4263_ _2265_ VGND VGND VPWR VPWR _0501_ sky130_fd_sc_hd__clkbuf_1
X_3214_ _1290_ _1409_ VGND VGND VPWR VPWR _1410_ sky130_fd_sc_hd__xor2_1
XFILLER_0_66_53 VGND VGND VPWR VPWR sky130_fd_sc_hd__decap_3
X_4194_ _2230_ VGND VGND VPWR VPWR _0535_ sky130_fd_sc_hd__clkbuf_1
X_3145_ _1258_ _1338_ _1339_ _1340_ VGND VGND VPWR VPWR _1341_ sky130_fd_sc_hd__a31oi_2
XFILLER_0_82_41 VPWR VGND VPWR VGND sky130_ef_sc_hd__decap_12
X_3076_ RF0.regs\[2\]\[11\] _1237_ _0974_ _1271_ VGND VGND VPWR VPWR _1272_ sky130_fd_sc_hd__a211o_1
XFILLER_0_77_501 VGND VGND VPWR VPWR sky130_fd_sc_hd__decap_3
XFILLER_0_82_85 VGND VGND VPWR VPWR sky130_fd_sc_hd__decap_4
XFILLER_0_49_258 VGND VGND VPWR VPWR sky130_fd_sc_hd__decap_8
XFILLER_0_15_90 VGND VGND VPWR VPWR sky130_fd_sc_hd__decap_4
XFILLER_0_9_322 VGND VGND VPWR VPWR sky130_fd_sc_hd__fill_1
X_3978_ _2116_ VGND VGND VPWR VPWR _0636_ sky130_fd_sc_hd__clkbuf_1
XFILLER_0_17_100 VPWR VGND VPWR VGND sky130_ef_sc_hd__decap_12
XFILLER_0_9_399 VGND VGND VPWR VPWR sky130_fd_sc_hd__decap_4
X_2929_ net105 VGND VGND VPWR VPWR _1170_ sky130_fd_sc_hd__clkbuf_1
XFILLER_0_17_188 VGND VGND VPWR VPWR sky130_fd_sc_hd__decap_4
XFILLER_0_17_166 VGND VGND VPWR VPWR sky130_fd_sc_hd__fill_2
XFILLER_0_60_434 VPWR VGND VPWR VGND sky130_ef_sc_hd__decap_12
XFILLER_0_20_309 VGND VGND VPWR VPWR sky130_fd_sc_hd__fill_2
XFILLER_0_60_489 VPWR VGND VPWR VGND sky130_ef_sc_hd__decap_12
XTAP_TAPCELL_ROW_5_232 VGND VPWR sky130_fd_sc_hd__tapvpwrvgnd_1
XFILLER_0_87_309 VPWR VGND VPWR VGND sky130_ef_sc_hd__decap_12
XTAP_TAPCELL_ROW_84_941 VGND VPWR sky130_fd_sc_hd__tapvpwrvgnd_1
XFILLER_0_11_15 VPWR VGND VPWR VGND sky130_ef_sc_hd__decap_12
XTAP_TAPCELL_ROW_11_289 VGND VPWR sky130_fd_sc_hd__tapvpwrvgnd_1
XFILLER_0_23_169 VPWR VGND VPWR VGND sky130_ef_sc_hd__decap_12
XFILLER_0_36_56 VGND VGND VPWR VPWR sky130_fd_sc_hd__decap_8
XFILLER_0_36_78 VGND VGND VPWR VPWR sky130_fd_sc_hd__decap_6
XTAP_TAPCELL_ROW_47_610 VGND VPWR sky130_fd_sc_hd__tapvpwrvgnd_1
XTAP_TAPCELL_ROW_19_356 VGND VPWR sky130_fd_sc_hd__tapvpwrvgnd_1
X_4950_ _2484_ VGND VGND VPWR VPWR _0337_ sky130_fd_sc_hd__inv_2
XFILLER_0_52_11 VGND VGND VPWR VPWR sky130_fd_sc_hd__decap_3
XFILLER_0_52_55 VGND VGND VPWR VPWR sky130_fd_sc_hd__fill_2
X_4881_ _2475_ VGND VGND VPWR VPWR _0277_ sky130_fd_sc_hd__inv_2
X_3901_ _2018_ _2065_ VGND VGND VPWR VPWR _2066_ sky130_fd_sc_hd__xnor2_4
X_3832_ _1732_ _1747_ _1923_ _1731_ VGND VGND VPWR VPWR _2004_ sky130_fd_sc_hd__o31a_1
XFILLER_0_27_486 VGND VGND VPWR VPWR sky130_fd_sc_hd__fill_1
X_3763_ _1587_ _1947_ _1948_ _1586_ VGND VGND VPWR VPWR _1949_ sky130_fd_sc_hd__o211a_1
XFILLER_0_54_250 VGND VGND VPWR VPWR sky130_fd_sc_hd__fill_2
X_3694_ RF0.regs\[20\]\[1\] _1220_ _1226_ RF0.regs\[15\]\[1\] _1879_ VGND VGND VPWR
+ VPWR _1880_ sky130_fd_sc_hd__a221o_1
X_2714_ _0794_ _0796_ VGND VGND VPWR VPWR _1006_ sky130_fd_sc_hd__nor2_1
XFILLER_0_42_456 VGND VGND VPWR VPWR sky130_fd_sc_hd__fill_1
XFILLER_0_42_489 VGND VGND VPWR VPWR sky130_fd_sc_hd__decap_4
X_2645_ RF0.regs\[10\]\[12\] _0810_ _0828_ RF0.regs\[25\]\[12\] _0936_ VGND VGND VPWR
+ VPWR _0937_ sky130_fd_sc_hd__a221o_2
X_5364_ clknet_leaf_7_clk _0740_ _0356_ VGND VGND VPWR VPWR RF0.regs\[0\]\[27\] sky130_fd_sc_hd__dfrtp_1
X_4315_ RF0.regs\[15\]\[19\] _2000_ _2290_ VGND VGND VPWR VPWR _2293_ sky130_fd_sc_hd__mux2_1
XFILLER_0_10_353 VGND VGND VPWR VPWR sky130_fd_sc_hd__fill_1
X_2576_ _0867_ VGND VGND VPWR VPWR _0868_ sky130_fd_sc_hd__buf_4
X_5295_ clknet_leaf_10_clk _0671_ _0287_ VGND VGND VPWR VPWR RF0.regs\[4\]\[22\] sky130_fd_sc_hd__dfrtp_2
X_4246_ net250 VGND VGND VPWR VPWR _2257_ sky130_fd_sc_hd__clkbuf_1
X_4177_ _2221_ VGND VGND VPWR VPWR _0543_ sky130_fd_sc_hd__clkbuf_1
X_3128_ net58 _1322_ _1323_ VGND VGND VPWR VPWR _1324_ sky130_fd_sc_hd__or3b_4
XTAP_TAPCELL_ROW_81_922 VGND VPWR sky130_fd_sc_hd__tapvpwrvgnd_1
X_3059_ RF0.regs\[4\]\[30\] _0839_ _0816_ RF0.regs\[10\]\[30\] VGND VGND VPWR VPWR
+ _1255_ sky130_fd_sc_hd__a22o_1
XTAP_TAPCELL_ROW_53_668 VGND VPWR sky130_fd_sc_hd__tapvpwrvgnd_1
XFILLER_0_33_445 VGND VGND VPWR VPWR sky130_fd_sc_hd__decap_3
XFILLER_0_60_253 VGND VGND VPWR VPWR sky130_fd_sc_hd__fill_1
XTAP_TAPCELL_ROW_16_337 VGND VPWR sky130_fd_sc_hd__tapvpwrvgnd_1
XFILLER_0_56_504 VGND VGND VPWR VPWR sky130_fd_sc_hd__decap_8
XFILLER_0_22_47 VGND VGND VPWR VPWR sky130_fd_sc_hd__fill_2
XFILLER_0_36_250 VGND VGND VPWR VPWR sky130_fd_sc_hd__fill_2
XFILLER_0_36_294 VGND VGND VPWR VPWR sky130_fd_sc_hd__fill_1
XFILLER_0_51_297 VPWR VGND VPWR VGND sky130_ef_sc_hd__decap_12
X_5080_ clknet_leaf_45_clk _0456_ _0072_ VGND VGND VPWR VPWR RF0.regs\[20\]\[31\]
+ sky130_fd_sc_hd__dfrtp_1
X_4100_ _2182_ VGND VGND VPWR VPWR _0581_ sky130_fd_sc_hd__clkbuf_1
X_4031_ _2144_ VGND VGND VPWR VPWR _0611_ sky130_fd_sc_hd__clkbuf_1
X_4933_ _2482_ VGND VGND VPWR VPWR _0322_ sky130_fd_sc_hd__inv_2
X_4864_ _2474_ VGND VGND VPWR VPWR _0261_ sky130_fd_sc_hd__inv_2
XTAP_TAPCELL_ROW_50_638 VGND VPWR sky130_fd_sc_hd__tapvpwrvgnd_1
X_3815_ _1662_ _1990_ VGND VGND VPWR VPWR _1991_ sky130_fd_sc_hd__or2_1
XFILLER_0_6_122 VPWR VGND VPWR VGND sky130_ef_sc_hd__decap_12
X_4795_ _2466_ VGND VGND VPWR VPWR _0200_ sky130_fd_sc_hd__inv_2
X_3746_ _1641_ _1931_ _1651_ VGND VGND VPWR VPWR _1932_ sky130_fd_sc_hd__o21a_1
XFILLER_0_42_253 VGND VGND VPWR VPWR sky130_fd_sc_hd__decap_3
XFILLER_0_70_3 VPWR VGND VPWR VGND sky130_ef_sc_hd__decap_12
X_3677_ RF0.regs\[6\]\[3\] _1230_ _1226_ RF0.regs\[15\]\[3\] _1862_ VGND VGND VPWR
+ VPWR _1863_ sky130_fd_sc_hd__a221o_1
X_5416_ clknet_leaf_23_clk net8 VGND VGND VPWR VPWR disp.digits\[15\] sky130_fd_sc_hd__dfxtp_1
X_2628_ _0919_ VGND VGND VPWR VPWR _0920_ sky130_fd_sc_hd__inv_2
X_2559_ _0802_ _0850_ _0781_ VGND VGND VPWR VPWR _0851_ sky130_fd_sc_hd__o21ba_1
X_5347_ clknet_leaf_23_clk _0723_ _0339_ VGND VGND VPWR VPWR RF0.regs\[0\]\[10\] sky130_fd_sc_hd__dfrtp_1
X_5278_ clknet_leaf_35_clk _0654_ _0270_ VGND VGND VPWR VPWR RF0.regs\[4\]\[5\] sky130_fd_sc_hd__dfrtp_2
X_4229_ _2248_ VGND VGND VPWR VPWR _0518_ sky130_fd_sc_hd__clkbuf_1
XTAP_TAPCELL_ROW_66_782 VGND VPWR sky130_fd_sc_hd__tapvpwrvgnd_1
XFILLER_0_84_109 VPWR VGND VPWR VGND sky130_ef_sc_hd__decap_12
XTAP_TAPCELL_ROW_13_307 VGND VPWR sky130_fd_sc_hd__tapvpwrvgnd_1
XFILLER_0_0_309 VGND VGND VPWR VPWR sky130_fd_sc_hd__fill_2
XFILLER_0_33_286 VGND VGND VPWR VPWR sky130_fd_sc_hd__fill_1
XTAP_TAPCELL_ROW_29_451 VGND VPWR sky130_fd_sc_hd__tapvpwrvgnd_1
XFILLER_0_75_109 VGND VGND VPWR VPWR sky130_fd_sc_hd__decap_3
XFILLER_0_83_131 VGND VGND VPWR VPWR sky130_fd_sc_hd__decap_4
XFILLER_0_56_356 VGND VGND VPWR VPWR sky130_fd_sc_hd__decap_8
XFILLER_0_71_337 VPWR VGND VPWR VGND sky130_ef_sc_hd__decap_12
X_4580_ _2438_ VGND VGND VPWR VPWR _0013_ sky130_fd_sc_hd__inv_2
X_3600_ net62 _1790_ _1455_ _1445_ VGND VGND VPWR VPWR _1791_ sky130_fd_sc_hd__o211ai_2
X_3531_ RF0.regs\[10\]\[16\] _0886_ _0814_ RF0.regs\[25\]\[16\] _1246_ VGND VGND VPWR
+ VPWR _1723_ sky130_fd_sc_hd__a221o_1
X_3462_ RF0.regs\[4\]\[20\] _1240_ _1232_ RF0.regs\[6\]\[20\] _1655_ VGND VGND VPWR
+ VPWR _1656_ sky130_fd_sc_hd__a221o_1
X_3393_ _1584_ _1586_ VGND VGND VPWR VPWR _1587_ sky130_fd_sc_hd__nand2_1
X_5201_ clknet_leaf_7_clk _0577_ _0193_ VGND VGND VPWR VPWR RF0.regs\[7\]\[24\] sky130_fd_sc_hd__dfrtp_1
XFILLER_0_58_43 VPWR VGND VPWR VGND sky130_ef_sc_hd__decap_12
X_5132_ clknet_leaf_14_clk _0508_ _0124_ VGND VGND VPWR VPWR RF0.regs\[12\]\[19\]
+ sky130_fd_sc_hd__dfrtp_1
X_5063_ clknet_leaf_22_clk _0439_ _0055_ VGND VGND VPWR VPWR RF0.regs\[20\]\[14\]
+ sky130_fd_sc_hd__dfrtp_1
X_4014_ RF0.regs\[5\]\[1\] _2099_ _0868_ VGND VGND VPWR VPWR _2135_ sky130_fd_sc_hd__mux2_1
XFILLER_0_74_97 VPWR VGND VPWR VGND sky130_ef_sc_hd__decap_12
XTAP_TAPCELL_ROW_63_752 VGND VPWR sky130_fd_sc_hd__tapvpwrvgnd_1
X_4916_ _2479_ VGND VGND VPWR VPWR _0308_ sky130_fd_sc_hd__inv_2
X_4847_ _2472_ VGND VGND VPWR VPWR _0246_ sky130_fd_sc_hd__inv_2
X_4778_ _2465_ VGND VGND VPWR VPWR _0184_ sky130_fd_sc_hd__inv_2
X_3729_ net61 _1792_ _1009_ VGND VGND VPWR VPWR _1915_ sky130_fd_sc_hd__o21ai_1
XTAP_TAPCELL_ROW_26_421 VGND VPWR sky130_fd_sc_hd__tapvpwrvgnd_1
XFILLER_0_85_429 VPWR VGND VPWR VGND sky130_ef_sc_hd__decap_12
XFILLER_0_53_304 VPWR VGND VPWR VGND sky130_ef_sc_hd__decap_12
XFILLER_0_21_212 VPWR VGND VPWR VGND sky130_ef_sc_hd__decap_12
XFILLER_0_44_23 VGND VGND VPWR VPWR sky130_fd_sc_hd__decap_4
XFILLER_0_76_429 VGND VGND VPWR VPWR sky130_fd_sc_hd__fill_2
XFILLER_0_69_470 VGND VGND VPWR VPWR sky130_fd_sc_hd__fill_1
X_2962_ _1186_ VGND VGND VPWR VPWR _0709_ sky130_fd_sc_hd__clkbuf_1
X_4701_ _2455_ VGND VGND VPWR VPWR _0117_ sky130_fd_sc_hd__inv_2
XTAP_TAPCELL_ROW_60_733 VGND VPWR sky130_fd_sc_hd__tapvpwrvgnd_1
XFILLER_0_71_101 VGND VGND VPWR VPWR sky130_fd_sc_hd__decap_8
X_2893_ net86 VGND VGND VPWR VPWR _1152_ sky130_fd_sc_hd__clkbuf_1
XTAP_TAPCELL_ROW_32_479 VGND VPWR sky130_fd_sc_hd__tapvpwrvgnd_1
X_4632_ _2442_ VGND VGND VPWR VPWR _2445_ sky130_fd_sc_hd__clkbuf_8
XFILLER_0_56_197 VPWR VGND VPWR VGND sky130_ef_sc_hd__decap_12
XFILLER_0_60_77 VGND VGND VPWR VPWR sky130_fd_sc_hd__decap_6
XFILLER_0_4_401 VPWR VGND VPWR VGND sky130_ef_sc_hd__decap_12
XFILLER_0_4_445 VPWR VGND VPWR VGND sky130_ef_sc_hd__decap_12
X_4563_ _1149_ _1603_ _1604_ VGND VGND VPWR VPWR _2431_ sky130_fd_sc_hd__and3_1
XFILLER_0_4_489 VPWR VGND VPWR VGND sky130_ef_sc_hd__decap_12
X_4494_ _2385_ VGND VGND VPWR VPWR _0778_ sky130_fd_sc_hd__inv_2
X_3514_ _0798_ _1705_ _1706_ VGND VGND VPWR VPWR _1707_ sky130_fd_sc_hd__or3b_2
X_3445_ RF0.regs\[5\]\[23\] _0867_ _1224_ RF0.regs\[20\]\[23\] _1638_ VGND VGND VPWR
+ VPWR _1639_ sky130_fd_sc_hd__a221o_1
X_3376_ _1546_ _1547_ _1347_ net57 VGND VGND VPWR VPWR _1571_ sky130_fd_sc_hd__o211ai_1
XPHY_EDGE_ROW_71_Left_159 VGND VGND VPWR VPWR sky130_fd_sc_hd__decap_3
X_5115_ clknet_leaf_36_clk _0491_ _0107_ VGND VGND VPWR VPWR RF0.regs\[12\]\[2\] sky130_fd_sc_hd__dfrtp_1
XTAP_TAPCELL_ROW_68_800 VGND VPWR sky130_fd_sc_hd__tapvpwrvgnd_1
XFILLER_0_33_3 VPWR VGND VPWR VGND sky130_ef_sc_hd__decap_12
X_5046_ clknet_leaf_1_clk _0422_ _0038_ VGND VGND VPWR VPWR RF0.regs\[25\]\[29\] sky130_fd_sc_hd__dfrtp_1
XFILLER_0_79_223 VGND VGND VPWR VPWR sky130_fd_sc_hd__fill_1
XFILLER_0_75_473 VPWR VGND VPWR VGND sky130_ef_sc_hd__decap_12
XFILLER_0_75_462 VGND VGND VPWR VPWR sky130_fd_sc_hd__decap_3
XFILLER_0_47_164 VGND VGND VPWR VPWR sky130_fd_sc_hd__fill_1
XPHY_EDGE_ROW_80_Left_168 VGND VGND VPWR VPWR sky130_fd_sc_hd__decap_3
XFILLER_0_35_337 VPWR VGND VPWR VGND sky130_ef_sc_hd__decap_12
XTAP_TAPCELL_ROW_74_858 VGND VPWR sky130_fd_sc_hd__tapvpwrvgnd_1
XFILLER_0_14_15 VPWR VGND VPWR VGND sky130_ef_sc_hd__decap_12
XFILLER_0_58_418 VGND VGND VPWR VPWR sky130_fd_sc_hd__fill_2
XFILLER_0_85_248 VGND VGND VPWR VPWR sky130_fd_sc_hd__fill_2
XFILLER_0_38_153 VGND VGND VPWR VPWR sky130_fd_sc_hd__decap_6
XFILLER_0_38_197 VGND VGND VPWR VPWR sky130_fd_sc_hd__fill_1
XFILLER_0_53_101 VGND VGND VPWR VPWR sky130_fd_sc_hd__decap_8
XFILLER_0_66_484 VPWR VGND VPWR VGND sky130_ef_sc_hd__decap_12
XFILLER_0_34_392 VPWR VGND VPWR VGND sky130_ef_sc_hd__decap_12
X_3230_ _1424_ _1425_ VGND VGND VPWR VPWR _1426_ sky130_fd_sc_hd__nand2_1
XFILLER_0_55_11 VGND VGND VPWR VPWR sky130_fd_sc_hd__fill_1
X_3161_ net58 _1322_ VGND VGND VPWR VPWR _1357_ sky130_fd_sc_hd__nor2_1
X_3092_ RF0.regs\[5\]\[3\] _0873_ _0862_ RF0.regs\[4\]\[3\] _1287_ VGND VGND VPWR
+ VPWR _1288_ sky130_fd_sc_hd__a221o_1
XFILLER_0_55_55 VGND VGND VPWR VPWR sky130_fd_sc_hd__fill_1
XFILLER_0_71_76 VGND VGND VPWR VPWR sky130_fd_sc_hd__decap_4
XTAP_TAPCELL_ROW_45_593 VGND VPWR sky130_fd_sc_hd__tapvpwrvgnd_1
X_3994_ RF0.regs\[5\]\[11\] _2072_ _2124_ VGND VGND VPWR VPWR _2125_ sky130_fd_sc_hd__mux2_1
XFILLER_0_57_462 VPWR VGND VPWR VGND sky130_ef_sc_hd__decap_12
XFILLER_0_17_337 VGND VGND VPWR VPWR sky130_fd_sc_hd__decap_4
X_2945_ net116 VGND VGND VPWR VPWR _1178_ sky130_fd_sc_hd__clkbuf_1
XFILLER_0_72_454 VGND VGND VPWR VPWR sky130_fd_sc_hd__fill_1
X_2876_ _0821_ _0859_ VGND VGND VPWR VPWR _1140_ sky130_fd_sc_hd__and2_1
X_4615_ _2443_ VGND VGND VPWR VPWR _0043_ sky130_fd_sc_hd__inv_2
XFILLER_0_4_264 VGND VGND VPWR VPWR sky130_fd_sc_hd__fill_2
X_4546_ _2424_ VGND VGND VPWR VPWR net5 sky130_fd_sc_hd__clkbuf_1
XFILLER_0_20_80 VGND VGND VPWR VPWR sky130_fd_sc_hd__decap_4
X_4477_ _2377_ VGND VGND VPWR VPWR _0399_ sky130_fd_sc_hd__clkbuf_1
X_3428_ RF0.regs\[10\]\[24\] _0887_ _0807_ RF0.regs\[25\]\[24\] _1247_ VGND VGND VPWR
+ VPWR _1622_ sky130_fd_sc_hd__a221o_1
X_3359_ net56 _1342_ _1553_ _1554_ _0799_ VGND VGND VPWR VPWR net26 sky130_fd_sc_hd__a311oi_4
X_5029_ clknet_leaf_25_clk _0405_ _0021_ VGND VGND VPWR VPWR RF0.regs\[25\]\[12\]
+ sky130_fd_sc_hd__dfrtp_1
XTAP_TAPCELL_ROW_71_828 VGND VPWR sky130_fd_sc_hd__tapvpwrvgnd_1
XTAP_TAPCELL_ROW_0_185 VGND VPWR sky130_fd_sc_hd__tapvpwrvgnd_1
XFILLER_0_48_495 VGND VGND VPWR VPWR sky130_fd_sc_hd__fill_1
XFILLER_0_35_145 VGND VGND VPWR VPWR sky130_fd_sc_hd__fill_2
XFILLER_0_31_351 VGND VGND VPWR VPWR sky130_fd_sc_hd__decap_8
XTAP_TAPCELL_ROW_8_263 VGND VPWR sky130_fd_sc_hd__tapvpwrvgnd_1
XTAP_TAPCELL_ROW_87_983 VGND VPWR sky130_fd_sc_hd__tapvpwrvgnd_1
XTAP_TAPCELL_ROW_87_972 VGND VPWR sky130_fd_sc_hd__tapvpwrvgnd_1
XFILLER_0_86_513 VGND VGND VPWR VPWR sky130_fd_sc_hd__decap_4
XFILLER_0_26_112 VPWR VGND VPWR VGND sky130_ef_sc_hd__decap_12
XFILLER_0_41_57 VPWR VGND VPWR VGND sky130_ef_sc_hd__decap_12
XTAP_TAPCELL_ROW_42_563 VGND VPWR sky130_fd_sc_hd__tapvpwrvgnd_1
XFILLER_0_26_156 VGND VGND VPWR VPWR sky130_fd_sc_hd__fill_2
X_2730_ RF0.regs\[4\]\[21\] _0868_ _0880_ RF0.regs\[2\]\[21\] _1021_ VGND VGND VPWR
+ VPWR _1022_ sky130_fd_sc_hd__a221o_1
XFILLER_0_14_329 VPWR VGND VPWR VGND sky130_ef_sc_hd__decap_12
XFILLER_0_14_307 VGND VGND VPWR VPWR sky130_fd_sc_hd__fill_1
X_2661_ _0950_ _0952_ VGND VGND VPWR VPWR _0953_ sky130_fd_sc_hd__xor2_1
XFILLER_0_41_126 VPWR VGND VPWR VGND sky130_ef_sc_hd__decap_12
X_4400_ _2337_ VGND VGND VPWR VPWR _0436_ sky130_fd_sc_hd__clkbuf_1
X_5380_ clknet_leaf_41_clk _0756_ _0372_ VGND VGND VPWR VPWR IM0.addr\[11\] sky130_fd_sc_hd__dfrtp_1
X_2592_ _0883_ VGND VGND VPWR VPWR _0884_ sky130_fd_sc_hd__buf_4
XFILLER_0_41_159 VGND VGND VPWR VPWR sky130_fd_sc_hd__decap_8
XFILLER_0_1_245 VGND VGND VPWR VPWR sky130_fd_sc_hd__fill_1
XFILLER_0_22_384 VPWR VGND VPWR VGND sky130_ef_sc_hd__decap_12
X_4331_ _2278_ VGND VGND VPWR VPWR _2301_ sky130_fd_sc_hd__buf_4
XFILLER_0_1_278 VGND VGND VPWR VPWR sky130_fd_sc_hd__fill_2
X_4262_ net94 VGND VGND VPWR VPWR _2265_ sky130_fd_sc_hd__clkbuf_1
XFILLER_0_5_57 VPWR VGND VPWR VGND sky130_ef_sc_hd__decap_12
X_3213_ _1277_ _1401_ VGND VGND VPWR VPWR _1409_ sky130_fd_sc_hd__nand2_1
XFILLER_0_66_65 VPWR VGND VPWR VGND sky130_ef_sc_hd__decap_12
X_4193_ RF0.regs\[10\]\[14\] _2063_ _2222_ VGND VGND VPWR VPWR _2230_ sky130_fd_sc_hd__mux2_1
X_3144_ _0818_ _1263_ VGND VGND VPWR VPWR _1340_ sky130_fd_sc_hd__and2_2
X_3075_ RF0.regs\[5\]\[11\] _0873_ _0862_ RF0.regs\[4\]\[11\] VGND VGND VPWR VPWR
+ _1271_ sky130_fd_sc_hd__a22o_1
XFILLER_0_82_53 VPWR VGND VPWR VGND sky130_ef_sc_hd__decap_12
XFILLER_0_9_334 VGND VGND VPWR VPWR sky130_fd_sc_hd__fill_2
XFILLER_0_9_312 VGND VGND VPWR VPWR sky130_fd_sc_hd__fill_1
X_3977_ RF0.regs\[5\]\[19\] _2000_ _2113_ VGND VGND VPWR VPWR _2116_ sky130_fd_sc_hd__mux2_1
XFILLER_0_57_281 VGND VGND VPWR VPWR sky130_fd_sc_hd__decap_3
X_2928_ _1169_ VGND VGND VPWR VPWR _0726_ sky130_fd_sc_hd__clkbuf_1
XFILLER_0_72_251 VGND VGND VPWR VPWR sky130_fd_sc_hd__fill_1
XFILLER_0_45_465 VGND VGND VPWR VPWR sky130_fd_sc_hd__fill_1
X_2859_ _1117_ net206 VGND VGND VPWR VPWR _1130_ sky130_fd_sc_hd__and2_1
XFILLER_0_60_446 VGND VGND VPWR VPWR sky130_fd_sc_hd__decap_8
X_4529_ _2408_ _2409_ _2414_ _2406_ VGND VGND VPWR VPWR _0003_ sky130_fd_sc_hd__a22o_1
XTAP_TAPCELL_ROW_5_233 VGND VPWR sky130_fd_sc_hd__tapvpwrvgnd_1
XTAP_TAPCELL_ROW_84_942 VGND VPWR sky130_fd_sc_hd__tapvpwrvgnd_1
XFILLER_0_83_505 VPWR VGND VPWR VGND sky130_ef_sc_hd__decap_12
XFILLER_0_11_27 VPWR VGND VPWR VGND sky130_ef_sc_hd__decap_12
XFILLER_0_36_68 VGND VGND VPWR VPWR sky130_fd_sc_hd__decap_6
XTAP_TAPCELL_ROW_47_611 VGND VPWR sky130_fd_sc_hd__tapvpwrvgnd_1
XTAP_TAPCELL_ROW_19_357 VGND VPWR sky130_fd_sc_hd__tapvpwrvgnd_1
XFILLER_0_86_365 VPWR VGND VPWR VGND sky130_ef_sc_hd__decap_12
X_4880_ _2475_ VGND VGND VPWR VPWR _0276_ sky130_fd_sc_hd__inv_2
X_3900_ _2019_ _2059_ _1780_ VGND VGND VPWR VPWR _2065_ sky130_fd_sc_hd__o21a_1
X_3831_ _2003_ VGND VGND VPWR VPWR _0667_ sky130_fd_sc_hd__clkbuf_1
X_3762_ _1570_ _1572_ VGND VGND VPWR VPWR _1948_ sky130_fd_sc_hd__nand2_1
XFILLER_0_39_281 VGND VGND VPWR VPWR sky130_fd_sc_hd__fill_2
X_3693_ RF0.regs\[5\]\[1\] _0863_ _1230_ RF0.regs\[6\]\[1\] VGND VGND VPWR VPWR _1879_
+ sky130_fd_sc_hd__a22o_1
XFILLER_0_42_424 VGND VGND VPWR VPWR sky130_fd_sc_hd__fill_2
X_2713_ _0997_ _0999_ _1002_ _1004_ VGND VGND VPWR VPWR _1005_ sky130_fd_sc_hd__a2bb2o_1
X_2644_ RF0.regs\[4\]\[12\] _0835_ _0843_ RF0.regs\[12\]\[12\] VGND VGND VPWR VPWR
+ _0936_ sky130_fd_sc_hd__a22o_1
X_2575_ _0866_ VGND VGND VPWR VPWR _0867_ sky130_fd_sc_hd__buf_4
X_5363_ clknet_leaf_6_clk _0739_ _0355_ VGND VGND VPWR VPWR RF0.regs\[0\]\[26\] sky130_fd_sc_hd__dfrtp_1
X_4314_ _2292_ VGND VGND VPWR VPWR _0477_ sky130_fd_sc_hd__clkbuf_1
X_5294_ clknet_leaf_11_clk _0670_ _0286_ VGND VGND VPWR VPWR RF0.regs\[4\]\[21\] sky130_fd_sc_hd__dfrtp_2
XFILLER_0_10_376 VPWR VGND VPWR VGND sky130_ef_sc_hd__decap_12
X_4245_ _2256_ VGND VGND VPWR VPWR _0510_ sky130_fd_sc_hd__clkbuf_1
XTAP_TAPCELL_ROW_2_203 VGND VPWR sky130_fd_sc_hd__tapvpwrvgnd_1
X_4176_ RF0.regs\[10\]\[22\] _1988_ _2211_ VGND VGND VPWR VPWR _2221_ sky130_fd_sc_hd__mux2_1
X_3127_ _1264_ _1002_ VGND VGND VPWR VPWR _1323_ sky130_fd_sc_hd__or2_1
X_3058_ _1253_ VGND VGND VPWR VPWR _1254_ sky130_fd_sc_hd__buf_4
XFILLER_0_65_505 VPWR VGND VPWR VGND sky130_ef_sc_hd__decap_12
XTAP_TAPCELL_ROW_53_669 VGND VPWR sky130_fd_sc_hd__tapvpwrvgnd_1
XFILLER_0_18_421 VGND VGND VPWR VPWR sky130_fd_sc_hd__decap_4
XFILLER_0_45_240 VGND VGND VPWR VPWR sky130_fd_sc_hd__fill_1
XFILLER_0_18_498 VGND VGND VPWR VPWR sky130_fd_sc_hd__fill_2
XFILLER_0_60_298 VGND VGND VPWR VPWR sky130_fd_sc_hd__decap_3
XFILLER_0_13_181 VPWR VGND VPWR VGND sky130_ef_sc_hd__decap_12
XFILLER_0_68_354 VGND VGND VPWR VPWR sky130_fd_sc_hd__decap_3
XFILLER_0_22_15 VPWR VGND VPWR VGND sky130_ef_sc_hd__decap_12
XFILLER_0_83_357 VGND VGND VPWR VPWR sky130_fd_sc_hd__fill_1
XFILLER_0_24_413 VGND VGND VPWR VPWR sky130_fd_sc_hd__fill_1
XFILLER_0_11_129 VGND VGND VPWR VPWR sky130_fd_sc_hd__decap_3
XFILLER_0_51_276 VGND VGND VPWR VPWR sky130_fd_sc_hd__decap_4
XFILLER_0_51_287 VGND VGND VPWR VPWR sky130_fd_sc_hd__fill_1
XPHY_EDGE_ROW_10_Right_10 VGND VGND VPWR VPWR sky130_fd_sc_hd__decap_3
X_4030_ _1975_ net218 _2138_ VGND VGND VPWR VPWR _2144_ sky130_fd_sc_hd__mux2_1
XFILLER_0_59_321 VGND VGND VPWR VPWR sky130_fd_sc_hd__fill_1
XFILLER_0_63_55 VGND VGND VPWR VPWR sky130_fd_sc_hd__fill_1
Xclkbuf_leaf_44_clk clknet_2_0__leaf_clk VGND VGND VPWR VPWR clknet_leaf_44_clk sky130_fd_sc_hd__clkbuf_8
X_4932_ _2482_ VGND VGND VPWR VPWR _0321_ sky130_fd_sc_hd__inv_2
XFILLER_0_47_505 VGND VGND VPWR VPWR sky130_fd_sc_hd__fill_1
X_4863_ _2471_ VGND VGND VPWR VPWR _2474_ sky130_fd_sc_hd__clkbuf_8
XTAP_TAPCELL_ROW_50_639 VGND VPWR sky130_fd_sc_hd__tapvpwrvgnd_1
X_3814_ _1663_ _1928_ VGND VGND VPWR VPWR _1990_ sky130_fd_sc_hd__nor2_1
XFILLER_0_6_134 VGND VGND VPWR VPWR sky130_fd_sc_hd__decap_6
X_4794_ _2466_ VGND VGND VPWR VPWR _0199_ sky130_fd_sc_hd__inv_2
X_3745_ _1647_ _1649_ VGND VGND VPWR VPWR _1931_ sky130_fd_sc_hd__or2_1
XFILLER_0_15_446 VGND VGND VPWR VPWR sky130_fd_sc_hd__fill_2
XFILLER_0_15_457 VPWR VGND VPWR VGND sky130_ef_sc_hd__decap_12
X_3676_ RF0.regs\[5\]\[3\] _0864_ _1220_ RF0.regs\[20\]\[3\] VGND VGND VPWR VPWR _1862_
+ sky130_fd_sc_hd__a22o_1
XFILLER_0_2_340 VPWR VGND VPWR VGND sky130_ef_sc_hd__decap_12
X_5415_ clknet_leaf_23_clk net7 VGND VGND VPWR VPWR disp.digits\[14\] sky130_fd_sc_hd__dfxtp_1
X_2627_ RF0.regs\[10\]\[13\] _0811_ _0828_ RF0.regs\[25\]\[13\] _0918_ VGND VGND VPWR
+ VPWR _0919_ sky130_fd_sc_hd__a221o_1
XFILLER_0_63_3 VPWR VGND VPWR VGND sky130_ef_sc_hd__decap_12
X_2558_ IM0.addr\[3\] _0820_ VGND VGND VPWR VPWR _0850_ sky130_fd_sc_hd__or2_1
X_5346_ clknet_leaf_30_clk _0722_ _0338_ VGND VGND VPWR VPWR RF0.regs\[0\]\[9\] sky130_fd_sc_hd__dfrtp_1
X_2489_ IM0.addr\[3\] IM0.addr\[0\] VGND VGND VPWR VPWR _0781_ sky130_fd_sc_hd__and2_1
XFILLER_0_10_184 VGND VGND VPWR VPWR sky130_fd_sc_hd__fill_1
X_5277_ clknet_leaf_35_clk _0653_ _0269_ VGND VGND VPWR VPWR RF0.regs\[4\]\[4\] sky130_fd_sc_hd__dfrtp_1
X_4228_ net149 VGND VGND VPWR VPWR _2248_ sky130_fd_sc_hd__clkbuf_1
X_4159_ _2212_ VGND VGND VPWR VPWR _0552_ sky130_fd_sc_hd__clkbuf_1
XTAP_TAPCELL_ROW_66_783 VGND VPWR sky130_fd_sc_hd__tapvpwrvgnd_1
Xclkbuf_leaf_35_clk clknet_2_2__leaf_clk VGND VGND VPWR VPWR clknet_leaf_35_clk sky130_fd_sc_hd__clkbuf_8
XFILLER_0_65_313 VGND VGND VPWR VPWR sky130_fd_sc_hd__fill_2
XTAP_TAPCELL_ROW_13_308 VGND VPWR sky130_fd_sc_hd__tapvpwrvgnd_1
XTAP_TAPCELL_ROW_21_374 VGND VPWR sky130_fd_sc_hd__tapvpwrvgnd_1
XFILLER_0_17_15 VPWR VGND VPWR VGND sky130_ef_sc_hd__decap_12
XTAP_TAPCELL_ROW_29_452 VGND VPWR sky130_fd_sc_hd__tapvpwrvgnd_1
Xclkbuf_leaf_26_clk clknet_2_3__leaf_clk VGND VGND VPWR VPWR clknet_leaf_26_clk sky130_fd_sc_hd__clkbuf_8
XFILLER_0_68_162 VPWR VGND VPWR VGND sky130_ef_sc_hd__decap_12
XFILLER_0_68_195 VGND VGND VPWR VPWR sky130_fd_sc_hd__fill_1
XFILLER_0_71_349 VGND VGND VPWR VPWR sky130_fd_sc_hd__decap_4
X_3530_ RF0.regs\[5\]\[16\] _0866_ _1228_ RF0.regs\[15\]\[16\] VGND VGND VPWR VPWR
+ _1722_ sky130_fd_sc_hd__a22o_1
XFILLER_0_12_405 VGND VGND VPWR VPWR sky130_fd_sc_hd__fill_1
X_3461_ RF0.regs\[10\]\[20\] _0886_ _0814_ RF0.regs\[25\]\[20\] _1246_ VGND VGND VPWR
+ VPWR _1655_ sky130_fd_sc_hd__a221o_1
X_5200_ clknet_leaf_10_clk _0576_ _0192_ VGND VGND VPWR VPWR RF0.regs\[7\]\[23\] sky130_fd_sc_hd__dfrtp_1
X_3392_ _1148_ _1545_ _1585_ _1583_ VGND VGND VPWR VPWR _1586_ sky130_fd_sc_hd__nand4_1
XFILLER_0_58_55 VGND VGND VPWR VPWR sky130_fd_sc_hd__decap_4
XFILLER_0_20_471 VGND VGND VPWR VPWR sky130_fd_sc_hd__decap_4
X_5131_ clknet_leaf_14_clk _0507_ _0123_ VGND VGND VPWR VPWR RF0.regs\[12\]\[18\]
+ sky130_fd_sc_hd__dfrtp_1
X_5062_ clknet_leaf_21_clk _0438_ _0054_ VGND VGND VPWR VPWR RF0.regs\[20\]\[13\]
+ sky130_fd_sc_hd__dfrtp_1
X_4013_ _2134_ VGND VGND VPWR VPWR _0619_ sky130_fd_sc_hd__clkbuf_1
Xclkbuf_leaf_17_clk clknet_2_3__leaf_clk VGND VGND VPWR VPWR clknet_leaf_17_clk sky130_fd_sc_hd__clkbuf_8
XFILLER_0_59_162 VGND VGND VPWR VPWR sky130_fd_sc_hd__decap_6
XTAP_TAPCELL_ROW_63_753 VGND VPWR sky130_fd_sc_hd__tapvpwrvgnd_1
XFILLER_0_74_121 VGND VGND VPWR VPWR sky130_fd_sc_hd__decap_6
X_4915_ _2479_ VGND VGND VPWR VPWR _0307_ sky130_fd_sc_hd__inv_2
XFILLER_0_35_508 VGND VGND VPWR VPWR sky130_fd_sc_hd__decap_4
X_4846_ _2472_ VGND VGND VPWR VPWR _0245_ sky130_fd_sc_hd__inv_2
XFILLER_0_62_316 VPWR VGND VPWR VGND sky130_ef_sc_hd__decap_12
XFILLER_0_15_210 VPWR VGND VPWR VGND sky130_ef_sc_hd__decap_12
X_4777_ _2465_ VGND VGND VPWR VPWR _0183_ sky130_fd_sc_hd__inv_2
X_3728_ _1805_ _1814_ _1912_ _1913_ VGND VGND VPWR VPWR _1914_ sky130_fd_sc_hd__o31a_2
X_3659_ RF0.regs\[4\]\[5\] _1238_ VGND VGND VPWR VPWR _1845_ sky130_fd_sc_hd__and2_1
XFILLER_0_11_460 VPWR VGND VPWR VGND sky130_ef_sc_hd__decap_12
X_5329_ clknet_leaf_3_clk _0705_ _0321_ VGND VGND VPWR VPWR RF0.regs\[2\]\[24\] sky130_fd_sc_hd__dfrtp_1
XTAP_TAPCELL_ROW_26_422 VGND VPWR sky130_fd_sc_hd__tapvpwrvgnd_1
XFILLER_0_80_124 VGND VGND VPWR VPWR sky130_fd_sc_hd__fill_1
XFILLER_0_53_349 VGND VGND VPWR VPWR sky130_fd_sc_hd__fill_1
XTAP_TAPCELL_ROW_77_878 VGND VPWR sky130_fd_sc_hd__tapvpwrvgnd_1
XFILLER_0_76_419 VGND VGND VPWR VPWR sky130_fd_sc_hd__fill_1
X_2961_ net167 VGND VGND VPWR VPWR _1186_ sky130_fd_sc_hd__clkbuf_1
X_4700_ _2451_ VGND VGND VPWR VPWR _2455_ sky130_fd_sc_hd__buf_4
X_4631_ _2444_ VGND VGND VPWR VPWR _0058_ sky130_fd_sc_hd__inv_2
X_2892_ _1151_ VGND VGND VPWR VPWR _0744_ sky130_fd_sc_hd__clkbuf_1
XFILLER_0_44_316 VGND VGND VPWR VPWR sky130_fd_sc_hd__decap_8
XFILLER_0_4_413 VGND VGND VPWR VPWR sky130_fd_sc_hd__decap_6
XFILLER_0_37_390 VGND VGND VPWR VPWR sky130_fd_sc_hd__fill_2
XFILLER_0_4_457 VPWR VGND VPWR VGND sky130_ef_sc_hd__decap_12
X_4562_ _2430_ VGND VGND VPWR VPWR net19 sky130_fd_sc_hd__buf_1
XFILLER_0_69_54 VGND VGND VPWR VPWR sky130_fd_sc_hd__fill_2
X_4493_ _0007_ net69 VGND VGND VPWR VPWR _2385_ sky130_fd_sc_hd__nor2_2
X_3513_ _1491_ _1704_ _1699_ VGND VGND VPWR VPWR _1706_ sky130_fd_sc_hd__a21o_1
Xclkbuf_leaf_6_clk clknet_2_1__leaf_clk VGND VGND VPWR VPWR clknet_leaf_6_clk sky130_fd_sc_hd__clkbuf_8
X_3444_ RF0.regs\[10\]\[23\] _0887_ _0815_ RF0.regs\[25\]\[23\] _1247_ VGND VGND VPWR
+ VPWR _1638_ sky130_fd_sc_hd__a221o_1
X_3375_ _1566_ _1567_ _1569_ _1219_ RF0.regs\[0\]\[29\] VGND VGND VPWR VPWR _1570_
+ sky130_fd_sc_hd__o32a_1
X_5114_ clknet_leaf_3_clk _0490_ _0106_ VGND VGND VPWR VPWR RF0.regs\[12\]\[1\] sky130_fd_sc_hd__dfrtp_1
XTAP_TAPCELL_ROW_68_801 VGND VPWR sky130_fd_sc_hd__tapvpwrvgnd_1
X_5045_ clknet_leaf_1_clk _0421_ _0037_ VGND VGND VPWR VPWR RF0.regs\[25\]\[28\] sky130_fd_sc_hd__dfrtp_1
XFILLER_0_26_3 VPWR VGND VPWR VGND sky130_ef_sc_hd__decap_12
XFILLER_0_47_143 VGND VGND VPWR VPWR sky130_fd_sc_hd__decap_3
XFILLER_0_75_485 VPWR VGND VPWR VGND sky130_ef_sc_hd__decap_12
X_4829_ _2462_ VGND VGND VPWR VPWR _2470_ sky130_fd_sc_hd__buf_4
XFILLER_0_28_390 VGND VGND VPWR VPWR sky130_fd_sc_hd__fill_1
XFILLER_0_35_349 VGND VGND VPWR VPWR sky130_fd_sc_hd__decap_3
XFILLER_0_31_500 VGND VGND VPWR VPWR sky130_fd_sc_hd__fill_1
XFILLER_0_43_393 VPWR VGND VPWR VGND sky130_ef_sc_hd__decap_12
XTAP_TAPCELL_ROW_74_859 VGND VPWR sky130_fd_sc_hd__tapvpwrvgnd_1
XFILLER_0_14_27 VGND VGND VPWR VPWR sky130_fd_sc_hd__fill_1
XFILLER_0_81_411 VPWR VGND VPWR VGND sky130_ef_sc_hd__decap_12
XFILLER_0_66_496 VPWR VGND VPWR VGND sky130_ef_sc_hd__decap_12
XFILLER_0_1_405 VPWR VGND VPWR VGND sky130_ef_sc_hd__decap_12
XFILLER_0_1_449 VPWR VGND VPWR VGND sky130_ef_sc_hd__decap_12
X_3160_ _1353_ _1355_ VGND VGND VPWR VPWR _1356_ sky130_fd_sc_hd__or2_1
X_3091_ RF0.regs\[2\]\[3\] _1236_ _1270_ RF0.regs\[15\]\[3\] _0989_ VGND VGND VPWR
+ VPWR _1287_ sky130_fd_sc_hd__a221o_1
XFILLER_0_71_55 VGND VGND VPWR VPWR sky130_fd_sc_hd__fill_1
XFILLER_0_9_505 VGND VGND VPWR VPWR sky130_fd_sc_hd__decap_8
XPHY_EDGE_ROW_8_Right_8 VGND VGND VPWR VPWR sky130_fd_sc_hd__decap_3
XTAP_TAPCELL_ROW_45_594 VGND VPWR sky130_fd_sc_hd__tapvpwrvgnd_1
X_3993_ _0868_ VGND VGND VPWR VPWR _2124_ sky130_fd_sc_hd__buf_4
X_2944_ _1177_ VGND VGND VPWR VPWR _0718_ sky130_fd_sc_hd__clkbuf_1
XFILLER_0_57_474 VGND VGND VPWR VPWR sky130_fd_sc_hd__decap_4
X_2875_ _0860_ VGND VGND VPWR VPWR _1139_ sky130_fd_sc_hd__buf_4
XFILLER_0_72_477 VPWR VGND VPWR VGND sky130_ef_sc_hd__decap_12
X_4614_ _2443_ VGND VGND VPWR VPWR _0042_ sky130_fd_sc_hd__inv_2
X_4545_ _1148_ _1776_ _1777_ VGND VGND VPWR VPWR _2424_ sky130_fd_sc_hd__and3_1
XFILLER_0_4_287 VPWR VGND VPWR VGND sky130_ef_sc_hd__decap_12
X_4476_ RF0.regs\[25\]\[6\] _2088_ _2371_ VGND VGND VPWR VPWR _2377_ sky130_fd_sc_hd__mux2_1
XPHY_EDGE_ROW_39_Right_39 VGND VGND VPWR VPWR sky130_fd_sc_hd__decap_3
X_3427_ RF0.regs\[6\]\[24\] _1233_ _1229_ RF0.regs\[15\]\[24\] _1620_ VGND VGND VPWR
+ VPWR _1621_ sky130_fd_sc_hd__a221o_1
X_3358_ _1342_ _1550_ _1553_ VGND VGND VPWR VPWR _1554_ sky130_fd_sc_hd__a21oi_2
X_3289_ _1483_ _1484_ _1340_ VGND VGND VPWR VPWR _1485_ sky130_fd_sc_hd__a21oi_2
X_5028_ clknet_leaf_26_clk _0404_ _0020_ VGND VGND VPWR VPWR RF0.regs\[25\]\[11\]
+ sky130_fd_sc_hd__dfrtp_1
XTAP_TAPCELL_ROW_71_829 VGND VPWR sky130_fd_sc_hd__tapvpwrvgnd_1
XTAP_TAPCELL_ROW_0_186 VGND VPWR sky130_fd_sc_hd__tapvpwrvgnd_1
XPHY_EDGE_ROW_48_Right_48 VGND VGND VPWR VPWR sky130_fd_sc_hd__decap_3
XFILLER_0_75_260 VGND VGND VPWR VPWR sky130_fd_sc_hd__fill_1
XFILLER_0_48_474 VGND VGND VPWR VPWR sky130_fd_sc_hd__fill_2
XFILLER_0_63_411 VGND VGND VPWR VPWR sky130_fd_sc_hd__decap_8
XFILLER_0_63_455 VGND VGND VPWR VPWR sky130_fd_sc_hd__fill_1
XFILLER_0_50_138 VGND VGND VPWR VPWR sky130_fd_sc_hd__fill_2
XPHY_EDGE_ROW_57_Right_57 VGND VGND VPWR VPWR sky130_fd_sc_hd__decap_3
XTAP_TAPCELL_ROW_8_264 VGND VPWR sky130_fd_sc_hd__tapvpwrvgnd_1
XTAP_TAPCELL_ROW_87_973 VGND VPWR sky130_fd_sc_hd__tapvpwrvgnd_1
XTAP_TAPCELL_ROW_87_984 VGND VPWR sky130_fd_sc_hd__tapvpwrvgnd_1
XPHY_EDGE_ROW_66_Right_66 VGND VGND VPWR VPWR sky130_fd_sc_hd__decap_3
XTAP_TAPCELL_ROW_42_564 VGND VPWR sky130_fd_sc_hd__tapvpwrvgnd_1
XFILLER_0_26_124 VGND VGND VPWR VPWR sky130_fd_sc_hd__decap_4
XFILLER_0_41_69 VPWR VGND VPWR VGND sky130_ef_sc_hd__decap_12
XFILLER_0_26_179 VPWR VGND VPWR VGND sky130_ef_sc_hd__decap_12
X_2660_ RF0.regs\[10\]\[5\] _0810_ _0827_ RF0.regs\[25\]\[5\] _0951_ VGND VGND VPWR
+ VPWR _0952_ sky130_fd_sc_hd__a221o_1
XFILLER_0_54_477 VGND VGND VPWR VPWR sky130_fd_sc_hd__decap_4
XFILLER_0_41_138 VGND VGND VPWR VPWR sky130_fd_sc_hd__fill_2
XPHY_EDGE_ROW_75_Right_75 VGND VGND VPWR VPWR sky130_fd_sc_hd__decap_3
X_2591_ _0882_ VGND VGND VPWR VPWR _0883_ sky130_fd_sc_hd__buf_4
XFILLER_0_22_363 VGND VGND VPWR VPWR sky130_fd_sc_hd__fill_1
XFILLER_0_22_396 VPWR VGND VPWR VGND sky130_ef_sc_hd__decap_12
X_4330_ _2300_ VGND VGND VPWR VPWR _0469_ sky130_fd_sc_hd__clkbuf_1
X_4261_ _2264_ VGND VGND VPWR VPWR _0502_ sky130_fd_sc_hd__clkbuf_1
XFILLER_0_5_69 VPWR VGND VPWR VGND sky130_ef_sc_hd__decap_12
X_3212_ RF0.regs\[25\]\[3\] _1252_ _1254_ RF0.regs\[12\]\[3\] _1407_ VGND VGND VPWR
+ VPWR _1408_ sky130_fd_sc_hd__a221oi_2
X_4192_ _2229_ VGND VGND VPWR VPWR _0536_ sky130_fd_sc_hd__clkbuf_1
XFILLER_0_66_77 VGND VGND VPWR VPWR sky130_fd_sc_hd__fill_2
X_3143_ _1264_ _1261_ _1337_ VGND VGND VPWR VPWR _1339_ sky130_fd_sc_hd__o21ai_2
XPHY_EDGE_ROW_84_Right_84 VGND VGND VPWR VPWR sky130_fd_sc_hd__decap_3
X_3074_ net55 net66 _0849_ _0851_ VGND VGND VPWR VPWR _1270_ sky130_fd_sc_hd__and4_2
XFILLER_0_82_65 VPWR VGND VPWR VGND sky130_ef_sc_hd__decap_12
XFILLER_0_15_81 VGND VGND VPWR VPWR sky130_fd_sc_hd__decap_6
X_3976_ _2115_ VGND VGND VPWR VPWR _0637_ sky130_fd_sc_hd__clkbuf_1
XFILLER_0_17_113 VGND VGND VPWR VPWR sky130_fd_sc_hd__decap_4
XFILLER_0_9_368 VPWR VGND VPWR VGND sky130_ef_sc_hd__decap_12
XFILLER_0_45_422 VGND VGND VPWR VPWR sky130_fd_sc_hd__fill_1
X_2927_ net70 VGND VGND VPWR VPWR _1169_ sky130_fd_sc_hd__clkbuf_1
XFILLER_0_72_241 VGND VGND VPWR VPWR sky130_fd_sc_hd__fill_1
XFILLER_0_60_414 VGND VGND VPWR VPWR sky130_fd_sc_hd__decap_6
X_2858_ _1129_ VGND VGND VPWR VPWR _0756_ sky130_fd_sc_hd__clkbuf_1
XFILLER_0_45_499 VGND VGND VPWR VPWR sky130_fd_sc_hd__decap_4
Xhold220 IM0.addr\[28\] VGND VGND VPWR VPWR net268 sky130_fd_sc_hd__dlygate4sd3_1
X_2789_ RF0.regs\[4\]\[2\] _0834_ _0842_ RF0.regs\[12\]\[2\] VGND VGND VPWR VPWR _1081_
+ sky130_fd_sc_hd__a22o_1
XFILLER_0_25_190 VGND VGND VPWR VPWR sky130_fd_sc_hd__decap_6
X_4528_ _2398_ _2413_ _2404_ VGND VGND VPWR VPWR _2414_ sky130_fd_sc_hd__a21oi_1
X_4459_ RF0.regs\[25\]\[14\] _2063_ _2360_ VGND VGND VPWR VPWR _2368_ sky130_fd_sc_hd__mux2_1
XTAP_TAPCELL_ROW_5_234 VGND VPWR sky130_fd_sc_hd__tapvpwrvgnd_1
XTAP_TAPCELL_ROW_84_943 VGND VPWR sky130_fd_sc_hd__tapvpwrvgnd_1
XFILLER_0_68_514 VGND VGND VPWR VPWR sky130_fd_sc_hd__decap_3
XTAP_TAPCELL_ROW_56_689 VGND VPWR sky130_fd_sc_hd__tapvpwrvgnd_1
XFILLER_0_48_293 VGND VGND VPWR VPWR sky130_fd_sc_hd__decap_8
XFILLER_0_11_39 VPWR VGND VPWR VGND sky130_ef_sc_hd__decap_12
XFILLER_0_23_105 VGND VGND VPWR VPWR sky130_fd_sc_hd__decap_4
XFILLER_0_51_469 VGND VGND VPWR VPWR sky130_fd_sc_hd__fill_2
XTAP_TAPCELL_ROW_47_612 VGND VPWR sky130_fd_sc_hd__tapvpwrvgnd_1
XTAP_TAPCELL_ROW_19_358 VGND VPWR sky130_fd_sc_hd__tapvpwrvgnd_1
XFILLER_0_86_377 VPWR VGND VPWR VGND sky130_ef_sc_hd__decap_12
X_3830_ RF0.regs\[4\]\[18\] _2002_ _1993_ VGND VGND VPWR VPWR _2003_ sky130_fd_sc_hd__mux2_1
X_3761_ _1619_ _1629_ _1933_ _1946_ VGND VGND VPWR VPWR _1947_ sky130_fd_sc_hd__o31a_1
XFILLER_0_27_466 VGND VGND VPWR VPWR sky130_fd_sc_hd__fill_1
X_2712_ RF0.regs\[10\]\[24\] _0814_ _0829_ RF0.regs\[25\]\[24\] _1003_ VGND VGND VPWR
+ VPWR _1004_ sky130_fd_sc_hd__a221o_1
X_3692_ _1395_ _1398_ VGND VGND VPWR VPWR _1878_ sky130_fd_sc_hd__xor2_1
XFILLER_0_42_414 VGND VGND VPWR VPWR sky130_fd_sc_hd__decap_6
X_2643_ RF0.regs\[2\]\[12\] _0878_ _0933_ _0934_ VGND VGND VPWR VPWR _0935_ sky130_fd_sc_hd__a211oi_2
XTAP_TAPCELL_ROW_10_280 VGND VPWR sky130_fd_sc_hd__tapvpwrvgnd_1
X_2574_ _0865_ VGND VGND VPWR VPWR _0866_ sky130_fd_sc_hd__buf_4
X_5362_ clknet_leaf_9_clk _0738_ _0354_ VGND VGND VPWR VPWR RF0.regs\[0\]\[25\] sky130_fd_sc_hd__dfrtp_1
X_4313_ RF0.regs\[15\]\[20\] _1996_ _2290_ VGND VGND VPWR VPWR _2292_ sky130_fd_sc_hd__mux2_1
XFILLER_0_10_333 VPWR VGND VPWR VGND sky130_ef_sc_hd__decap_12
XFILLER_0_22_182 VPWR VGND VPWR VGND sky130_ef_sc_hd__decap_12
X_5293_ clknet_leaf_11_clk _0669_ _0285_ VGND VGND VPWR VPWR RF0.regs\[4\]\[20\] sky130_fd_sc_hd__dfrtp_2
XFILLER_0_10_388 VGND VGND VPWR VPWR sky130_fd_sc_hd__decap_8
X_4244_ net227 VGND VGND VPWR VPWR _2256_ sky130_fd_sc_hd__clkbuf_1
XTAP_TAPCELL_ROW_2_204 VGND VPWR sky130_fd_sc_hd__tapvpwrvgnd_1
X_4175_ _2220_ VGND VGND VPWR VPWR _0544_ sky130_fd_sc_hd__clkbuf_1
X_3126_ _1319_ _1321_ _1258_ VGND VGND VPWR VPWR _1322_ sky130_fd_sc_hd__o21a_1
X_3057_ _0832_ _0831_ _1215_ VGND VGND VPWR VPWR _1253_ sky130_fd_sc_hd__and3b_1
XFILLER_0_26_80 VGND VGND VPWR VPWR sky130_fd_sc_hd__decap_4
XFILLER_0_9_110 VGND VGND VPWR VPWR sky130_fd_sc_hd__fill_2
XFILLER_0_9_198 VPWR VGND VPWR VGND sky130_ef_sc_hd__decap_12
XFILLER_0_18_477 VGND VGND VPWR VPWR sky130_fd_sc_hd__decap_4
X_3959_ _2106_ VGND VGND VPWR VPWR _0645_ sky130_fd_sc_hd__clkbuf_1
XFILLER_0_5_393 VPWR VGND VPWR VGND sky130_ef_sc_hd__decap_12
XFILLER_0_13_193 VGND VGND VPWR VPWR sky130_fd_sc_hd__fill_1
XFILLER_0_41_491 VGND VGND VPWR VPWR sky130_fd_sc_hd__fill_2
XFILLER_0_22_27 VGND VGND VPWR VPWR sky130_fd_sc_hd__fill_1
XFILLER_0_11_108 VGND VGND VPWR VPWR sky130_fd_sc_hd__decap_4
XFILLER_0_32_491 VGND VGND VPWR VPWR sky130_fd_sc_hd__fill_1
XFILLER_0_47_57 VGND VGND VPWR VPWR sky130_fd_sc_hd__fill_1
XFILLER_0_2_15 VPWR VGND VPWR VGND sky130_ef_sc_hd__decap_12
XFILLER_0_86_141 VPWR VGND VPWR VGND sky130_ef_sc_hd__decap_12
X_4931_ _2482_ VGND VGND VPWR VPWR _0320_ sky130_fd_sc_hd__inv_2
XFILLER_0_74_314 VPWR VGND VPWR VGND sky130_ef_sc_hd__decap_12
X_4862_ _2473_ VGND VGND VPWR VPWR _0260_ sky130_fd_sc_hd__inv_2
X_3813_ _1989_ VGND VGND VPWR VPWR _0671_ sky130_fd_sc_hd__clkbuf_1
XFILLER_0_27_241 VPWR VGND VPWR VGND sky130_ef_sc_hd__decap_12
X_4793_ _2466_ VGND VGND VPWR VPWR _0198_ sky130_fd_sc_hd__inv_2
X_3744_ _1669_ net15 _1929_ VGND VGND VPWR VPWR _1930_ sky130_fd_sc_hd__o21ai_1
XFILLER_0_15_469 VPWR VGND VPWR VGND sky130_ef_sc_hd__decap_12
X_3675_ _1406_ _1411_ VGND VGND VPWR VPWR _1861_ sky130_fd_sc_hd__xor2_1
X_5414_ clknet_leaf_23_clk net6 VGND VGND VPWR VPWR disp.digits\[13\] sky130_fd_sc_hd__dfxtp_1
X_2626_ RF0.regs\[4\]\[13\] _0836_ _0844_ RF0.regs\[12\]\[13\] VGND VGND VPWR VPWR
+ _0918_ sky130_fd_sc_hd__a22o_1
XFILLER_0_2_352 VPWR VGND VPWR VGND sky130_ef_sc_hd__decap_12
X_2557_ _0821_ _0848_ VGND VGND VPWR VPWR _0849_ sky130_fd_sc_hd__nor2_1
X_5345_ clknet_leaf_30_clk _0721_ _0337_ VGND VGND VPWR VPWR RF0.regs\[0\]\[8\] sky130_fd_sc_hd__dfrtp_1
X_5276_ clknet_leaf_35_clk _0652_ _0268_ VGND VGND VPWR VPWR RF0.regs\[4\]\[3\] sky130_fd_sc_hd__dfrtp_2
X_4227_ _2247_ VGND VGND VPWR VPWR _0519_ sky130_fd_sc_hd__clkbuf_1
XTAP_TAPCELL_ROW_58_707 VGND VPWR sky130_fd_sc_hd__tapvpwrvgnd_1
X_4158_ RF0.regs\[10\]\[31\] _1952_ _2211_ VGND VGND VPWR VPWR _2212_ sky130_fd_sc_hd__mux2_1
X_4089_ _1889_ net2 VGND VGND VPWR VPWR _2176_ sky130_fd_sc_hd__nor2_1
X_3109_ RF0.regs\[2\]\[17\] _1237_ _0854_ RF0.regs\[15\]\[17\] _0902_ VGND VGND VPWR
+ VPWR _1305_ sky130_fd_sc_hd__a221o_1
XTAP_TAPCELL_ROW_66_784 VGND VPWR sky130_fd_sc_hd__tapvpwrvgnd_1
XTAP_TAPCELL_ROW_13_309 VGND VPWR sky130_fd_sc_hd__tapvpwrvgnd_1
XPHY_EDGE_ROW_12_Left_100 VGND VGND VPWR VPWR sky130_fd_sc_hd__decap_3
XTAP_TAPCELL_ROW_21_375 VGND VPWR sky130_fd_sc_hd__tapvpwrvgnd_1
XFILLER_0_21_428 VGND VGND VPWR VPWR sky130_fd_sc_hd__decap_8
XFILLER_0_17_27 VPWR VGND VPWR VGND sky130_ef_sc_hd__decap_12
XTAP_TAPCELL_ROW_29_453 VGND VPWR sky130_fd_sc_hd__tapvpwrvgnd_1
XFILLER_0_33_15 VGND VGND VPWR VPWR sky130_fd_sc_hd__decap_4
XFILLER_0_33_48 VGND VGND VPWR VPWR sky130_fd_sc_hd__decap_4
XFILLER_0_68_141 VPWR VGND VPWR VGND sky130_ef_sc_hd__decap_12
XFILLER_0_68_174 VPWR VGND VPWR VGND sky130_ef_sc_hd__decap_12
XFILLER_0_83_122 VGND VGND VPWR VPWR sky130_fd_sc_hd__decap_6
XFILLER_0_83_111 VGND VGND VPWR VPWR sky130_fd_sc_hd__fill_1
XFILLER_0_83_155 VGND VGND VPWR VPWR sky130_fd_sc_hd__fill_1
XFILLER_0_24_244 VGND VGND VPWR VPWR sky130_fd_sc_hd__fill_1
X_3460_ RF0.regs\[20\]\[20\] _1224_ _1229_ RF0.regs\[15\]\[20\] _1653_ VGND VGND VPWR
+ VPWR _1654_ sky130_fd_sc_hd__a221o_1
X_3391_ _1575_ _1576_ VGND VGND VPWR VPWR _1585_ sky130_fd_sc_hd__or2_1
X_5130_ clknet_leaf_15_clk _0506_ _0122_ VGND VGND VPWR VPWR RF0.regs\[12\]\[17\]
+ sky130_fd_sc_hd__dfrtp_1
X_5061_ clknet_leaf_22_clk _0437_ _0053_ VGND VGND VPWR VPWR RF0.regs\[20\]\[12\]
+ sky130_fd_sc_hd__dfrtp_1
X_4012_ RF0.regs\[5\]\[2\] _2097_ _2124_ VGND VGND VPWR VPWR _2134_ sky130_fd_sc_hd__mux2_1
XFILLER_0_87_461 VPWR VGND VPWR VGND sky130_ef_sc_hd__decap_12
X_4914_ _2479_ VGND VGND VPWR VPWR _0306_ sky130_fd_sc_hd__inv_2
XTAP_TAPCELL_ROW_63_754 VGND VPWR sky130_fd_sc_hd__tapvpwrvgnd_1
X_4845_ _2472_ VGND VGND VPWR VPWR _0244_ sky130_fd_sc_hd__inv_2
X_4776_ _2465_ VGND VGND VPWR VPWR _0182_ sky130_fd_sc_hd__inv_2
XFILLER_0_62_328 VPWR VGND VPWR VGND sky130_ef_sc_hd__decap_12
XFILLER_0_15_222 VGND VGND VPWR VPWR sky130_fd_sc_hd__fill_2
X_3727_ _1009_ _1791_ _1800_ _1803_ VGND VGND VPWR VPWR _1913_ sky130_fd_sc_hd__nand4_1
X_3658_ _1843_ _1417_ VGND VGND VPWR VPWR _1844_ sky130_fd_sc_hd__xnor2_1
X_2609_ _0857_ VGND VGND VPWR VPWR _0901_ sky130_fd_sc_hd__buf_6
X_3589_ _1009_ _1776_ _1775_ _1777_ VGND VGND VPWR VPWR _1780_ sky130_fd_sc_hd__nand4_1
XFILLER_0_11_472 VGND VGND VPWR VPWR sky130_fd_sc_hd__decap_6
X_5328_ clknet_leaf_4_clk _0704_ _0320_ VGND VGND VPWR VPWR RF0.regs\[2\]\[23\] sky130_fd_sc_hd__dfrtp_1
X_5259_ clknet_leaf_13_clk _0635_ _0251_ VGND VGND VPWR VPWR RF0.regs\[5\]\[18\] sky130_fd_sc_hd__dfrtp_1
Xclkbuf_2_2__f_clk clknet_0_clk VGND VGND VPWR VPWR clknet_2_2__leaf_clk sky130_fd_sc_hd__clkbuf_16
XTAP_TAPCELL_ROW_26_423 VGND VPWR sky130_fd_sc_hd__tapvpwrvgnd_1
XFILLER_0_65_111 VGND VGND VPWR VPWR sky130_fd_sc_hd__fill_1
XFILLER_0_65_133 VGND VGND VPWR VPWR sky130_fd_sc_hd__decap_8
XFILLER_0_61_361 VGND VGND VPWR VPWR sky130_fd_sc_hd__decap_4
XFILLER_0_28_15 VPWR VGND VPWR VGND sky130_ef_sc_hd__decap_12
XFILLER_0_28_59 VGND VGND VPWR VPWR sky130_fd_sc_hd__fill_2
XTAP_TAPCELL_ROW_77_879 VGND VPWR sky130_fd_sc_hd__tapvpwrvgnd_1
X_2960_ _1185_ VGND VGND VPWR VPWR _0710_ sky130_fd_sc_hd__clkbuf_1
X_2891_ net142 VGND VGND VPWR VPWR _1151_ sky130_fd_sc_hd__clkbuf_1
XFILLER_0_84_475 VGND VGND VPWR VPWR sky130_fd_sc_hd__fill_1
X_4630_ _2444_ VGND VGND VPWR VPWR _0057_ sky130_fd_sc_hd__inv_2
XFILLER_0_71_125 VPWR VGND VPWR VGND sky130_ef_sc_hd__decap_12
XFILLER_0_56_177 VPWR VGND VPWR VGND sky130_ef_sc_hd__decap_12
XFILLER_0_60_57 VGND VGND VPWR VPWR sky130_fd_sc_hd__fill_1
XFILLER_0_71_169 VGND VGND VPWR VPWR sky130_fd_sc_hd__decap_8
X_4561_ _1149_ _1934_ _1935_ VGND VGND VPWR VPWR _2430_ sky130_fd_sc_hd__and3_1
XFILLER_0_4_469 VGND VGND VPWR VPWR sky130_fd_sc_hd__decap_6
X_4492_ net68 VGND VGND VPWR VPWR _0007_ sky130_fd_sc_hd__inv_2
X_3512_ _1699_ _1491_ _1704_ VGND VGND VPWR VPWR _1705_ sky130_fd_sc_hd__and3_1
X_3443_ RF0.regs\[7\]\[23\] _1244_ VGND VGND VPWR VPWR _1637_ sky130_fd_sc_hd__and2_1
X_3374_ RF0.regs\[4\]\[29\] _1241_ _1225_ RF0.regs\[20\]\[29\] _1568_ VGND VGND VPWR
+ VPWR _1569_ sky130_fd_sc_hd__a221o_1
X_5113_ clknet_leaf_3_clk _0489_ _0105_ VGND VGND VPWR VPWR RF0.regs\[12\]\[0\] sky130_fd_sc_hd__dfrtp_1
XTAP_TAPCELL_ROW_68_802 VGND VPWR sky130_fd_sc_hd__tapvpwrvgnd_1
X_5044_ clknet_leaf_1_clk _0420_ _0036_ VGND VGND VPWR VPWR RF0.regs\[25\]\[27\] sky130_fd_sc_hd__dfrtp_1
XFILLER_0_79_225 VGND VGND VPWR VPWR sky130_fd_sc_hd__decap_3
XFILLER_0_19_3 VPWR VGND VPWR VGND sky130_ef_sc_hd__decap_12
XFILLER_0_47_111 VGND VGND VPWR VPWR sky130_fd_sc_hd__fill_1
XFILLER_0_75_497 VGND VGND VPWR VPWR sky130_fd_sc_hd__decap_6
X_4828_ _2469_ VGND VGND VPWR VPWR _0230_ sky130_fd_sc_hd__inv_2
XFILLER_0_62_103 VGND VGND VPWR VPWR sky130_fd_sc_hd__fill_2
XTAP_TAPCELL_ROW_31_470 VGND VPWR sky130_fd_sc_hd__tapvpwrvgnd_1
X_4759_ _2435_ VGND VGND VPWR VPWR _2462_ sky130_fd_sc_hd__clkbuf_4
XFILLER_0_50_309 VGND VGND VPWR VPWR sky130_fd_sc_hd__decap_6
XFILLER_0_85_206 VGND VGND VPWR VPWR sky130_fd_sc_hd__decap_4
XPHY_EDGE_ROW_9_Left_97 VGND VGND VPWR VPWR sky130_fd_sc_hd__decap_3
XFILLER_0_38_111 VGND VGND VPWR VPWR sky130_fd_sc_hd__decap_8
XFILLER_0_66_475 VGND VGND VPWR VPWR sky130_fd_sc_hd__fill_1
XFILLER_0_30_27 VGND VGND VPWR VPWR sky130_fd_sc_hd__fill_1
XFILLER_0_53_169 VPWR VGND VPWR VGND sky130_ef_sc_hd__decap_12
XFILLER_0_1_417 VPWR VGND VPWR VGND sky130_ef_sc_hd__decap_12
X_3090_ _1285_ _1263_ _1281_ VGND VGND VPWR VPWR _1286_ sky130_fd_sc_hd__o21a_1
XFILLER_0_55_57 VPWR VGND VPWR VGND sky130_ef_sc_hd__decap_12
XTAP_TAPCELL_ROW_37_518 VGND VPWR sky130_fd_sc_hd__tapvpwrvgnd_1
X_3992_ _2123_ VGND VGND VPWR VPWR _0629_ sky130_fd_sc_hd__clkbuf_1
X_2943_ net117 VGND VGND VPWR VPWR _1177_ sky130_fd_sc_hd__clkbuf_1
XTAP_TAPCELL_ROW_45_595 VGND VPWR sky130_fd_sc_hd__tapvpwrvgnd_1
XFILLER_0_84_283 VGND VGND VPWR VPWR sky130_fd_sc_hd__decap_3
XFILLER_0_29_166 VGND VGND VPWR VPWR sky130_fd_sc_hd__fill_2
XFILLER_0_57_497 VGND VGND VPWR VPWR sky130_fd_sc_hd__decap_6
XFILLER_0_84_294 VGND VGND VPWR VPWR sky130_fd_sc_hd__decap_8
X_2874_ _1137_ VGND VGND VPWR VPWR _1138_ sky130_fd_sc_hd__buf_4
XFILLER_0_29_199 VGND VGND VPWR VPWR sky130_fd_sc_hd__decap_6
XFILLER_0_72_489 VPWR VGND VPWR VGND sky130_ef_sc_hd__decap_12
X_4613_ _2443_ VGND VGND VPWR VPWR _0041_ sky130_fd_sc_hd__inv_2
XFILLER_0_44_169 VGND VGND VPWR VPWR sky130_fd_sc_hd__fill_1
X_4544_ _2423_ VGND VGND VPWR VPWR net30 sky130_fd_sc_hd__clkbuf_1
XFILLER_0_4_299 VGND VGND VPWR VPWR sky130_fd_sc_hd__decap_3
X_4475_ _2376_ VGND VGND VPWR VPWR _0400_ sky130_fd_sc_hd__clkbuf_1
XFILLER_0_0_461 VPWR VGND VPWR VGND sky130_ef_sc_hd__decap_12
X_3426_ RF0.regs\[5\]\[24\] _0867_ _1224_ RF0.regs\[20\]\[24\] VGND VGND VPWR VPWR
+ _1620_ sky130_fd_sc_hd__a22o_1
X_3357_ _1013_ _1552_ VGND VGND VPWR VPWR _1553_ sky130_fd_sc_hd__xnor2_2
X_5027_ clknet_leaf_26_clk _0403_ _0019_ VGND VGND VPWR VPWR RF0.regs\[25\]\[10\]
+ sky130_fd_sc_hd__dfrtp_1
X_3288_ _1304_ _1307_ _1264_ VGND VGND VPWR VPWR _1484_ sky130_fd_sc_hd__a21oi_1
XTAP_TAPCELL_ROW_0_176 VGND VPWR sky130_fd_sc_hd__tapvpwrvgnd_1
XTAP_TAPCELL_ROW_0_187 VGND VPWR sky130_fd_sc_hd__tapvpwrvgnd_1
XFILLER_0_82_209 VPWR VGND VPWR VGND sky130_ef_sc_hd__decap_12
XFILLER_0_0_81 VGND VGND VPWR VPWR sky130_fd_sc_hd__decap_3
XFILLER_0_16_361 VGND VGND VPWR VPWR sky130_fd_sc_hd__decap_3
XFILLER_0_16_350 VGND VGND VPWR VPWR sky130_fd_sc_hd__fill_2
XFILLER_0_8_3 VPWR VGND VPWR VGND sky130_ef_sc_hd__decap_12
XTAP_TAPCELL_ROW_8_265 VGND VPWR sky130_fd_sc_hd__tapvpwrvgnd_1
XTAP_TAPCELL_ROW_87_974 VGND VPWR sky130_fd_sc_hd__tapvpwrvgnd_1
XTAP_TAPCELL_ROW_87_985 VGND VPWR sky130_fd_sc_hd__tapvpwrvgnd_1
XTAP_TAPCELL_ROW_42_565 VGND VPWR sky130_fd_sc_hd__tapvpwrvgnd_1
XFILLER_0_41_106 VGND VGND VPWR VPWR sky130_fd_sc_hd__decap_6
XFILLER_0_81_297 VGND VGND VPWR VPWR sky130_fd_sc_hd__fill_1
XFILLER_0_1_225 VPWR VGND VPWR VGND sky130_ef_sc_hd__decap_12
X_2590_ net55 net66 _0881_ VGND VGND VPWR VPWR _0882_ sky130_fd_sc_hd__and3_2
XFILLER_0_5_15 VPWR VGND VPWR VGND sky130_ef_sc_hd__decap_12
X_4260_ net158 VGND VGND VPWR VPWR _2264_ sky130_fd_sc_hd__clkbuf_1
X_4191_ RF0.regs\[10\]\[15\] _2012_ _2222_ VGND VGND VPWR VPWR _2229_ sky130_fd_sc_hd__mux2_1
X_3211_ RF0.regs\[4\]\[3\] _0834_ _0809_ RF0.regs\[10\]\[3\] VGND VGND VPWR VPWR _1407_
+ sky130_fd_sc_hd__a22o_1
X_3142_ _1261_ _1337_ VGND VGND VPWR VPWR _1338_ sky130_fd_sc_hd__or2_1
XFILLER_0_66_89 VGND VGND VPWR VPWR sky130_fd_sc_hd__fill_1
X_3073_ _1267_ _1268_ VGND VGND VPWR VPWR _1269_ sky130_fd_sc_hd__nand2_1
XFILLER_0_49_206 VGND VGND VPWR VPWR sky130_fd_sc_hd__decap_4
XFILLER_0_82_77 VGND VGND VPWR VPWR sky130_fd_sc_hd__decap_6
XPHY_EDGE_ROW_59_Left_147 VGND VGND VPWR VPWR sky130_fd_sc_hd__decap_3
X_3975_ RF0.regs\[5\]\[20\] _1996_ _2113_ VGND VGND VPWR VPWR _2115_ sky130_fd_sc_hd__mux2_1
XFILLER_0_64_209 VPWR VGND VPWR VGND sky130_ef_sc_hd__decap_12
X_2926_ _1168_ VGND VGND VPWR VPWR _0727_ sky130_fd_sc_hd__clkbuf_1
XFILLER_0_72_253 VPWR VGND VPWR VGND sky130_ef_sc_hd__decap_12
X_2857_ _1117_ net220 VGND VGND VPWR VPWR _1129_ sky130_fd_sc_hd__and2_1
XFILLER_0_60_404 VGND VGND VPWR VPWR sky130_fd_sc_hd__decap_6
XFILLER_0_86_3 VPWR VGND VPWR VGND sky130_ef_sc_hd__decap_12
XFILLER_0_32_128 VPWR VGND VPWR VGND sky130_ef_sc_hd__decap_12
Xhold210 RF0.regs\[20\]\[18\] VGND VGND VPWR VPWR net258 sky130_fd_sc_hd__dlygate4sd3_1
X_2788_ RF0.regs\[4\]\[2\] _0868_ _0880_ RF0.regs\[2\]\[2\] _1079_ VGND VGND VPWR
+ VPWR _1080_ sky130_fd_sc_hd__a221oi_2
X_4527_ _2412_ VGND VGND VPWR VPWR _2413_ sky130_fd_sc_hd__inv_2
Xhold221 RF0.regs\[6\]\[10\] VGND VGND VPWR VPWR net269 sky130_fd_sc_hd__dlygate4sd3_1
XPHY_EDGE_ROW_68_Left_156 VGND VGND VPWR VPWR sky130_fd_sc_hd__decap_3
X_4458_ _2367_ VGND VGND VPWR VPWR _0408_ sky130_fd_sc_hd__clkbuf_1
X_3409_ _1356_ _1541_ _1540_ VGND VGND VPWR VPWR _1603_ sky130_fd_sc_hd__nand3_1
X_4389_ _2331_ VGND VGND VPWR VPWR _0441_ sky130_fd_sc_hd__clkbuf_1
XTAP_TAPCELL_ROW_5_235 VGND VPWR sky130_fd_sc_hd__tapvpwrvgnd_1
XTAP_TAPCELL_ROW_84_944 VGND VPWR sky130_fd_sc_hd__tapvpwrvgnd_1
XPHY_EDGE_ROW_77_Left_165 VGND VGND VPWR VPWR sky130_fd_sc_hd__decap_3
XFILLER_0_48_272 VPWR VGND VPWR VGND sky130_ef_sc_hd__decap_12
XFILLER_0_8_380 VGND VGND VPWR VPWR sky130_fd_sc_hd__fill_2
XFILLER_0_63_286 VGND VGND VPWR VPWR sky130_fd_sc_hd__decap_4
XPHY_EDGE_ROW_86_Left_174 VGND VGND VPWR VPWR sky130_fd_sc_hd__decap_3
XFILLER_0_16_191 VGND VGND VPWR VPWR sky130_fd_sc_hd__decap_4
XFILLER_0_36_26 VGND VGND VPWR VPWR sky130_fd_sc_hd__fill_2
XTAP_TAPCELL_ROW_47_613 VGND VPWR sky130_fd_sc_hd__tapvpwrvgnd_1
XFILLER_0_86_323 VGND VGND VPWR VPWR sky130_fd_sc_hd__decap_4
XTAP_TAPCELL_ROW_19_359 VGND VPWR sky130_fd_sc_hd__tapvpwrvgnd_1
XFILLER_0_86_389 VPWR VGND VPWR VGND sky130_ef_sc_hd__decap_12
XFILLER_0_27_401 VGND VGND VPWR VPWR sky130_fd_sc_hd__fill_2
XFILLER_0_27_423 VPWR VGND VPWR VGND sky130_ef_sc_hd__decap_12
X_3760_ _1596_ _1606_ _1937_ _1942_ _1945_ VGND VGND VPWR VPWR _1946_ sky130_fd_sc_hd__o311a_1
XFILLER_0_54_253 VGND VGND VPWR VPWR sky130_fd_sc_hd__fill_1
X_2711_ RF0.regs\[4\]\[24\] _0838_ _0844_ RF0.regs\[12\]\[24\] VGND VGND VPWR VPWR
+ _1003_ sky130_fd_sc_hd__a22o_1
X_3691_ _1007_ _1869_ _1870_ _1876_ VGND VGND VPWR VPWR _1877_ sky130_fd_sc_hd__a31oi_1
XFILLER_0_2_501 VPWR VGND VPWR VGND sky130_ef_sc_hd__decap_12
X_2642_ RF0.regs\[10\]\[12\] _0883_ _0854_ RF0.regs\[15\]\[12\] VGND VGND VPWR VPWR
+ _0934_ sky130_fd_sc_hd__a22o_1
X_2573_ _0864_ VGND VGND VPWR VPWR _0865_ sky130_fd_sc_hd__buf_4
XTAP_TAPCELL_ROW_10_281 VGND VPWR sky130_fd_sc_hd__tapvpwrvgnd_1
X_5361_ clknet_leaf_7_clk _0737_ _0353_ VGND VGND VPWR VPWR RF0.regs\[0\]\[24\] sky130_fd_sc_hd__dfrtp_1
X_5292_ clknet_leaf_12_clk _0668_ _0284_ VGND VGND VPWR VPWR RF0.regs\[4\]\[19\] sky130_fd_sc_hd__dfrtp_2
X_4312_ _2291_ VGND VGND VPWR VPWR _0478_ sky130_fd_sc_hd__clkbuf_1
XFILLER_0_77_55 VGND VGND VPWR VPWR sky130_fd_sc_hd__fill_1
XFILLER_0_22_194 VGND VGND VPWR VPWR sky130_fd_sc_hd__fill_2
XFILLER_0_10_345 VGND VGND VPWR VPWR sky130_fd_sc_hd__decap_8
X_4243_ _2255_ VGND VGND VPWR VPWR _0511_ sky130_fd_sc_hd__clkbuf_1
X_4174_ RF0.regs\[10\]\[23\] _1986_ _2211_ VGND VGND VPWR VPWR _2220_ sky130_fd_sc_hd__mux2_1
XTAP_TAPCELL_ROW_2_205 VGND VPWR sky130_fd_sc_hd__tapvpwrvgnd_1
X_3125_ RF0.regs\[4\]\[23\] _0864_ _1320_ VGND VGND VPWR VPWR _1321_ sky130_fd_sc_hd__a21o_1
X_3056_ _1251_ VGND VGND VPWR VPWR _1252_ sky130_fd_sc_hd__buf_4
XTAP_TAPCELL_ROW_81_914 VGND VPWR sky130_fd_sc_hd__tapvpwrvgnd_1
XFILLER_0_26_92 VGND VGND VPWR VPWR sky130_fd_sc_hd__decap_8
XFILLER_0_18_434 VGND VGND VPWR VPWR sky130_fd_sc_hd__fill_1
X_3958_ RF0.regs\[5\]\[28\] _1965_ _2102_ VGND VGND VPWR VPWR _2106_ sky130_fd_sc_hd__mux2_1
XFILLER_0_45_253 VGND VGND VPWR VPWR sky130_fd_sc_hd__fill_1
X_2909_ net191 VGND VGND VPWR VPWR _1160_ sky130_fd_sc_hd__clkbuf_1
X_3889_ _2054_ VGND VGND VPWR VPWR _2055_ sky130_fd_sc_hd__inv_2
XFILLER_0_5_372 VGND VGND VPWR VPWR sky130_fd_sc_hd__decap_3
XFILLER_0_60_289 VGND VGND VPWR VPWR sky130_fd_sc_hd__fill_2
XFILLER_0_87_109 VGND VGND VPWR VPWR sky130_fd_sc_hd__decap_3
XTAP_TAPCELL_ROW_16_329 VGND VPWR sky130_fd_sc_hd__tapvpwrvgnd_1
XFILLER_0_28_209 VPWR VGND VPWR VGND sky130_ef_sc_hd__decap_12
XFILLER_0_68_378 VGND VGND VPWR VPWR sky130_fd_sc_hd__fill_2
XTAP_TAPCELL_ROW_52_660 VGND VPWR sky130_fd_sc_hd__tapvpwrvgnd_1
XFILLER_0_24_437 VPWR VGND VPWR VGND sky130_ef_sc_hd__decap_12
XFILLER_0_32_481 VGND VGND VPWR VPWR sky130_fd_sc_hd__fill_1
XFILLER_0_2_27 VGND VGND VPWR VPWR sky130_fd_sc_hd__fill_1
XFILLER_0_63_57 VPWR VGND VPWR VGND sky130_ef_sc_hd__decap_12
X_4930_ _2482_ VGND VGND VPWR VPWR _0319_ sky130_fd_sc_hd__inv_2
XFILLER_0_59_356 VGND VGND VPWR VPWR sky130_fd_sc_hd__fill_1
XFILLER_0_74_304 VGND VGND VPWR VPWR sky130_fd_sc_hd__decap_4
X_4861_ _2473_ VGND VGND VPWR VPWR _0259_ sky130_fd_sc_hd__inv_2
XFILLER_0_59_389 VGND VGND VPWR VPWR sky130_fd_sc_hd__decap_3
XFILLER_0_74_326 VGND VGND VPWR VPWR sky130_fd_sc_hd__decap_6
X_3812_ RF0.regs\[4\]\[22\] _1988_ _1953_ VGND VGND VPWR VPWR _1989_ sky130_fd_sc_hd__mux2_1
XFILLER_0_6_103 VGND VGND VPWR VPWR sky130_fd_sc_hd__fill_1
XFILLER_0_27_253 VGND VGND VPWR VPWR sky130_fd_sc_hd__decap_4
X_4792_ _2466_ VGND VGND VPWR VPWR _0197_ sky130_fd_sc_hd__inv_2
XFILLER_0_82_381 VGND VGND VPWR VPWR sky130_fd_sc_hd__fill_1
X_3743_ _1010_ _1669_ _1671_ _1672_ _1662_ VGND VGND VPWR VPWR _1929_ sky130_fd_sc_hd__a41o_1
XFILLER_0_6_147 VGND VGND VPWR VPWR sky130_fd_sc_hd__fill_1
XFILLER_0_12_83 VGND VGND VPWR VPWR sky130_fd_sc_hd__fill_1
X_3674_ _1007_ _1852_ _1853_ _1859_ VGND VGND VPWR VPWR _1860_ sky130_fd_sc_hd__a31o_1
X_5413_ clknet_leaf_23_clk net5 VGND VGND VPWR VPWR disp.digits\[12\] sky130_fd_sc_hd__dfxtp_1
X_2625_ RF0.regs\[4\]\[13\] _0863_ _0878_ RF0.regs\[2\]\[13\] _0916_ VGND VGND VPWR
+ VPWR _0917_ sky130_fd_sc_hd__a221o_1
X_5344_ clknet_leaf_33_clk _0720_ _0336_ VGND VGND VPWR VPWR RF0.regs\[0\]\[7\] sky130_fd_sc_hd__dfrtp_1
X_2556_ IM0.addr\[1\] _0820_ _0819_ VGND VGND VPWR VPWR _0848_ sky130_fd_sc_hd__a21o_1
X_5275_ clknet_leaf_35_clk _0651_ _0267_ VGND VGND VPWR VPWR RF0.regs\[4\]\[2\] sky130_fd_sc_hd__dfrtp_2
X_4226_ net178 VGND VGND VPWR VPWR _2247_ sky130_fd_sc_hd__clkbuf_1
X_4157_ _0909_ VGND VGND VPWR VPWR _2211_ sky130_fd_sc_hd__clkbuf_4
XTAP_TAPCELL_ROW_58_708 VGND VPWR sky130_fd_sc_hd__tapvpwrvgnd_1
X_3108_ _1303_ _1302_ _1300_ VGND VGND VPWR VPWR _1304_ sky130_fd_sc_hd__nor3_4
X_4088_ _2174_ _2175_ _0799_ VGND VGND VPWR VPWR net2 sky130_fd_sc_hd__a21oi_2
XFILLER_0_77_120 VGND VGND VPWR VPWR sky130_fd_sc_hd__fill_1
X_3039_ RF0.regs\[20\]\[31\] _1225_ _1229_ RF0.regs\[15\]\[31\] _1234_ VGND VGND VPWR
+ VPWR _1235_ sky130_fd_sc_hd__a221o_1
XTAP_TAPCELL_ROW_66_785 VGND VPWR sky130_fd_sc_hd__tapvpwrvgnd_1
XFILLER_0_65_337 VGND VGND VPWR VPWR sky130_fd_sc_hd__fill_2
XFILLER_0_80_307 VGND VGND VPWR VPWR sky130_fd_sc_hd__fill_1
XFILLER_0_33_212 VPWR VGND VPWR VGND sky130_ef_sc_hd__decap_12
XTAP_TAPCELL_ROW_21_376 VGND VPWR sky130_fd_sc_hd__tapvpwrvgnd_1
XFILLER_0_33_234 VGND VGND VPWR VPWR sky130_fd_sc_hd__decap_6
XFILLER_0_14_470 VGND VGND VPWR VPWR sky130_fd_sc_hd__decap_6
XFILLER_0_17_39 VPWR VGND VPWR VGND sky130_ef_sc_hd__decap_12
XTAP_TAPCELL_ROW_29_454 VGND VPWR sky130_fd_sc_hd__tapvpwrvgnd_1
XFILLER_0_68_153 VGND VGND VPWR VPWR sky130_fd_sc_hd__decap_4
XFILLER_0_68_197 VPWR VGND VPWR VGND sky130_ef_sc_hd__decap_12
XFILLER_0_83_167 VGND VGND VPWR VPWR sky130_fd_sc_hd__fill_1
XFILLER_0_24_256 VGND VGND VPWR VPWR sky130_fd_sc_hd__fill_1
XFILLER_0_24_289 VPWR VGND VPWR VGND sky130_ef_sc_hd__decap_12
X_3390_ net22 _1583_ VGND VGND VPWR VPWR _1584_ sky130_fd_sc_hd__or2_1
X_5060_ clknet_leaf_23_clk _0436_ _0052_ VGND VGND VPWR VPWR RF0.regs\[20\]\[11\]
+ sky130_fd_sc_hd__dfrtp_1
X_4011_ _2133_ VGND VGND VPWR VPWR _0620_ sky130_fd_sc_hd__clkbuf_1
XFILLER_0_87_473 VGND VGND VPWR VPWR sky130_fd_sc_hd__decap_3
X_4913_ _2479_ VGND VGND VPWR VPWR _0305_ sky130_fd_sc_hd__inv_2
XTAP_TAPCELL_ROW_63_755 VGND VPWR sky130_fd_sc_hd__tapvpwrvgnd_1
XFILLER_0_47_359 VGND VGND VPWR VPWR sky130_fd_sc_hd__fill_1
X_4844_ _2472_ VGND VGND VPWR VPWR _0243_ sky130_fd_sc_hd__inv_2
XFILLER_0_62_307 VGND VGND VPWR VPWR sky130_fd_sc_hd__fill_1
X_4775_ _2465_ VGND VGND VPWR VPWR _0181_ sky130_fd_sc_hd__inv_2
XFILLER_0_23_93 VPWR VGND VPWR VGND sky130_ef_sc_hd__decap_12
X_3726_ _1812_ net33 _1823_ _1909_ _1911_ VGND VGND VPWR VPWR _1912_ sky130_fd_sc_hd__a221oi_2
X_3657_ _1390_ _1413_ _1391_ VGND VGND VPWR VPWR _1843_ sky130_fd_sc_hd__a21boi_1
X_2608_ RF0.regs\[10\]\[18\] _0817_ _0830_ RF0.regs\[25\]\[18\] _0899_ VGND VGND VPWR
+ VPWR _0900_ sky130_fd_sc_hd__a221o_1
X_3588_ _1775_ _1778_ VGND VGND VPWR VPWR _1779_ sky130_fd_sc_hd__or2_1
X_2539_ _0800_ _0796_ _0802_ VGND VGND VPWR VPWR _0831_ sky130_fd_sc_hd__a21o_1
X_5327_ clknet_leaf_3_clk _0703_ _0319_ VGND VGND VPWR VPWR RF0.regs\[2\]\[22\] sky130_fd_sc_hd__dfrtp_1
X_5258_ clknet_leaf_17_clk _0634_ _0250_ VGND VGND VPWR VPWR RF0.regs\[5\]\[17\] sky130_fd_sc_hd__dfrtp_1
X_5189_ clknet_leaf_22_clk _0565_ _0181_ VGND VGND VPWR VPWR RF0.regs\[7\]\[12\] sky130_fd_sc_hd__dfrtp_1
X_4209_ _2238_ VGND VGND VPWR VPWR _0528_ sky130_fd_sc_hd__clkbuf_1
XFILLER_0_3_81 VGND VGND VPWR VPWR sky130_fd_sc_hd__decap_8
XTAP_TAPCELL_ROW_26_424 VGND VPWR sky130_fd_sc_hd__tapvpwrvgnd_1
XFILLER_0_65_156 VGND VGND VPWR VPWR sky130_fd_sc_hd__fill_1
XFILLER_0_65_167 VGND VGND VPWR VPWR sky130_fd_sc_hd__fill_1
XFILLER_0_65_178 VGND VGND VPWR VPWR sky130_fd_sc_hd__fill_1
XFILLER_0_0_109 VGND VGND VPWR VPWR sky130_fd_sc_hd__decap_3
XFILLER_0_28_27 VGND VGND VPWR VPWR sky130_fd_sc_hd__fill_1
XFILLER_0_84_421 VPWR VGND VPWR VGND sky130_ef_sc_hd__decap_12
XFILLER_0_8_209 VGND VGND VPWR VPWR sky130_fd_sc_hd__fill_2
X_2890_ net1 net67 _1150_ VGND VGND VPWR VPWR _0745_ sky130_fd_sc_hd__a21oi_1
XTAP_TAPCELL_ROW_60_725 VGND VPWR sky130_fd_sc_hd__tapvpwrvgnd_1
XFILLER_0_44_307 VGND VGND VPWR VPWR sky130_fd_sc_hd__fill_1
XFILLER_0_56_189 VGND VGND VPWR VPWR sky130_fd_sc_hd__decap_6
XFILLER_0_71_137 VPWR VGND VPWR VGND sky130_ef_sc_hd__decap_12
XFILLER_0_37_381 VGND VGND VPWR VPWR sky130_fd_sc_hd__fill_1
X_4560_ _2429_ VGND VGND VPWR VPWR net18 sky130_fd_sc_hd__buf_1
XFILLER_0_8_15 VPWR VGND VPWR VGND sky130_ef_sc_hd__decap_12
X_4491_ _2384_ VGND VGND VPWR VPWR _0777_ sky130_fd_sc_hd__inv_2
X_3511_ _1475_ _1702_ _1703_ _1683_ VGND VGND VPWR VPWR _1704_ sky130_fd_sc_hd__o211ai_2
X_3442_ RF0.regs\[6\]\[23\] _1233_ _1228_ RF0.regs\[15\]\[23\] _1635_ VGND VGND VPWR
+ VPWR _1636_ sky130_fd_sc_hd__a221o_1
XFILLER_0_69_67 VGND VGND VPWR VPWR sky130_fd_sc_hd__fill_1
XPHY_EDGE_ROW_31_Left_119 VGND VGND VPWR VPWR sky130_fd_sc_hd__decap_3
X_3373_ RF0.regs\[10\]\[29\] _0909_ _0816_ RF0.regs\[25\]\[29\] _1247_ VGND VGND VPWR
+ VPWR _1568_ sky130_fd_sc_hd__a221o_1
X_5112_ clknet_leaf_0_clk _0488_ _0104_ VGND VGND VPWR VPWR RF0.regs\[15\]\[31\] sky130_fd_sc_hd__dfrtp_1
XFILLER_0_85_55 VGND VGND VPWR VPWR sky130_fd_sc_hd__fill_1
XTAP_TAPCELL_ROW_68_803 VGND VPWR sky130_fd_sc_hd__tapvpwrvgnd_1
X_5043_ clknet_leaf_6_clk _0419_ _0035_ VGND VGND VPWR VPWR RF0.regs\[25\]\[26\] sky130_fd_sc_hd__dfrtp_1
XPHY_EDGE_ROW_40_Left_128 VGND VGND VPWR VPWR sky130_fd_sc_hd__decap_3
XFILLER_0_47_101 VGND VGND VPWR VPWR sky130_fd_sc_hd__fill_2
Xclone17 _0824_ VGND VGND VPWR VPWR net65 sky130_fd_sc_hd__buf_2
X_4827_ _2469_ VGND VGND VPWR VPWR _0229_ sky130_fd_sc_hd__inv_2
XTAP_TAPCELL_ROW_31_471 VGND VPWR sky130_fd_sc_hd__tapvpwrvgnd_1
X_4758_ _2461_ VGND VGND VPWR VPWR _0168_ sky130_fd_sc_hd__inv_2
X_3709_ _1007_ _1869_ _1870_ _1876_ VGND VGND VPWR VPWR _1895_ sky130_fd_sc_hd__and4_1
X_4689_ _2451_ VGND VGND VPWR VPWR _2454_ sky130_fd_sc_hd__buf_4
XFILLER_0_14_29 VPWR VGND VPWR VGND sky130_ef_sc_hd__decap_12
XFILLER_0_66_410 VGND VGND VPWR VPWR sky130_fd_sc_hd__fill_2
XFILLER_0_26_307 VGND VGND VPWR VPWR sky130_fd_sc_hd__fill_1
XFILLER_0_81_446 VGND VGND VPWR VPWR sky130_fd_sc_hd__fill_2
XFILLER_0_1_429 VPWR VGND VPWR VGND sky130_ef_sc_hd__decap_12
XFILLER_0_39_15 VGND VGND VPWR VPWR sky130_fd_sc_hd__decap_4
XFILLER_0_55_69 VGND VGND VPWR VPWR sky130_fd_sc_hd__fill_1
XTAP_TAPCELL_ROW_37_519 VGND VPWR sky130_fd_sc_hd__tapvpwrvgnd_1
XTAP_TAPCELL_ROW_73_850 VGND VPWR sky130_fd_sc_hd__tapvpwrvgnd_1
XFILLER_0_69_281 VGND VGND VPWR VPWR sky130_fd_sc_hd__fill_2
X_3991_ RF0.regs\[5\]\[12\] _2069_ _2113_ VGND VGND VPWR VPWR _2123_ sky130_fd_sc_hd__mux2_1
XFILLER_0_71_68 VGND VGND VPWR VPWR sky130_fd_sc_hd__decap_4
X_2942_ _1176_ VGND VGND VPWR VPWR _0719_ sky130_fd_sc_hd__clkbuf_1
XTAP_TAPCELL_ROW_45_596 VGND VPWR sky130_fd_sc_hd__tapvpwrvgnd_1
XFILLER_0_57_432 VGND VGND VPWR VPWR sky130_fd_sc_hd__decap_3
XFILLER_0_17_318 VGND VGND VPWR VPWR sky130_fd_sc_hd__fill_1
X_2873_ _0833_ _0831_ VGND VGND VPWR VPWR _1137_ sky130_fd_sc_hd__and2_1
XFILLER_0_13_502 VGND VGND VPWR VPWR sky130_fd_sc_hd__fill_2
X_4612_ _2442_ VGND VGND VPWR VPWR _2443_ sky130_fd_sc_hd__buf_4
XFILLER_0_25_362 VGND VGND VPWR VPWR sky130_fd_sc_hd__decap_4
X_4543_ _1148_ _1427_ _1840_ VGND VGND VPWR VPWR _2423_ sky130_fd_sc_hd__and3_1
X_4474_ RF0.regs\[25\]\[7\] _2086_ _2371_ VGND VGND VPWR VPWR _2376_ sky130_fd_sc_hd__mux2_1
XFILLER_0_40_365 VGND VGND VPWR VPWR sky130_fd_sc_hd__fill_2
XFILLER_0_0_473 VGND VGND VPWR VPWR sky130_fd_sc_hd__decap_3
X_3425_ _1596_ _1597_ _1606_ _1618_ VGND VGND VPWR VPWR _1619_ sky130_fd_sc_hd__or4_1
X_3356_ _1258_ _1551_ _1225_ VGND VGND VPWR VPWR _1552_ sky130_fd_sc_hd__a21o_1
X_3287_ _1304_ _1307_ VGND VGND VPWR VPWR _1483_ sky130_fd_sc_hd__or2_1
XFILLER_0_31_3 VGND VGND VPWR VPWR sky130_fd_sc_hd__decap_8
X_5026_ clknet_leaf_27_clk _0402_ _0018_ VGND VGND VPWR VPWR RF0.regs\[25\]\[9\] sky130_fd_sc_hd__dfrtp_1
XTAP_TAPCELL_ROW_0_177 VGND VPWR sky130_fd_sc_hd__tapvpwrvgnd_1
XTAP_TAPCELL_ROW_0_188 VGND VPWR sky130_fd_sc_hd__tapvpwrvgnd_1
XFILLER_0_48_410 VGND VGND VPWR VPWR sky130_fd_sc_hd__fill_1
XFILLER_0_48_487 VGND VGND VPWR VPWR sky130_fd_sc_hd__decap_8
XFILLER_0_35_137 VGND VGND VPWR VPWR sky130_fd_sc_hd__decap_8
XFILLER_0_16_373 VGND VGND VPWR VPWR sky130_fd_sc_hd__decap_3
XTAP_TAPCELL_ROW_87_975 VGND VPWR sky130_fd_sc_hd__tapvpwrvgnd_1
XTAP_TAPCELL_ROW_70_820 VGND VPWR sky130_fd_sc_hd__tapvpwrvgnd_1
XFILLER_0_39_443 VGND VGND VPWR VPWR sky130_fd_sc_hd__fill_2
XFILLER_0_66_262 VPWR VGND VPWR VGND sky130_ef_sc_hd__decap_12
XTAP_TAPCELL_ROW_42_566 VGND VPWR sky130_fd_sc_hd__tapvpwrvgnd_1
XFILLER_0_54_424 VPWR VGND VPWR VGND sky130_ef_sc_hd__decap_12
XFILLER_0_81_254 VGND VGND VPWR VPWR sky130_fd_sc_hd__fill_2
XFILLER_0_34_192 VGND VGND VPWR VPWR sky130_fd_sc_hd__decap_4
XFILLER_0_10_516 VGND VGND VPWR VPWR sky130_fd_sc_hd__fill_1
XFILLER_0_1_237 VGND VGND VPWR VPWR sky130_fd_sc_hd__decap_8
XFILLER_0_5_27 VPWR VGND VPWR VGND sky130_ef_sc_hd__decap_12
X_4190_ _2228_ VGND VGND VPWR VPWR _0537_ sky130_fd_sc_hd__clkbuf_1
X_3210_ _1400_ _1404_ _1405_ VGND VGND VPWR VPWR _1406_ sky130_fd_sc_hd__a21o_1
X_3141_ _1335_ _1336_ VGND VGND VPWR VPWR _1337_ sky130_fd_sc_hd__and2_1
X_3072_ _1257_ _0917_ VGND VGND VPWR VPWR _1268_ sky130_fd_sc_hd__nand2_1
XFILLER_0_77_505 VPWR VGND VPWR VGND sky130_ef_sc_hd__decap_12
XFILLER_0_82_89 VGND VGND VPWR VPWR sky130_fd_sc_hd__fill_1
X_3974_ _2114_ VGND VGND VPWR VPWR _0638_ sky130_fd_sc_hd__clkbuf_1
XFILLER_0_15_94 VGND VGND VPWR VPWR sky130_fd_sc_hd__fill_1
XFILLER_0_9_337 VGND VGND VPWR VPWR sky130_fd_sc_hd__decap_8
XFILLER_0_72_221 VGND VGND VPWR VPWR sky130_fd_sc_hd__decap_6
X_2925_ net102 VGND VGND VPWR VPWR _1168_ sky130_fd_sc_hd__clkbuf_1
XFILLER_0_45_446 VGND VGND VPWR VPWR sky130_fd_sc_hd__fill_2
X_2856_ _1128_ VGND VGND VPWR VPWR _0757_ sky130_fd_sc_hd__clkbuf_1
XFILLER_0_31_60 VGND VGND VPWR VPWR sky130_fd_sc_hd__decap_4
XFILLER_0_31_93 VGND VGND VPWR VPWR sky130_fd_sc_hd__fill_1
XFILLER_0_60_427 VGND VGND VPWR VPWR sky130_fd_sc_hd__fill_1
XFILLER_0_79_3 VPWR VGND VPWR VGND sky130_ef_sc_hd__decap_12
Xhold211 RF0.regs\[6\]\[6\] VGND VGND VPWR VPWR net259 sky130_fd_sc_hd__dlygate4sd3_1
XFILLER_0_13_321 VPWR VGND VPWR VGND sky130_ef_sc_hd__decap_12
X_2787_ RF0.regs\[5\]\[2\] _0876_ _0856_ RF0.regs\[15\]\[2\] _1078_ VGND VGND VPWR
+ VPWR _1079_ sky130_fd_sc_hd__a221o_1
Xhold200 RF0.regs\[6\]\[7\] VGND VGND VPWR VPWR net248 sky130_fd_sc_hd__dlygate4sd3_1
X_4526_ _2394_ _2397_ VGND VGND VPWR VPWR _2412_ sky130_fd_sc_hd__nor2_1
Xhold222 RF0.regs\[2\]\[9\] VGND VGND VPWR VPWR net270 sky130_fd_sc_hd__dlygate4sd3_1
X_4457_ RF0.regs\[25\]\[15\] _2012_ _2360_ VGND VGND VPWR VPWR _2367_ sky130_fd_sc_hd__mux2_1
XFILLER_0_0_281 VPWR VGND VPWR VGND sky130_ef_sc_hd__decap_12
X_3408_ RF0.regs\[0\]\[26\] _1219_ _1599_ _1601_ VGND VGND VPWR VPWR _1602_ sky130_fd_sc_hd__o22a_1
X_4388_ net195 _2008_ _2325_ VGND VGND VPWR VPWR _2331_ sky130_fd_sc_hd__mux2_1
XTAP_TAPCELL_ROW_5_236 VGND VPWR sky130_fd_sc_hd__tapvpwrvgnd_1
X_3339_ _1223_ _1327_ VGND VGND VPWR VPWR _1535_ sky130_fd_sc_hd__nor2_1
XTAP_TAPCELL_ROW_84_945 VGND VPWR sky130_fd_sc_hd__tapvpwrvgnd_1
X_5009_ _2436_ VGND VGND VPWR VPWR _0392_ sky130_fd_sc_hd__inv_2
XFILLER_0_36_424 VGND VGND VPWR VPWR sky130_fd_sc_hd__decap_6
XFILLER_0_48_284 VGND VGND VPWR VPWR sky130_fd_sc_hd__decap_6
XFILLER_0_63_221 VGND VGND VPWR VPWR sky130_fd_sc_hd__decap_3
XFILLER_0_51_427 VGND VGND VPWR VPWR sky130_fd_sc_hd__fill_1
XFILLER_0_63_276 VGND VGND VPWR VPWR sky130_fd_sc_hd__decap_4
XFILLER_0_36_49 VGND VGND VPWR VPWR sky130_fd_sc_hd__fill_2
XTAP_TAPCELL_ROW_47_614 VGND VPWR sky130_fd_sc_hd__tapvpwrvgnd_1
XFILLER_0_59_505 VPWR VGND VPWR VGND sky130_ef_sc_hd__decap_12
XTAP_TAPCELL_ROW_55_680 VGND VPWR sky130_fd_sc_hd__tapvpwrvgnd_1
XFILLER_0_27_435 VPWR VGND VPWR VGND sky130_ef_sc_hd__decap_12
XFILLER_0_54_210 VGND VGND VPWR VPWR sky130_fd_sc_hd__fill_1
X_2710_ RF0.regs\[5\]\[24\] _0875_ _1000_ _1001_ VGND VGND VPWR VPWR _1002_ sky130_fd_sc_hd__a211oi_2
X_3690_ _1872_ _1873_ _1875_ _1216_ RF0.regs\[0\]\[2\] VGND VGND VPWR VPWR _1876_
+ sky130_fd_sc_hd__o32a_1
XFILLER_0_54_287 VGND VGND VPWR VPWR sky130_fd_sc_hd__fill_1
XFILLER_0_2_513 VGND VGND VPWR VPWR sky130_fd_sc_hd__decap_4
XFILLER_0_42_449 VGND VGND VPWR VPWR sky130_fd_sc_hd__fill_2
X_2641_ RF0.regs\[5\]\[12\] _0874_ _0863_ RF0.regs\[4\]\[12\] VGND VGND VPWR VPWR
+ _0933_ sky130_fd_sc_hd__a22o_1
X_5360_ clknet_leaf_10_clk _0736_ _0352_ VGND VGND VPWR VPWR RF0.regs\[0\]\[23\] sky130_fd_sc_hd__dfrtp_1
X_2572_ _0863_ VGND VGND VPWR VPWR _0864_ sky130_fd_sc_hd__buf_4
XTAP_TAPCELL_ROW_10_282 VGND VPWR sky130_fd_sc_hd__tapvpwrvgnd_1
XFILLER_0_22_151 VGND VGND VPWR VPWR sky130_fd_sc_hd__decap_3
X_5291_ clknet_leaf_12_clk _0667_ _0283_ VGND VGND VPWR VPWR RF0.regs\[4\]\[18\] sky130_fd_sc_hd__dfrtp_4
X_4311_ RF0.regs\[15\]\[21\] _1992_ _2290_ VGND VGND VPWR VPWR _2291_ sky130_fd_sc_hd__mux2_1
X_4242_ RF0.regs\[12\]\[22\] VGND VGND VPWR VPWR _2255_ sky130_fd_sc_hd__clkbuf_1
X_4173_ _2219_ VGND VGND VPWR VPWR _0545_ sky130_fd_sc_hd__clkbuf_1
XTAP_TAPCELL_ROW_2_206 VGND VPWR sky130_fd_sc_hd__tapvpwrvgnd_1
X_3124_ RF0.regs\[2\]\[23\] _1238_ _1270_ RF0.regs\[15\]\[23\] VGND VGND VPWR VPWR
+ _1320_ sky130_fd_sc_hd__a22o_1
X_3055_ _0804_ _0825_ VGND VGND VPWR VPWR _1251_ sky130_fd_sc_hd__nor2_1
XTAP_TAPCELL_ROW_81_915 VGND VPWR sky130_fd_sc_hd__tapvpwrvgnd_1
XFILLER_0_77_313 VGND VGND VPWR VPWR sky130_fd_sc_hd__decap_3
XFILLER_0_9_101 VGND VGND VPWR VPWR sky130_fd_sc_hd__fill_1
XFILLER_0_9_167 VGND VGND VPWR VPWR sky130_fd_sc_hd__fill_1
X_3957_ _2105_ VGND VGND VPWR VPWR _0646_ sky130_fd_sc_hd__clkbuf_1
X_2908_ _1159_ VGND VGND VPWR VPWR _0736_ sky130_fd_sc_hd__clkbuf_1
XFILLER_0_45_232 VGND VGND VPWR VPWR sky130_fd_sc_hd__decap_8
X_3888_ _1820_ net32 VGND VGND VPWR VPWR _2054_ sky130_fd_sc_hd__and2_1
XFILLER_0_60_202 VPWR VGND VPWR VGND sky130_ef_sc_hd__decap_12
X_2839_ _1118_ net182 VGND VGND VPWR VPWR _1120_ sky130_fd_sc_hd__and2_1
XFILLER_0_5_362 VGND VGND VPWR VPWR sky130_fd_sc_hd__decap_6
XFILLER_0_33_449 VGND VGND VPWR VPWR sky130_fd_sc_hd__fill_1
X_4509_ _2394_ _2397_ VGND VGND VPWR VPWR _2398_ sky130_fd_sc_hd__nand2_1
Xclkbuf_leaf_38_clk clknet_2_2__leaf_clk VGND VGND VPWR VPWR clknet_leaf_38_clk sky130_fd_sc_hd__clkbuf_8
XFILLER_0_68_346 VGND VGND VPWR VPWR sky130_fd_sc_hd__decap_8
XFILLER_0_83_349 VGND VGND VPWR VPWR sky130_fd_sc_hd__decap_8
XFILLER_0_22_29 VPWR VGND VPWR VGND sky130_ef_sc_hd__decap_12
XTAP_TAPCELL_ROW_52_661 VGND VPWR sky130_fd_sc_hd__tapvpwrvgnd_1
XFILLER_0_76_390 VGND VGND VPWR VPWR sky130_fd_sc_hd__decap_6
XFILLER_0_24_449 VGND VGND VPWR VPWR sky130_fd_sc_hd__fill_2
XFILLER_0_47_15 VGND VGND VPWR VPWR sky130_fd_sc_hd__fill_2
XFILLER_0_47_37 VGND VGND VPWR VPWR sky130_fd_sc_hd__fill_1
Xclkbuf_leaf_29_clk clknet_2_2__leaf_clk VGND VGND VPWR VPWR clknet_leaf_29_clk sky130_fd_sc_hd__clkbuf_8
XFILLER_0_86_121 VPWR VGND VPWR VGND sky130_ef_sc_hd__decap_12
XFILLER_0_59_335 VGND VGND VPWR VPWR sky130_fd_sc_hd__fill_1
XFILLER_0_63_69 VGND VGND VPWR VPWR sky130_fd_sc_hd__decap_4
X_4860_ _2473_ VGND VGND VPWR VPWR _0258_ sky130_fd_sc_hd__inv_2
X_3811_ _1650_ _1984_ VGND VGND VPWR VPWR _1988_ sky130_fd_sc_hd__xor2_2
X_4791_ _2466_ VGND VGND VPWR VPWR _0196_ sky130_fd_sc_hd__inv_2
X_3742_ _1691_ _1721_ net45 _1927_ VGND VGND VPWR VPWR _1928_ sky130_fd_sc_hd__a31oi_4
X_3673_ _1855_ _1856_ _1858_ _1216_ RF0.regs\[0\]\[4\] VGND VGND VPWR VPWR _1859_
+ sky130_fd_sc_hd__o32a_1
X_2624_ RF0.regs\[5\]\[13\] _0874_ _0853_ RF0.regs\[15\]\[13\] _0915_ VGND VGND VPWR
+ VPWR _0916_ sky130_fd_sc_hd__a221o_1
XFILLER_0_42_268 VGND VGND VPWR VPWR sky130_fd_sc_hd__fill_2
XFILLER_0_42_279 VGND VGND VPWR VPWR sky130_fd_sc_hd__fill_1
X_5412_ clknet_leaf_23_clk net4 VGND VGND VPWR VPWR disp.digits\[11\] sky130_fd_sc_hd__dfxtp_1
X_5343_ clknet_leaf_33_clk _0719_ _0335_ VGND VGND VPWR VPWR RF0.regs\[0\]\[6\] sky130_fd_sc_hd__dfrtp_1
XFILLER_0_2_365 VPWR VGND VPWR VGND sky130_ef_sc_hd__decap_12
X_2555_ RF0.regs\[10\]\[30\] _0817_ _0830_ RF0.regs\[25\]\[30\] _0846_ VGND VGND VPWR
+ VPWR _0847_ sky130_fd_sc_hd__a221oi_2
X_5274_ clknet_leaf_38_clk _0650_ _0266_ VGND VGND VPWR VPWR RF0.regs\[4\]\[1\] sky130_fd_sc_hd__dfrtp_1
X_4225_ _2246_ VGND VGND VPWR VPWR _0520_ sky130_fd_sc_hd__clkbuf_1
X_4156_ _2210_ VGND VGND VPWR VPWR _0553_ sky130_fd_sc_hd__clkbuf_1
XTAP_TAPCELL_ROW_58_709 VGND VPWR sky130_fd_sc_hd__tapvpwrvgnd_1
X_3107_ _1264_ _0993_ VGND VGND VPWR VPWR _1303_ sky130_fd_sc_hd__nor2_1
X_4087_ _2173_ _1393_ VGND VGND VPWR VPWR _2175_ sky130_fd_sc_hd__nand2_1
X_3038_ RF0.regs\[5\]\[31\] _0868_ _1233_ RF0.regs\[6\]\[31\] VGND VGND VPWR VPWR
+ _1234_ sky130_fd_sc_hd__a22o_1
XTAP_TAPCELL_ROW_66_786 VGND VPWR sky130_fd_sc_hd__tapvpwrvgnd_1
XFILLER_0_65_305 VGND VGND VPWR VPWR sky130_fd_sc_hd__decap_8
XFILLER_0_18_210 VGND VGND VPWR VPWR sky130_fd_sc_hd__decap_4
X_4989_ _2487_ VGND VGND VPWR VPWR _0373_ sky130_fd_sc_hd__inv_2
XFILLER_0_73_371 VPWR VGND VPWR VGND sky130_ef_sc_hd__decap_12
XFILLER_0_73_393 VPWR VGND VPWR VGND sky130_ef_sc_hd__decap_12
XTAP_TAPCELL_ROW_21_377 VGND VPWR sky130_fd_sc_hd__tapvpwrvgnd_1
XFILLER_0_21_408 VGND VGND VPWR VPWR sky130_fd_sc_hd__decap_6
XFILLER_0_33_279 VGND VGND VPWR VPWR sky130_fd_sc_hd__fill_1
XFILLER_0_83_113 VGND VGND VPWR VPWR sky130_fd_sc_hd__fill_2
XTAP_TAPCELL_ROW_12_300 VGND VPWR sky130_fd_sc_hd__tapvpwrvgnd_1
XFILLER_0_20_441 VGND VGND VPWR VPWR sky130_fd_sc_hd__fill_2
X_4010_ RF0.regs\[5\]\[3\] _2094_ _2124_ VGND VGND VPWR VPWR _2133_ sky130_fd_sc_hd__mux2_1
X_4912_ _2479_ VGND VGND VPWR VPWR _0304_ sky130_fd_sc_hd__inv_2
XTAP_TAPCELL_ROW_63_756 VGND VPWR sky130_fd_sc_hd__tapvpwrvgnd_1
XFILLER_0_7_424 VGND VGND VPWR VPWR sky130_fd_sc_hd__decap_4
XFILLER_0_7_402 VGND VGND VPWR VPWR sky130_fd_sc_hd__fill_2
X_4843_ _2472_ VGND VGND VPWR VPWR _0242_ sky130_fd_sc_hd__inv_2
X_4774_ _2462_ VGND VGND VPWR VPWR _2465_ sky130_fd_sc_hd__buf_4
XFILLER_0_7_457 VPWR VGND VPWR VGND sky130_ef_sc_hd__decap_12
X_3725_ _1910_ VGND VGND VPWR VPWR _1911_ sky130_fd_sc_hd__inv_2
XFILLER_0_55_393 VPWR VGND VPWR VGND sky130_ef_sc_hd__decap_12
Xclkbuf_leaf_9_clk clknet_2_1__leaf_clk VGND VGND VPWR VPWR clknet_leaf_9_clk sky130_fd_sc_hd__clkbuf_8
XFILLER_0_70_363 VGND VGND VPWR VPWR sky130_fd_sc_hd__fill_1
XFILLER_0_70_385 VPWR VGND VPWR VGND sky130_ef_sc_hd__decap_12
XFILLER_0_70_374 VGND VGND VPWR VPWR sky130_fd_sc_hd__decap_3
X_3656_ _1839_ _1841_ VGND VGND VPWR VPWR _1842_ sky130_fd_sc_hd__xnor2_4
X_2607_ RF0.regs\[4\]\[18\] _0839_ _0845_ RF0.regs\[12\]\[18\] VGND VGND VPWR VPWR
+ _0899_ sky130_fd_sc_hd__a22o_1
X_3587_ _1008_ _1776_ _1777_ VGND VGND VPWR VPWR _1778_ sky130_fd_sc_hd__and3_1
XFILLER_0_61_3 VGND VGND VPWR VPWR sky130_fd_sc_hd__decap_6
X_2538_ _0829_ VGND VGND VPWR VPWR _0830_ sky130_fd_sc_hd__buf_4
X_5326_ clknet_leaf_4_clk _0702_ _0318_ VGND VGND VPWR VPWR RF0.regs\[2\]\[21\] sky130_fd_sc_hd__dfrtp_1
X_5257_ clknet_leaf_19_clk _0633_ _0249_ VGND VGND VPWR VPWR RF0.regs\[5\]\[16\] sky130_fd_sc_hd__dfrtp_1
X_4208_ RF0.regs\[10\]\[7\] _2086_ _2233_ VGND VGND VPWR VPWR _2238_ sky130_fd_sc_hd__mux2_1
X_5188_ clknet_leaf_23_clk _0564_ _0180_ VGND VGND VPWR VPWR RF0.regs\[7\]\[11\] sky130_fd_sc_hd__dfrtp_1
X_4139_ net81 VGND VGND VPWR VPWR _2202_ sky130_fd_sc_hd__clkbuf_1
XTAP_TAPCELL_ROW_26_425 VGND VPWR sky130_fd_sc_hd__tapvpwrvgnd_1
XFILLER_0_38_316 VPWR VGND VPWR VGND sky130_ef_sc_hd__decap_12
XTAP_TAPCELL_ROW_34_491 VGND VPWR sky130_fd_sc_hd__tapvpwrvgnd_1
XFILLER_0_46_393 VGND VGND VPWR VPWR sky130_fd_sc_hd__fill_1
XFILLER_0_61_352 VGND VGND VPWR VPWR sky130_fd_sc_hd__fill_1
XFILLER_0_61_374 VPWR VGND VPWR VGND sky130_ef_sc_hd__decap_12
XFILLER_0_21_238 VGND VGND VPWR VPWR sky130_fd_sc_hd__fill_1
XFILLER_0_44_27 VGND VGND VPWR VPWR sky130_fd_sc_hd__fill_1
XFILLER_0_84_433 VPWR VGND VPWR VGND sky130_ef_sc_hd__decap_12
XTAP_TAPCELL_ROW_60_726 VGND VPWR sky130_fd_sc_hd__tapvpwrvgnd_1
XFILLER_0_84_477 VPWR VGND VPWR VGND sky130_ef_sc_hd__decap_12
XFILLER_0_71_149 VGND VGND VPWR VPWR sky130_fd_sc_hd__fill_2
XFILLER_0_37_393 VGND VGND VPWR VPWR sky130_fd_sc_hd__fill_2
XFILLER_0_8_27 VGND VGND VPWR VPWR sky130_fd_sc_hd__fill_1
XFILLER_0_52_363 VGND VGND VPWR VPWR sky130_fd_sc_hd__fill_1
X_3510_ _1490_ _1491_ VGND VGND VPWR VPWR _1703_ sky130_fd_sc_hd__and2_1
XFILLER_0_69_57 VGND VGND VPWR VPWR sky130_fd_sc_hd__fill_1
X_4490_ net277 disp.digit_select\[1\] VGND VGND VPWR VPWR _2384_ sky130_fd_sc_hd__nor2_1
X_3441_ RF0.regs\[4\]\[23\] _1240_ VGND VGND VPWR VPWR _1635_ sky130_fd_sc_hd__and2_1
XFILLER_0_20_260 VPWR VGND VPWR VGND sky130_ef_sc_hd__decap_12
X_3372_ RF0.regs\[7\]\[29\] _1245_ VGND VGND VPWR VPWR _1567_ sky130_fd_sc_hd__and2_1
X_5111_ clknet_leaf_2_clk _0487_ _0103_ VGND VGND VPWR VPWR RF0.regs\[15\]\[30\] sky130_fd_sc_hd__dfrtp_1
XTAP_TAPCELL_ROW_68_804 VGND VPWR sky130_fd_sc_hd__tapvpwrvgnd_1
XFILLER_0_18_61 VGND VGND VPWR VPWR sky130_fd_sc_hd__fill_2
X_5042_ clknet_leaf_8_clk _0418_ _0034_ VGND VGND VPWR VPWR RF0.regs\[25\]\[25\] sky130_fd_sc_hd__dfrtp_1
XFILLER_0_79_205 VPWR VGND VPWR VGND sky130_ef_sc_hd__decap_12
XFILLER_0_18_83 VGND VGND VPWR VPWR sky130_fd_sc_hd__fill_1
XTAP_TAPCELL_ROW_76_870 VGND VPWR sky130_fd_sc_hd__tapvpwrvgnd_1
XFILLER_0_34_60 VGND VGND VPWR VPWR sky130_fd_sc_hd__fill_1
XFILLER_0_47_113 VPWR VGND VPWR VGND sky130_ef_sc_hd__decap_12
X_4826_ _2469_ VGND VGND VPWR VPWR _0228_ sky130_fd_sc_hd__inv_2
Xclone18 net48 VGND VGND VPWR VPWR net66 sky130_fd_sc_hd__buf_2
X_4757_ _2461_ VGND VGND VPWR VPWR _0167_ sky130_fd_sc_hd__inv_2
XTAP_TAPCELL_ROW_31_472 VGND VPWR sky130_fd_sc_hd__tapvpwrvgnd_1
XFILLER_0_50_92 VGND VGND VPWR VPWR sky130_fd_sc_hd__decap_4
X_3708_ _1884_ _1892_ _1893_ VGND VGND VPWR VPWR _1894_ sky130_fd_sc_hd__a21oi_1
X_4688_ _2453_ VGND VGND VPWR VPWR _0106_ sky130_fd_sc_hd__inv_2
X_3639_ RF0.regs\[7\]\[7\] _1243_ VGND VGND VPWR VPWR _1826_ sky130_fd_sc_hd__and2_1
X_5309_ clknet_leaf_34_clk _0685_ _0301_ VGND VGND VPWR VPWR RF0.regs\[2\]\[4\] sky130_fd_sc_hd__dfrtp_1
XFILLER_0_38_102 VGND VGND VPWR VPWR sky130_fd_sc_hd__decap_6
XFILLER_0_66_433 VGND VGND VPWR VPWR sky130_fd_sc_hd__fill_2
XFILLER_0_38_168 VGND VGND VPWR VPWR sky130_fd_sc_hd__decap_6
XFILLER_0_46_190 VGND VGND VPWR VPWR sky130_fd_sc_hd__decap_3
XFILLER_0_55_15 VPWR VGND VPWR VGND sky130_ef_sc_hd__decap_12
X_3990_ _2122_ VGND VGND VPWR VPWR _0630_ sky130_fd_sc_hd__clkbuf_1
XFILLER_0_84_230 VGND VGND VPWR VPWR sky130_fd_sc_hd__fill_2
X_2941_ RF0.regs\[0\]\[6\] VGND VGND VPWR VPWR _1176_ sky130_fd_sc_hd__clkbuf_1
XFILLER_0_29_113 VGND VGND VPWR VPWR sky130_fd_sc_hd__decap_3
XTAP_TAPCELL_ROW_45_597 VGND VPWR sky130_fd_sc_hd__tapvpwrvgnd_1
XFILLER_0_57_444 VGND VGND VPWR VPWR sky130_fd_sc_hd__fill_1
X_2872_ _1136_ VGND VGND VPWR VPWR _0749_ sky130_fd_sc_hd__clkbuf_1
X_4611_ _2435_ VGND VGND VPWR VPWR _2442_ sky130_fd_sc_hd__clkbuf_2
X_4542_ _2422_ VGND VGND VPWR VPWR net27 sky130_fd_sc_hd__clkbuf_1
XFILLER_0_25_374 VGND VGND VPWR VPWR sky130_fd_sc_hd__fill_1
XFILLER_0_52_171 VGND VGND VPWR VPWR sky130_fd_sc_hd__fill_2
X_4473_ _2375_ VGND VGND VPWR VPWR _0401_ sky130_fd_sc_hd__clkbuf_1
X_3424_ _1615_ _1617_ VGND VGND VPWR VPWR _1618_ sky130_fd_sc_hd__or2_1
X_3355_ _1016_ _1339_ VGND VGND VPWR VPWR _1551_ sky130_fd_sc_hd__xnor2_1
X_3286_ RF0.regs\[25\]\[17\] _1252_ _1254_ RF0.regs\[12\]\[17\] _1481_ VGND VGND VPWR
+ VPWR _1482_ sky130_fd_sc_hd__a221o_1
X_5025_ clknet_leaf_27_clk _0401_ _0017_ VGND VGND VPWR VPWR RF0.regs\[25\]\[8\] sky130_fd_sc_hd__dfrtp_1
XFILLER_0_24_3 VPWR VGND VPWR VGND sky130_ef_sc_hd__decap_12
XTAP_TAPCELL_ROW_0_178 VGND VPWR sky130_fd_sc_hd__tapvpwrvgnd_1
XTAP_TAPCELL_ROW_0_189 VGND VPWR sky130_fd_sc_hd__tapvpwrvgnd_1
XPHY_EDGE_ROW_17_Right_17 VGND VGND VPWR VPWR sky130_fd_sc_hd__decap_3
XFILLER_0_16_341 VGND VGND VPWR VPWR sky130_fd_sc_hd__decap_6
X_4809_ _2468_ VGND VGND VPWR VPWR _0212_ sky130_fd_sc_hd__inv_2
XFILLER_0_43_182 VGND VGND VPWR VPWR sky130_fd_sc_hd__fill_2
XPHY_EDGE_ROW_26_Right_26 VGND VGND VPWR VPWR sky130_fd_sc_hd__decap_3
XTAP_TAPCELL_ROW_87_976 VGND VPWR sky130_fd_sc_hd__tapvpwrvgnd_1
XTAP_TAPCELL_ROW_70_821 VGND VPWR sky130_fd_sc_hd__tapvpwrvgnd_1
XFILLER_0_81_211 VGND VGND VPWR VPWR sky130_fd_sc_hd__decap_4
XPHY_EDGE_ROW_35_Right_35 VGND VGND VPWR VPWR sky130_fd_sc_hd__decap_3
XFILLER_0_39_488 VPWR VGND VPWR VGND sky130_ef_sc_hd__decap_12
XTAP_TAPCELL_ROW_42_567 VGND VPWR sky130_fd_sc_hd__tapvpwrvgnd_1
XFILLER_0_54_436 VPWR VGND VPWR VGND sky130_ef_sc_hd__decap_12
XFILLER_0_66_274 VPWR VGND VPWR VGND sky130_ef_sc_hd__decap_12
XFILLER_0_34_160 VPWR VGND VPWR VGND sky130_ef_sc_hd__decap_12
XFILLER_0_34_182 VGND VGND VPWR VPWR sky130_fd_sc_hd__decap_4
XFILLER_0_5_39 VPWR VGND VPWR VGND sky130_ef_sc_hd__decap_12
XPHY_EDGE_ROW_44_Right_44 VGND VGND VPWR VPWR sky130_fd_sc_hd__decap_3
X_3140_ _1258_ _0895_ VGND VGND VPWR VPWR _1336_ sky130_fd_sc_hd__nand2_1
X_3071_ _1264_ _0935_ VGND VGND VPWR VPWR _1267_ sky130_fd_sc_hd__or2_1
XFILLER_0_15_51 VGND VGND VPWR VPWR sky130_fd_sc_hd__decap_4
X_3973_ RF0.regs\[5\]\[21\] _1992_ _2113_ VGND VGND VPWR VPWR _2114_ sky130_fd_sc_hd__mux2_1
XPHY_EDGE_ROW_53_Right_53 VGND VGND VPWR VPWR sky130_fd_sc_hd__decap_3
X_2924_ _1167_ VGND VGND VPWR VPWR _0728_ sky130_fd_sc_hd__clkbuf_1
X_2855_ _1118_ net170 VGND VGND VPWR VPWR _1128_ sky130_fd_sc_hd__and2_1
XFILLER_0_31_50 VGND VGND VPWR VPWR sky130_fd_sc_hd__decap_6
XFILLER_0_31_72 VPWR VGND VPWR VGND sky130_ef_sc_hd__decap_12
XFILLER_0_13_333 VGND VGND VPWR VPWR sky130_fd_sc_hd__decap_3
X_4525_ _2404_ _2411_ _2405_ VGND VGND VPWR VPWR _0002_ sky130_fd_sc_hd__a21oi_1
Xhold201 IM0.addr\[19\] VGND VGND VPWR VPWR net249 sky130_fd_sc_hd__dlygate4sd3_1
X_2786_ RF0.regs\[10\]\[2\] _0882_ VGND VGND VPWR VPWR _1078_ sky130_fd_sc_hd__and2_1
Xhold212 RF0.regs\[20\]\[15\] VGND VGND VPWR VPWR net260 sky130_fd_sc_hd__dlygate4sd3_1
XFILLER_0_40_141 VPWR VGND VPWR VGND sky130_ef_sc_hd__decap_12
Xhold223 RF0.regs\[6\]\[27\] VGND VGND VPWR VPWR net271 sky130_fd_sc_hd__dlygate4sd3_1
X_4456_ _2366_ VGND VGND VPWR VPWR _0409_ sky130_fd_sc_hd__clkbuf_1
XPHY_EDGE_ROW_62_Right_62 VGND VGND VPWR VPWR sky130_fd_sc_hd__decap_3
X_4387_ _2330_ VGND VGND VPWR VPWR _0442_ sky130_fd_sc_hd__clkbuf_1
X_3407_ RF0.regs\[20\]\[26\] _1224_ _1245_ RF0.regs\[7\]\[26\] _1600_ VGND VGND VPWR
+ VPWR _1601_ sky130_fd_sc_hd__a221o_1
XTAP_TAPCELL_ROW_5_237 VGND VPWR sky130_fd_sc_hd__tapvpwrvgnd_1
XFILLER_0_0_293 VPWR VGND VPWR VGND sky130_ef_sc_hd__decap_12
X_3338_ _1532_ _1517_ _1533_ _1359_ VGND VGND VPWR VPWR _1534_ sky130_fd_sc_hd__a211o_4
X_3269_ _1054_ VGND VGND VPWR VPWR _1465_ sky130_fd_sc_hd__inv_2
XTAP_TAPCELL_ROW_84_946 VGND VPWR sky130_fd_sc_hd__tapvpwrvgnd_1
XFILLER_0_68_506 VGND VGND VPWR VPWR sky130_fd_sc_hd__decap_8
X_5008_ _2436_ VGND VGND VPWR VPWR _0391_ sky130_fd_sc_hd__inv_2
XPHY_EDGE_ROW_71_Right_71 VGND VGND VPWR VPWR sky130_fd_sc_hd__decap_3
XPHY_EDGE_ROW_80_Right_80 VGND VGND VPWR VPWR sky130_fd_sc_hd__decap_3
XFILLER_0_31_141 VGND VGND VPWR VPWR sky130_fd_sc_hd__fill_2
XTAP_TAPCELL_ROW_47_615 VGND VPWR sky130_fd_sc_hd__tapvpwrvgnd_1
XFILLER_0_39_241 VGND VGND VPWR VPWR sky130_fd_sc_hd__fill_2
XTAP_TAPCELL_ROW_55_681 VGND VPWR sky130_fd_sc_hd__tapvpwrvgnd_1
XFILLER_0_39_263 VGND VGND VPWR VPWR sky130_fd_sc_hd__decap_3
XFILLER_0_27_447 VGND VGND VPWR VPWR sky130_fd_sc_hd__fill_1
XFILLER_0_54_233 VGND VGND VPWR VPWR sky130_fd_sc_hd__decap_4
XFILLER_0_54_277 VGND VGND VPWR VPWR sky130_fd_sc_hd__decap_3
X_2640_ _0931_ VGND VGND VPWR VPWR _0932_ sky130_fd_sc_hd__inv_2
XTAP_TAPCELL_ROW_10_283 VGND VPWR sky130_fd_sc_hd__tapvpwrvgnd_1
XFILLER_0_22_130 VGND VGND VPWR VPWR sky130_fd_sc_hd__decap_8
X_2571_ _0862_ VGND VGND VPWR VPWR _0863_ sky130_fd_sc_hd__buf_4
X_5290_ clknet_leaf_18_clk _0666_ _0282_ VGND VGND VPWR VPWR RF0.regs\[4\]\[17\] sky130_fd_sc_hd__dfrtp_2
XFILLER_0_22_174 VGND VGND VPWR VPWR sky130_fd_sc_hd__fill_1
X_4310_ _2278_ VGND VGND VPWR VPWR _2290_ sky130_fd_sc_hd__buf_4
XFILLER_0_77_57 VGND VGND VPWR VPWR sky130_fd_sc_hd__decap_6
X_4241_ _2254_ VGND VGND VPWR VPWR _0512_ sky130_fd_sc_hd__clkbuf_1
X_4172_ RF0.regs\[10\]\[24\] _1981_ _2211_ VGND VGND VPWR VPWR _2219_ sky130_fd_sc_hd__mux2_1
XTAP_TAPCELL_ROW_2_207 VGND VPWR sky130_fd_sc_hd__tapvpwrvgnd_1
X_3123_ RF0.regs\[10\]\[23\] _0885_ _0875_ RF0.regs\[5\]\[23\] VGND VGND VPWR VPWR
+ _1319_ sky130_fd_sc_hd__a22o_1
X_3054_ RF0.regs\[0\]\[31\] _1219_ _1235_ _1249_ VGND VGND VPWR VPWR _1250_ sky130_fd_sc_hd__o22a_1
XTAP_TAPCELL_ROW_81_916 VGND VPWR sky130_fd_sc_hd__tapvpwrvgnd_1
XTAP_TAPCELL_ROW_18_350 VGND VPWR sky130_fd_sc_hd__tapvpwrvgnd_1
XFILLER_0_18_425 VGND VGND VPWR VPWR sky130_fd_sc_hd__fill_1
X_3956_ RF0.regs\[5\]\[29\] _1962_ _2102_ VGND VGND VPWR VPWR _2105_ sky130_fd_sc_hd__mux2_1
X_2907_ net134 VGND VGND VPWR VPWR _1159_ sky130_fd_sc_hd__clkbuf_1
XFILLER_0_33_406 VPWR VGND VPWR VGND sky130_ef_sc_hd__decap_12
X_3887_ _1453_ _1802_ VGND VGND VPWR VPWR _2053_ sky130_fd_sc_hd__xnor2_1
X_2838_ _1119_ VGND VGND VPWR VPWR _0766_ sky130_fd_sc_hd__clkbuf_1
XFILLER_0_33_439 VGND VGND VPWR VPWR sky130_fd_sc_hd__fill_1
X_2769_ RF0.regs\[10\]\[20\] _0812_ _0829_ RF0.regs\[25\]\[20\] _1060_ VGND VGND VPWR
+ VPWR _1061_ sky130_fd_sc_hd__a221oi_4
X_4508_ disp.digits\[2\] _0777_ _2396_ VGND VGND VPWR VPWR _2397_ sky130_fd_sc_hd__o21ai_2
XFILLER_0_41_483 VGND VGND VPWR VPWR sky130_fd_sc_hd__decap_8
X_4439_ _2357_ VGND VGND VPWR VPWR _0417_ sky130_fd_sc_hd__clkbuf_1
XFILLER_0_24_417 VGND VGND VPWR VPWR sky130_fd_sc_hd__decap_3
XFILLER_0_2_29 VPWR VGND VPWR VGND sky130_ef_sc_hd__decap_12
XFILLER_0_63_15 VPWR VGND VPWR VGND sky130_ef_sc_hd__decap_12
XFILLER_0_59_303 VGND VGND VPWR VPWR sky130_fd_sc_hd__decap_4
XFILLER_0_86_133 VGND VGND VPWR VPWR sky130_fd_sc_hd__decap_6
XFILLER_0_47_509 VGND VGND VPWR VPWR sky130_fd_sc_hd__decap_4
X_3810_ _1987_ VGND VGND VPWR VPWR _0672_ sky130_fd_sc_hd__clkbuf_1
XTAP_TAPCELL_ROW_15_320 VGND VPWR sky130_fd_sc_hd__tapvpwrvgnd_1
X_4790_ _2466_ VGND VGND VPWR VPWR _0195_ sky130_fd_sc_hd__inv_2
X_3741_ _1697_ _1707_ _1720_ _1925_ _1926_ VGND VGND VPWR VPWR _1927_ sky130_fd_sc_hd__o221ai_4
XFILLER_0_67_391 VGND VGND VPWR VPWR sky130_fd_sc_hd__fill_1
XFILLER_0_12_41 VPWR VGND VPWR VGND sky130_ef_sc_hd__decap_12
XFILLER_0_27_266 VGND VGND VPWR VPWR sky130_fd_sc_hd__decap_8
X_3672_ RF0.regs\[5\]\[4\] _0864_ _1220_ RF0.regs\[20\]\[4\] _1857_ VGND VGND VPWR
+ VPWR _1858_ sky130_fd_sc_hd__a221o_1
XFILLER_0_30_409 VGND VGND VPWR VPWR sky130_fd_sc_hd__fill_2
X_5411_ clknet_leaf_23_clk net3 VGND VGND VPWR VPWR disp.digits\[10\] sky130_fd_sc_hd__dfxtp_1
X_2623_ RF0.regs\[10\]\[13\] _0883_ VGND VGND VPWR VPWR _0915_ sky130_fd_sc_hd__and2_1
X_5342_ clknet_leaf_33_clk _0718_ _0334_ VGND VGND VPWR VPWR RF0.regs\[0\]\[5\] sky130_fd_sc_hd__dfrtp_1
X_2554_ RF0.regs\[4\]\[30\] _0839_ _0845_ RF0.regs\[12\]\[30\] VGND VGND VPWR VPWR
+ _0846_ sky130_fd_sc_hd__a22o_1
XFILLER_0_2_377 VPWR VGND VPWR VGND sky130_ef_sc_hd__decap_12
X_5273_ clknet_leaf_41_clk _0649_ _0265_ VGND VGND VPWR VPWR RF0.regs\[4\]\[0\] sky130_fd_sc_hd__dfrtp_4
X_4224_ net84 VGND VGND VPWR VPWR _2246_ sky130_fd_sc_hd__clkbuf_1
X_4155_ net153 VGND VGND VPWR VPWR _2210_ sky130_fd_sc_hd__clkbuf_1
X_3106_ _0923_ _0922_ _1301_ _1257_ VGND VGND VPWR VPWR _1302_ sky130_fd_sc_hd__o31a_1
X_4086_ _2173_ _1393_ VGND VGND VPWR VPWR _2174_ sky130_fd_sc_hd__or2_1
X_3037_ _1232_ VGND VGND VPWR VPWR _1233_ sky130_fd_sc_hd__buf_4
XTAP_TAPCELL_ROW_66_787 VGND VPWR sky130_fd_sc_hd__tapvpwrvgnd_1
XFILLER_0_77_177 VGND VGND VPWR VPWR sky130_fd_sc_hd__decap_4
XFILLER_0_18_222 VGND VGND VPWR VPWR sky130_fd_sc_hd__decap_3
X_4988_ _2487_ VGND VGND VPWR VPWR _0372_ sky130_fd_sc_hd__inv_2
XFILLER_0_80_309 VPWR VGND VPWR VGND sky130_ef_sc_hd__decap_12
X_3939_ _2034_ _1896_ VGND VGND VPWR VPWR _2094_ sky130_fd_sc_hd__xnor2_2
XFILLER_0_33_203 VGND VGND VPWR VPWR sky130_fd_sc_hd__decap_6
XFILLER_0_18_288 VGND VGND VPWR VPWR sky130_fd_sc_hd__decap_3
XTAP_TAPCELL_ROW_21_378 VGND VPWR sky130_fd_sc_hd__tapvpwrvgnd_1
XFILLER_0_33_247 VPWR VGND VPWR VGND sky130_ef_sc_hd__decap_12
XFILLER_0_14_494 VPWR VGND VPWR VGND sky130_ef_sc_hd__decap_12
XTAP_TAPCELL_ROW_12_301 VGND VPWR sky130_fd_sc_hd__tapvpwrvgnd_1
XFILLER_0_64_350 VGND VGND VPWR VPWR sky130_fd_sc_hd__fill_1
XFILLER_0_20_475 VGND VGND VPWR VPWR sky130_fd_sc_hd__fill_1
XFILLER_0_20_497 VGND VGND VPWR VPWR sky130_fd_sc_hd__fill_1
X_4911_ _2479_ VGND VGND VPWR VPWR _0303_ sky130_fd_sc_hd__inv_2
XTAP_TAPCELL_ROW_63_757 VGND VPWR sky130_fd_sc_hd__tapvpwrvgnd_1
X_4842_ _2472_ VGND VGND VPWR VPWR _0241_ sky130_fd_sc_hd__inv_2
X_4773_ _2464_ VGND VGND VPWR VPWR _0180_ sky130_fd_sc_hd__inv_2
XFILLER_0_15_225 VPWR VGND VPWR VGND sky130_ef_sc_hd__decap_12
XFILLER_0_7_469 VPWR VGND VPWR VGND sky130_ef_sc_hd__decap_12
X_3724_ _0797_ net63 _1822_ _1820_ VGND VGND VPWR VPWR _1910_ sky130_fd_sc_hd__or4b_1
X_3655_ _1008_ _1427_ _1840_ VGND VGND VPWR VPWR _1841_ sky130_fd_sc_hd__nand3_2
XFILLER_0_70_397 VGND VGND VPWR VPWR sky130_fd_sc_hd__fill_1
X_2606_ RF0.regs\[5\]\[18\] _0874_ _0864_ RF0.regs\[4\]\[18\] _0897_ VGND VGND VPWR
+ VPWR _0898_ sky130_fd_sc_hd__a221oi_4
XFILLER_0_30_228 VGND VGND VPWR VPWR sky130_fd_sc_hd__fill_2
XFILLER_0_2_174 VGND VGND VPWR VPWR sky130_fd_sc_hd__fill_2
XFILLER_0_30_239 VGND VGND VPWR VPWR sky130_fd_sc_hd__decap_4
X_3586_ _1363_ _1460_ VGND VGND VPWR VPWR _1777_ sky130_fd_sc_hd__or2_1
X_5325_ clknet_leaf_13_clk _0701_ _0317_ VGND VGND VPWR VPWR RF0.regs\[2\]\[20\] sky130_fd_sc_hd__dfrtp_1
X_2537_ _0828_ VGND VGND VPWR VPWR _0829_ sky130_fd_sc_hd__buf_4
X_5256_ clknet_leaf_19_clk _0632_ _0248_ VGND VGND VPWR VPWR RF0.regs\[5\]\[15\] sky130_fd_sc_hd__dfrtp_1
XFILLER_0_54_3 VGND VGND VPWR VPWR sky130_fd_sc_hd__fill_2
X_4207_ _2237_ VGND VGND VPWR VPWR _0529_ sky130_fd_sc_hd__clkbuf_1
X_5187_ clknet_leaf_23_clk _0563_ _0179_ VGND VGND VPWR VPWR RF0.regs\[7\]\[10\] sky130_fd_sc_hd__dfrtp_1
X_4138_ _2201_ VGND VGND VPWR VPWR _0562_ sky130_fd_sc_hd__clkbuf_1
X_4069_ _2164_ VGND VGND VPWR VPWR _0593_ sky130_fd_sc_hd__clkbuf_1
XFILLER_0_78_464 VPWR VGND VPWR VGND sky130_ef_sc_hd__decap_12
XTAP_TAPCELL_ROW_26_426 VGND VPWR sky130_fd_sc_hd__tapvpwrvgnd_1
XFILLER_0_38_306 VGND VGND VPWR VPWR sky130_fd_sc_hd__fill_2
XFILLER_0_38_328 VGND VGND VPWR VPWR sky130_fd_sc_hd__fill_1
XTAP_TAPCELL_ROW_34_492 VGND VPWR sky130_fd_sc_hd__tapvpwrvgnd_1
XFILLER_0_80_128 VPWR VGND VPWR VGND sky130_ef_sc_hd__decap_12
XFILLER_0_46_372 VGND VGND VPWR VPWR sky130_fd_sc_hd__fill_1
XFILLER_0_61_386 VGND VGND VPWR VPWR sky130_fd_sc_hd__decap_6
XFILLER_0_28_29 VPWR VGND VPWR VGND sky130_ef_sc_hd__decap_12
XFILLER_0_84_445 VPWR VGND VPWR VGND sky130_ef_sc_hd__decap_12
XTAP_TAPCELL_ROW_60_727 VGND VPWR sky130_fd_sc_hd__tapvpwrvgnd_1
XFILLER_0_84_489 VPWR VGND VPWR VGND sky130_ef_sc_hd__decap_12
XFILLER_0_37_350 VGND VGND VPWR VPWR sky130_fd_sc_hd__decap_4
XFILLER_0_44_309 VGND VGND VPWR VPWR sky130_fd_sc_hd__fill_2
X_3440_ _1630_ _1632_ _1504_ VGND VGND VPWR VPWR _1634_ sky130_fd_sc_hd__a21o_1
X_3371_ RF0.regs\[6\]\[29\] _1233_ _1229_ RF0.regs\[15\]\[29\] _1565_ VGND VGND VPWR
+ VPWR _1566_ sky130_fd_sc_hd__a221o_1
XFILLER_0_20_272 VGND VGND VPWR VPWR sky130_fd_sc_hd__fill_2
X_5110_ clknet_leaf_0_clk _0486_ _0102_ VGND VGND VPWR VPWR RF0.regs\[15\]\[29\] sky130_fd_sc_hd__dfrtp_1
XFILLER_0_85_57 VPWR VGND VPWR VGND sky130_ef_sc_hd__decap_12
XTAP_TAPCELL_ROW_68_805 VGND VPWR sky130_fd_sc_hd__tapvpwrvgnd_1
XFILLER_0_40_9 VGND VGND VPWR VPWR sky130_fd_sc_hd__fill_1
X_5041_ clknet_leaf_7_clk _0417_ _0033_ VGND VGND VPWR VPWR RF0.regs\[25\]\[24\] sky130_fd_sc_hd__dfrtp_1
XFILLER_0_79_217 VGND VGND VPWR VPWR sky130_fd_sc_hd__decap_6
XTAP_TAPCELL_ROW_76_871 VGND VPWR sky130_fd_sc_hd__tapvpwrvgnd_1
XFILLER_0_87_261 VGND VGND VPWR VPWR sky130_fd_sc_hd__decap_4
XFILLER_0_75_445 VGND VGND VPWR VPWR sky130_fd_sc_hd__decap_3
XFILLER_0_47_125 VGND VGND VPWR VPWR sky130_fd_sc_hd__decap_4
X_4825_ _2469_ VGND VGND VPWR VPWR _0227_ sky130_fd_sc_hd__inv_2
Xclone19 IM0.addr\[0\] VGND VGND VPWR VPWR net67 sky130_fd_sc_hd__buf_2
XFILLER_0_28_394 VPWR VGND VPWR VGND sky130_ef_sc_hd__decap_12
X_4756_ _2461_ VGND VGND VPWR VPWR _0166_ sky130_fd_sc_hd__inv_2
XFILLER_0_50_82 VGND VGND VPWR VPWR sky130_fd_sc_hd__fill_2
X_3707_ _1007_ _1878_ _1883_ VGND VGND VPWR VPWR _1893_ sky130_fd_sc_hd__and3_1
X_4687_ _2453_ VGND VGND VPWR VPWR _0105_ sky130_fd_sc_hd__inv_2
XFILLER_0_3_461 VPWR VGND VPWR VGND sky130_ef_sc_hd__decap_12
X_3638_ RF0.regs\[6\]\[7\] _1231_ _1227_ RF0.regs\[15\]\[7\] _1824_ VGND VGND VPWR
+ VPWR _1825_ sky130_fd_sc_hd__a221o_1
X_3569_ RF0.regs\[20\]\[13\] _1223_ _1228_ RF0.regs\[15\]\[13\] _1760_ VGND VGND VPWR
+ VPWR _1761_ sky130_fd_sc_hd__a221o_1
XFILLER_0_11_272 VGND VGND VPWR VPWR sky130_fd_sc_hd__fill_2
X_5308_ clknet_leaf_37_clk _0684_ _0300_ VGND VGND VPWR VPWR RF0.regs\[2\]\[3\] sky130_fd_sc_hd__dfrtp_1
X_5239_ clknet_leaf_43_clk _0615_ _0231_ VGND VGND VPWR VPWR RF0.regs\[6\]\[30\] sky130_fd_sc_hd__dfrtp_1
XTAP_TAPCELL_ROW_39_540 VGND VPWR sky130_fd_sc_hd__tapvpwrvgnd_1
XFILLER_0_78_250 VGND VGND VPWR VPWR sky130_fd_sc_hd__fill_2
XFILLER_0_26_309 VGND VGND VPWR VPWR sky130_fd_sc_hd__fill_1
XFILLER_0_81_426 VPWR VGND VPWR VGND sky130_ef_sc_hd__decap_12
XFILLER_0_53_139 VGND VGND VPWR VPWR sky130_fd_sc_hd__decap_3
XFILLER_0_34_342 VGND VGND VPWR VPWR sky130_fd_sc_hd__fill_1
XFILLER_0_61_172 VPWR VGND VPWR VGND sky130_ef_sc_hd__decap_12
XFILLER_0_55_27 VPWR VGND VPWR VGND sky130_ef_sc_hd__decap_12
XFILLER_0_76_209 VGND VGND VPWR VPWR sky130_fd_sc_hd__decap_4
XFILLER_0_71_15 VPWR VGND VPWR VGND sky130_ef_sc_hd__decap_12
XFILLER_0_69_250 VGND VGND VPWR VPWR sky130_fd_sc_hd__fill_1
X_2940_ _1175_ VGND VGND VPWR VPWR _0720_ sky130_fd_sc_hd__clkbuf_1
XFILLER_0_84_253 VGND VGND VPWR VPWR sky130_fd_sc_hd__fill_2
X_2871_ _1117_ net200 VGND VGND VPWR VPWR _1136_ sky130_fd_sc_hd__and2_1
XFILLER_0_29_147 VGND VGND VPWR VPWR sky130_fd_sc_hd__decap_4
XFILLER_0_29_169 VGND VGND VPWR VPWR sky130_fd_sc_hd__decap_3
XTAP_TAPCELL_ROW_45_598 VGND VPWR sky130_fd_sc_hd__tapvpwrvgnd_1
XFILLER_0_84_275 VGND VGND VPWR VPWR sky130_fd_sc_hd__decap_8
X_4610_ _2441_ VGND VGND VPWR VPWR _0040_ sky130_fd_sc_hd__inv_2
XFILLER_0_44_139 VGND VGND VPWR VPWR sky130_fd_sc_hd__fill_1
XFILLER_0_25_342 VGND VGND VPWR VPWR sky130_fd_sc_hd__decap_3
XFILLER_0_37_180 VGND VGND VPWR VPWR sky130_fd_sc_hd__fill_1
XFILLER_0_20_41 VGND VGND VPWR VPWR sky130_fd_sc_hd__decap_8
X_4541_ _1149_ _1861_ VGND VGND VPWR VPWR _2422_ sky130_fd_sc_hd__and2_1
X_4472_ RF0.regs\[25\]\[8\] _2083_ _2371_ VGND VGND VPWR VPWR _2375_ sky130_fd_sc_hd__mux2_1
XFILLER_0_40_378 VGND VGND VPWR VPWR sky130_fd_sc_hd__decap_4
X_3423_ _1609_ _1616_ _1010_ VGND VGND VPWR VPWR _1617_ sky130_fd_sc_hd__and3b_1
X_3354_ _1548_ _1345_ _1549_ VGND VGND VPWR VPWR _1550_ sky130_fd_sc_hd__a21o_1
X_3285_ RF0.regs\[4\]\[17\] _0836_ _0811_ RF0.regs\[10\]\[17\] VGND VGND VPWR VPWR
+ _1481_ sky130_fd_sc_hd__a22o_1
X_5024_ clknet_leaf_38_clk _0400_ _0016_ VGND VGND VPWR VPWR RF0.regs\[25\]\[7\] sky130_fd_sc_hd__dfrtp_1
XFILLER_0_17_3 VPWR VGND VPWR VGND sky130_ef_sc_hd__decap_12
XTAP_TAPCELL_ROW_36_510 VGND VPWR sky130_fd_sc_hd__tapvpwrvgnd_1
XTAP_TAPCELL_ROW_0_179 VGND VPWR sky130_fd_sc_hd__tapvpwrvgnd_1
XFILLER_0_67_209 VPWR VGND VPWR VGND sky130_ef_sc_hd__decap_12
X_4808_ _2468_ VGND VGND VPWR VPWR _0211_ sky130_fd_sc_hd__inv_2
X_4739_ _2459_ VGND VGND VPWR VPWR _0151_ sky130_fd_sc_hd__inv_2
XFILLER_0_31_367 VGND VGND VPWR VPWR sky130_fd_sc_hd__fill_2
XTAP_TAPCELL_ROW_8_257 VGND VPWR sky130_fd_sc_hd__tapvpwrvgnd_1
XTAP_TAPCELL_ROW_87_977 VGND VPWR sky130_fd_sc_hd__tapvpwrvgnd_1
XFILLER_0_58_209 VGND VGND VPWR VPWR sky130_fd_sc_hd__decap_8
XTAP_TAPCELL_ROW_70_822 VGND VPWR sky130_fd_sc_hd__tapvpwrvgnd_1
XTAP_TAPCELL_ROW_42_568 VGND VPWR sky130_fd_sc_hd__tapvpwrvgnd_1
XFILLER_0_66_286 VGND VGND VPWR VPWR sky130_fd_sc_hd__fill_2
XFILLER_0_26_139 VGND VGND VPWR VPWR sky130_fd_sc_hd__fill_1
XFILLER_0_54_448 VPWR VGND VPWR VGND sky130_ef_sc_hd__decap_12
XFILLER_0_1_206 VPWR VGND VPWR VGND sky130_ef_sc_hd__decap_12
XFILLER_0_34_172 VGND VGND VPWR VPWR sky130_fd_sc_hd__decap_3
XFILLER_0_66_15 VGND VGND VPWR VPWR sky130_fd_sc_hd__decap_4
XPHY_EDGE_ROW_19_Left_107 VGND VGND VPWR VPWR sky130_fd_sc_hd__decap_3
X_3070_ _1264_ _1052_ VGND VGND VPWR VPWR _1266_ sky130_fd_sc_hd__nor2_1
X_3972_ _0868_ VGND VGND VPWR VPWR _2113_ sky130_fd_sc_hd__buf_4
XFILLER_0_57_242 VGND VGND VPWR VPWR sky130_fd_sc_hd__decap_3
X_2923_ net104 VGND VGND VPWR VPWR _1167_ sky130_fd_sc_hd__clkbuf_1
XFILLER_0_17_117 VGND VGND VPWR VPWR sky130_fd_sc_hd__fill_1
XFILLER_0_45_426 VPWR VGND VPWR VGND sky130_ef_sc_hd__decap_12
XFILLER_0_57_264 VGND VGND VPWR VPWR sky130_fd_sc_hd__fill_2
XFILLER_0_72_245 VGND VGND VPWR VPWR sky130_fd_sc_hd__decap_6
X_2854_ _1127_ VGND VGND VPWR VPWR _0758_ sky130_fd_sc_hd__clkbuf_1
XPHY_EDGE_ROW_28_Left_116 VGND VGND VPWR VPWR sky130_fd_sc_hd__decap_3
XFILLER_0_31_84 VGND VGND VPWR VPWR sky130_fd_sc_hd__decap_6
X_2785_ _1032_ _1049_ _1056_ _1076_ VGND VGND VPWR VPWR _1077_ sky130_fd_sc_hd__or4_1
X_4524_ _2393_ _2399_ _2390_ VGND VGND VPWR VPWR _2411_ sky130_fd_sc_hd__or3b_1
Xhold202 RF0.regs\[12\]\[20\] VGND VGND VPWR VPWR net250 sky130_fd_sc_hd__dlygate4sd3_1
Xhold224 RF0.regs\[6\]\[20\] VGND VGND VPWR VPWR net272 sky130_fd_sc_hd__dlygate4sd3_1
Xhold213 RF0.regs\[12\]\[27\] VGND VGND VPWR VPWR net261 sky130_fd_sc_hd__dlygate4sd3_1
X_4455_ RF0.regs\[25\]\[16\] _2008_ _2360_ VGND VGND VPWR VPWR _2366_ sky130_fd_sc_hd__mux2_1
XFILLER_0_40_164 VPWR VGND VPWR VGND sky130_ef_sc_hd__decap_12
X_4386_ net210 _2005_ _2325_ VGND VGND VPWR VPWR _2330_ sky130_fd_sc_hd__mux2_1
XFILLER_0_0_261 VGND VGND VPWR VPWR sky130_fd_sc_hd__fill_1
XFILLER_0_40_197 VGND VGND VPWR VPWR sky130_fd_sc_hd__decap_3
X_3406_ RF0.regs\[25\]\[26\] _0807_ _1033_ _1247_ VGND VGND VPWR VPWR _1600_ sky130_fd_sc_hd__a211o_1
XPHY_EDGE_ROW_37_Left_125 VGND VGND VPWR VPWR sky130_fd_sc_hd__decap_3
X_3337_ _1004_ _1358_ VGND VGND VPWR VPWR _1533_ sky130_fd_sc_hd__nor2_1
XTAP_TAPCELL_ROW_5_238 VGND VPWR sky130_fd_sc_hd__tapvpwrvgnd_1
X_3268_ _0919_ _1379_ _1463_ VGND VGND VPWR VPWR _1464_ sky130_fd_sc_hd__a21oi_1
XTAP_TAPCELL_ROW_84_947 VGND VPWR sky130_fd_sc_hd__tapvpwrvgnd_1
X_5007_ _2436_ VGND VGND VPWR VPWR _0390_ sky130_fd_sc_hd__inv_2
X_3199_ _1074_ _1394_ VGND VGND VPWR VPWR _1395_ sky130_fd_sc_hd__xnor2_1
XFILLER_0_48_253 VGND VGND VPWR VPWR sky130_fd_sc_hd__decap_4
XPHY_EDGE_ROW_46_Left_134 VGND VGND VPWR VPWR sky130_fd_sc_hd__decap_3
XFILLER_0_63_212 VGND VGND VPWR VPWR sky130_fd_sc_hd__decap_3
XFILLER_0_8_361 VGND VGND VPWR VPWR sky130_fd_sc_hd__decap_3
XFILLER_0_63_234 VPWR VGND VPWR VGND sky130_ef_sc_hd__decap_12
XFILLER_0_6_3 VPWR VGND VPWR VGND sky130_ef_sc_hd__decap_12
XPHY_EDGE_ROW_55_Left_143 VGND VGND VPWR VPWR sky130_fd_sc_hd__decap_3
XTAP_TAPCELL_ROW_47_616 VGND VPWR sky130_fd_sc_hd__tapvpwrvgnd_1
XTAP_TAPCELL_ROW_55_682 VGND VPWR sky130_fd_sc_hd__tapvpwrvgnd_1
XPHY_EDGE_ROW_64_Left_152 VGND VGND VPWR VPWR sky130_fd_sc_hd__decap_3
XFILLER_0_39_286 VGND VGND VPWR VPWR sky130_fd_sc_hd__fill_1
X_2570_ _0861_ VGND VGND VPWR VPWR _0862_ sky130_fd_sc_hd__buf_4
XPHY_EDGE_ROW_73_Left_161 VGND VGND VPWR VPWR sky130_fd_sc_hd__decap_3
XFILLER_0_22_197 VGND VGND VPWR VPWR sky130_fd_sc_hd__decap_4
X_4240_ net231 VGND VGND VPWR VPWR _2254_ sky130_fd_sc_hd__clkbuf_1
X_4171_ _2218_ VGND VGND VPWR VPWR _0546_ sky130_fd_sc_hd__clkbuf_1
X_3122_ _1317_ _1315_ _1312_ VGND VGND VPWR VPWR _1318_ sky130_fd_sc_hd__or3_4
XTAP_TAPCELL_ROW_2_208 VGND VPWR sky130_fd_sc_hd__tapvpwrvgnd_1
X_3053_ RF0.regs\[4\]\[31\] _1241_ _1245_ RF0.regs\[7\]\[31\] _1248_ VGND VGND VPWR
+ VPWR _1249_ sky130_fd_sc_hd__a221o_1
XPHY_EDGE_ROW_82_Left_170 VGND VGND VPWR VPWR sky130_fd_sc_hd__decap_3
XTAP_TAPCELL_ROW_81_917 VGND VPWR sky130_fd_sc_hd__tapvpwrvgnd_1
XTAP_TAPCELL_ROW_18_351 VGND VPWR sky130_fd_sc_hd__tapvpwrvgnd_1
X_3955_ _2104_ VGND VGND VPWR VPWR _0647_ sky130_fd_sc_hd__clkbuf_1
XFILLER_0_42_83 VGND VGND VPWR VPWR sky130_fd_sc_hd__fill_1
X_2906_ _1158_ VGND VGND VPWR VPWR _0737_ sky130_fd_sc_hd__clkbuf_1
XFILLER_0_5_331 VGND VGND VPWR VPWR sky130_fd_sc_hd__decap_4
XFILLER_0_33_418 VPWR VGND VPWR VGND sky130_ef_sc_hd__decap_12
X_3886_ _2023_ _2051_ VGND VGND VPWR VPWR _2052_ sky130_fd_sc_hd__or2_1
XFILLER_0_84_3 VPWR VGND VPWR VGND sky130_ef_sc_hd__decap_12
X_2837_ _1118_ net188 VGND VGND VPWR VPWR _1119_ sky130_fd_sc_hd__and2_1
XFILLER_0_13_120 VGND VGND VPWR VPWR sky130_fd_sc_hd__fill_1
XFILLER_0_41_440 VGND VGND VPWR VPWR sky130_fd_sc_hd__fill_1
XFILLER_0_60_248 VGND VGND VPWR VPWR sky130_fd_sc_hd__fill_1
X_2768_ RF0.regs\[4\]\[20\] _0837_ _0844_ RF0.regs\[12\]\[20\] VGND VGND VPWR VPWR
+ _1060_ sky130_fd_sc_hd__a22o_1
X_4507_ disp.digits\[6\] _2385_ _2395_ _2384_ VGND VGND VPWR VPWR _2396_ sky130_fd_sc_hd__a211o_1
X_2699_ RF0.regs\[4\]\[3\] _0867_ _0879_ RF0.regs\[2\]\[3\] VGND VGND VPWR VPWR _0991_
+ sky130_fd_sc_hd__a22o_1
X_4438_ RF0.regs\[25\]\[24\] _1981_ _2349_ VGND VGND VPWR VPWR _2357_ sky130_fd_sc_hd__mux2_1
XFILLER_0_6_83 VGND VGND VPWR VPWR sky130_fd_sc_hd__fill_1
X_4369_ net236 _1978_ _2314_ VGND VGND VPWR VPWR _2321_ sky130_fd_sc_hd__mux2_1
XFILLER_0_68_315 VGND VGND VPWR VPWR sky130_fd_sc_hd__fill_1
XFILLER_0_68_326 VGND VGND VPWR VPWR sky130_fd_sc_hd__fill_1
XFILLER_0_24_407 VGND VGND VPWR VPWR sky130_fd_sc_hd__decap_6
XFILLER_0_63_27 VPWR VGND VPWR VGND sky130_ef_sc_hd__decap_12
XFILLER_0_59_315 VGND VGND VPWR VPWR sky130_fd_sc_hd__decap_6
XFILLER_0_59_337 VGND VGND VPWR VPWR sky130_fd_sc_hd__decap_8
XTAP_TAPCELL_ROW_15_321 VGND VPWR sky130_fd_sc_hd__tapvpwrvgnd_1
X_3740_ _1697_ _1707_ _1718_ VGND VGND VPWR VPWR _1926_ sky130_fd_sc_hd__a21o_1
XFILLER_0_27_223 VGND VGND VPWR VPWR sky130_fd_sc_hd__fill_1
XFILLER_0_12_53 VPWR VGND VPWR VGND sky130_ef_sc_hd__decap_12
X_3671_ RF0.regs\[10\]\[4\] _0884_ _0810_ RF0.regs\[25\]\[4\] _0794_ VGND VGND VPWR
+ VPWR _1857_ sky130_fd_sc_hd__a221o_1
XFILLER_0_23_440 VGND VGND VPWR VPWR sky130_fd_sc_hd__fill_1
X_2622_ RF0.regs\[4\]\[7\] _0835_ _0843_ RF0.regs\[12\]\[7\] _0913_ VGND VGND VPWR
+ VPWR _0914_ sky130_fd_sc_hd__a221o_2
X_5410_ clknet_leaf_30_clk net33 VGND VGND VPWR VPWR disp.digits\[9\] sky130_fd_sc_hd__dfxtp_1
X_5341_ clknet_leaf_33_clk _0717_ _0333_ VGND VGND VPWR VPWR RF0.regs\[0\]\[4\] sky130_fd_sc_hd__dfrtp_1
X_2553_ _0844_ VGND VGND VPWR VPWR _0845_ sky130_fd_sc_hd__clkbuf_4
XFILLER_0_2_389 VPWR VGND VPWR VGND sky130_ef_sc_hd__decap_12
X_5272_ clknet_leaf_45_clk _0648_ _0264_ VGND VGND VPWR VPWR RF0.regs\[5\]\[31\] sky130_fd_sc_hd__dfrtp_1
X_4223_ _2245_ VGND VGND VPWR VPWR _0521_ sky130_fd_sc_hd__clkbuf_1
X_4154_ _2209_ VGND VGND VPWR VPWR _0554_ sky130_fd_sc_hd__clkbuf_1
X_4085_ RF0.regs\[4\]\[0\] _0839_ _1138_ RF0.regs\[12\]\[0\] _2172_ VGND VGND VPWR
+ VPWR _2173_ sky130_fd_sc_hd__a221o_1
X_3105_ RF0.regs\[2\]\[15\] _1237_ VGND VGND VPWR VPWR _1301_ sky130_fd_sc_hd__and2_1
X_3036_ _1231_ VGND VGND VPWR VPWR _1232_ sky130_fd_sc_hd__clkbuf_4
X_4987_ _2487_ VGND VGND VPWR VPWR _0371_ sky130_fd_sc_hd__inv_2
X_3938_ _2093_ VGND VGND VPWR VPWR _0653_ sky130_fd_sc_hd__clkbuf_1
X_3869_ _2035_ VGND VGND VPWR VPWR net24 sky130_fd_sc_hd__dlymetal6s2s_1
XTAP_TAPCELL_ROW_21_379 VGND VPWR sky130_fd_sc_hd__tapvpwrvgnd_1
XFILLER_0_33_259 VPWR VGND VPWR VGND sky130_ef_sc_hd__decap_12
XFILLER_0_41_292 VGND VGND VPWR VPWR sky130_fd_sc_hd__fill_1
XTAP_TAPCELL_ROW_57_700 VGND VPWR sky130_fd_sc_hd__tapvpwrvgnd_1
XTAP_TAPCELL_ROW_29_446 VGND VPWR sky130_fd_sc_hd__tapvpwrvgnd_1
XFILLER_0_56_307 VGND VGND VPWR VPWR sky130_fd_sc_hd__fill_1
XFILLER_0_68_189 VGND VGND VPWR VPWR sky130_fd_sc_hd__decap_6
XFILLER_0_64_362 VGND VGND VPWR VPWR sky130_fd_sc_hd__fill_2
XFILLER_0_58_27 VGND VGND VPWR VPWR sky130_fd_sc_hd__fill_1
XFILLER_0_74_15 VPWR VGND VPWR VGND sky130_ef_sc_hd__decap_12
XFILLER_0_87_421 VPWR VGND VPWR VGND sky130_ef_sc_hd__decap_12
X_4910_ _2479_ VGND VGND VPWR VPWR _0302_ sky130_fd_sc_hd__inv_2
X_4841_ _2471_ VGND VGND VPWR VPWR _2472_ sky130_fd_sc_hd__buf_4
XFILLER_0_59_189 VPWR VGND VPWR VGND sky130_ef_sc_hd__decap_12
XTAP_TAPCELL_ROW_63_758 VGND VPWR sky130_fd_sc_hd__tapvpwrvgnd_1
XFILLER_0_23_85 VGND VGND VPWR VPWR sky130_fd_sc_hd__fill_1
X_4772_ _2464_ VGND VGND VPWR VPWR _0179_ sky130_fd_sc_hd__inv_2
XFILLER_0_82_170 VGND VGND VPWR VPWR sky130_fd_sc_hd__fill_1
X_3723_ _1834_ _1907_ _1908_ VGND VGND VPWR VPWR _1909_ sky130_fd_sc_hd__o21ai_2
XFILLER_0_70_354 VGND VGND VPWR VPWR sky130_fd_sc_hd__fill_1
XFILLER_0_15_237 VGND VGND VPWR VPWR sky130_fd_sc_hd__decap_4
X_3654_ _1426_ _1386_ _1420_ VGND VGND VPWR VPWR _1840_ sky130_fd_sc_hd__nand3_1
X_2605_ RF0.regs\[15\]\[18\] _0854_ _0878_ RF0.regs\[2\]\[18\] _0896_ VGND VGND VPWR
+ VPWR _0897_ sky130_fd_sc_hd__a221o_1
XFILLER_0_23_281 VGND VGND VPWR VPWR sky130_fd_sc_hd__decap_6
X_3585_ _1363_ _1460_ VGND VGND VPWR VPWR _1776_ sky130_fd_sc_hd__nand2_1
X_2536_ _0827_ VGND VGND VPWR VPWR _0828_ sky130_fd_sc_hd__buf_4
X_5324_ clknet_leaf_14_clk _0700_ _0316_ VGND VGND VPWR VPWR RF0.regs\[2\]\[19\] sky130_fd_sc_hd__dfrtp_1
X_5255_ clknet_leaf_20_clk _0631_ _0247_ VGND VGND VPWR VPWR RF0.regs\[5\]\[14\] sky130_fd_sc_hd__dfrtp_1
X_4206_ RF0.regs\[10\]\[8\] _2083_ _2233_ VGND VGND VPWR VPWR _2237_ sky130_fd_sc_hd__mux2_1
XFILLER_0_47_3 VPWR VGND VPWR VGND sky130_ef_sc_hd__decap_12
X_5186_ clknet_leaf_30_clk _0562_ _0178_ VGND VGND VPWR VPWR RF0.regs\[7\]\[9\] sky130_fd_sc_hd__dfrtp_1
XFILLER_0_3_51 VGND VGND VPWR VPWR sky130_fd_sc_hd__decap_4
X_4137_ net125 VGND VGND VPWR VPWR _2201_ sky130_fd_sc_hd__clkbuf_1
X_4068_ _2083_ net226 _2160_ VGND VGND VPWR VPWR _2164_ sky130_fd_sc_hd__mux2_1
XFILLER_0_78_454 VGND VGND VPWR VPWR sky130_fd_sc_hd__fill_2
X_3019_ _0801_ _0781_ VGND VGND VPWR VPWR _1215_ sky130_fd_sc_hd__nor2_1
XTAP_TAPCELL_ROW_26_427 VGND VPWR sky130_fd_sc_hd__tapvpwrvgnd_1
XTAP_TAPCELL_ROW_34_493 VGND VPWR sky130_fd_sc_hd__tapvpwrvgnd_1
XFILLER_0_61_310 VGND VGND VPWR VPWR sky130_fd_sc_hd__fill_2
XFILLER_0_73_181 VGND VGND VPWR VPWR sky130_fd_sc_hd__decap_3
XFILLER_0_61_365 VGND VGND VPWR VPWR sky130_fd_sc_hd__fill_1
XFILLER_0_44_29 VPWR VGND VPWR VGND sky130_ef_sc_hd__decap_12
XTAP_TAPCELL_ROW_60_728 VGND VPWR sky130_fd_sc_hd__tapvpwrvgnd_1
XFILLER_0_84_457 VPWR VGND VPWR VGND sky130_ef_sc_hd__decap_12
XFILLER_0_37_340 VGND VGND VPWR VPWR sky130_fd_sc_hd__fill_1
XFILLER_0_37_362 VGND VGND VPWR VPWR sky130_fd_sc_hd__decap_6
XFILLER_0_8_29 VPWR VGND VPWR VGND sky130_ef_sc_hd__decap_12
XFILLER_0_69_15 VPWR VGND VPWR VGND sky130_ef_sc_hd__decap_12
XFILLER_0_40_516 VGND VGND VPWR VPWR sky130_fd_sc_hd__fill_1
XFILLER_0_52_365 VPWR VGND VPWR VGND sky130_ef_sc_hd__decap_12
X_3370_ RF0.regs\[5\]\[29\] _0961_ _1139_ VGND VGND VPWR VPWR _1565_ sky130_fd_sc_hd__and3_1
X_5040_ clknet_leaf_8_clk _0416_ _0032_ VGND VGND VPWR VPWR RF0.regs\[25\]\[23\] sky130_fd_sc_hd__dfrtp_2
XFILLER_0_85_69 VPWR VGND VPWR VGND sky130_ef_sc_hd__decap_12
XFILLER_0_18_41 VGND VGND VPWR VPWR sky130_fd_sc_hd__decap_8
XFILLER_0_18_96 VGND VGND VPWR VPWR sky130_fd_sc_hd__decap_3
XTAP_TAPCELL_ROW_76_872 VGND VPWR sky130_fd_sc_hd__tapvpwrvgnd_1
XFILLER_0_87_295 VGND VGND VPWR VPWR sky130_fd_sc_hd__fill_2
X_4824_ _2469_ VGND VGND VPWR VPWR _0226_ sky130_fd_sc_hd__inv_2
X_4755_ _2461_ VGND VGND VPWR VPWR _0165_ sky130_fd_sc_hd__inv_2
XFILLER_0_62_118 VGND VGND VPWR VPWR sky130_fd_sc_hd__fill_2
X_3706_ _1006_ _1889_ _1891_ VGND VGND VPWR VPWR _1892_ sky130_fd_sc_hd__and3_1
XFILLER_0_70_162 VGND VGND VPWR VPWR sky130_fd_sc_hd__fill_1
X_4686_ _2451_ VGND VGND VPWR VPWR _2453_ sky130_fd_sc_hd__buf_1
XFILLER_0_43_365 VPWR VGND VPWR VGND sky130_ef_sc_hd__decap_12
X_3637_ RF0.regs\[5\]\[7\] _0961_ _1139_ VGND VGND VPWR VPWR _1824_ sky130_fd_sc_hd__and3_1
X_3568_ RF0.regs\[5\]\[13\] _0961_ _1139_ VGND VGND VPWR VPWR _1760_ sky130_fd_sc_hd__and3_1
XFILLER_0_3_473 VPWR VGND VPWR VGND sky130_ef_sc_hd__decap_12
X_2519_ _0810_ VGND VGND VPWR VPWR _0811_ sky130_fd_sc_hd__clkbuf_4
X_5307_ clknet_leaf_38_clk _0683_ _0299_ VGND VGND VPWR VPWR RF0.regs\[2\]\[2\] sky130_fd_sc_hd__dfrtp_1
X_3499_ RF0.regs\[5\]\[19\] _0866_ _1228_ RF0.regs\[15\]\[19\] VGND VGND VPWR VPWR
+ _1692_ sky130_fd_sc_hd__a22o_1
X_5238_ clknet_leaf_0_clk _0614_ _0230_ VGND VGND VPWR VPWR RF0.regs\[6\]\[29\] sky130_fd_sc_hd__dfrtp_1
X_5169_ clknet_leaf_5_clk _0545_ _0161_ VGND VGND VPWR VPWR RF0.regs\[10\]\[24\] sky130_fd_sc_hd__dfrtp_1
XTAP_TAPCELL_ROW_39_541 VGND VPWR sky130_fd_sc_hd__tapvpwrvgnd_1
XFILLER_0_66_402 VGND VGND VPWR VPWR sky130_fd_sc_hd__decap_8
XFILLER_0_38_137 VGND VGND VPWR VPWR sky130_fd_sc_hd__decap_3
XFILLER_0_38_159 VGND VGND VPWR VPWR sky130_fd_sc_hd__fill_1
XFILLER_0_81_438 VGND VGND VPWR VPWR sky130_fd_sc_hd__decap_8
XFILLER_0_81_449 VPWR VGND VPWR VGND sky130_ef_sc_hd__decap_12
XFILLER_0_22_516 VGND VGND VPWR VPWR sky130_fd_sc_hd__fill_1
XFILLER_0_61_184 VGND VGND VPWR VPWR sky130_fd_sc_hd__decap_4
XFILLER_0_55_39 VPWR VGND VPWR VGND sky130_ef_sc_hd__decap_12
XTAP_TAPCELL_ROW_73_842 VGND VPWR sky130_fd_sc_hd__tapvpwrvgnd_1
XFILLER_0_71_27 VGND VGND VPWR VPWR sky130_fd_sc_hd__decap_8
X_2870_ _1135_ VGND VGND VPWR VPWR _0750_ sky130_fd_sc_hd__clkbuf_1
XFILLER_0_72_449 VGND VGND VPWR VPWR sky130_fd_sc_hd__fill_2
Xclkbuf_leaf_10_clk clknet_2_1__leaf_clk VGND VGND VPWR VPWR clknet_leaf_10_clk sky130_fd_sc_hd__clkbuf_8
XFILLER_0_13_505 VPWR VGND VPWR VGND sky130_ef_sc_hd__decap_12
X_4540_ _2421_ VGND VGND VPWR VPWR net13 sky130_fd_sc_hd__clkbuf_1
X_4471_ _2374_ VGND VGND VPWR VPWR _0402_ sky130_fd_sc_hd__clkbuf_1
XFILLER_0_0_421 VPWR VGND VPWR VGND sky130_ef_sc_hd__decap_12
X_3422_ _1614_ VGND VGND VPWR VPWR _1616_ sky130_fd_sc_hd__inv_2
X_3353_ _1256_ _1341_ VGND VGND VPWR VPWR _1549_ sky130_fd_sc_hd__xnor2_1
X_3284_ _1477_ _1479_ VGND VGND VPWR VPWR _1480_ sky130_fd_sc_hd__xor2_1
X_5023_ clknet_leaf_37_clk _0399_ _0015_ VGND VGND VPWR VPWR RF0.regs\[25\]\[6\] sky130_fd_sc_hd__dfrtp_1
XTAP_TAPCELL_ROW_36_511 VGND VPWR sky130_fd_sc_hd__tapvpwrvgnd_1
XFILLER_0_0_41 VPWR VGND VPWR VGND sky130_ef_sc_hd__decap_12
XFILLER_0_0_85 VPWR VGND VPWR VGND sky130_ef_sc_hd__decap_12
X_4807_ _2462_ VGND VGND VPWR VPWR _2468_ sky130_fd_sc_hd__buf_4
XPHY_EDGE_ROW_3_Right_3 VGND VGND VPWR VPWR sky130_fd_sc_hd__decap_3
X_2999_ net270 VGND VGND VPWR VPWR _1205_ sky130_fd_sc_hd__clkbuf_1
XFILLER_0_63_449 VGND VGND VPWR VPWR sky130_fd_sc_hd__decap_6
X_4738_ _2459_ VGND VGND VPWR VPWR _0150_ sky130_fd_sc_hd__inv_2
XFILLER_0_16_365 VGND VGND VPWR VPWR sky130_fd_sc_hd__decap_8
XFILLER_0_31_335 VGND VGND VPWR VPWR sky130_fd_sc_hd__fill_1
X_4669_ _2447_ VGND VGND VPWR VPWR _2450_ sky130_fd_sc_hd__clkbuf_8
XTAP_TAPCELL_ROW_8_258 VGND VPWR sky130_fd_sc_hd__tapvpwrvgnd_1
XTAP_TAPCELL_ROW_87_978 VGND VPWR sky130_fd_sc_hd__tapvpwrvgnd_1
XTAP_TAPCELL_ROW_70_823 VGND VPWR sky130_fd_sc_hd__tapvpwrvgnd_1
XTAP_TAPCELL_ROW_42_569 VGND VPWR sky130_fd_sc_hd__tapvpwrvgnd_1
XFILLER_0_81_246 VGND VGND VPWR VPWR sky130_fd_sc_hd__decap_8
XFILLER_0_81_279 VGND VGND VPWR VPWR sky130_fd_sc_hd__fill_1
XFILLER_0_62_493 VPWR VGND VPWR VGND sky130_ef_sc_hd__decap_12
XFILLER_0_1_218 VGND VGND VPWR VPWR sky130_fd_sc_hd__decap_6
XFILLER_0_22_368 VPWR VGND VPWR VGND sky130_ef_sc_hd__decap_12
XFILLER_0_82_15 VPWR VGND VPWR VGND sky130_ef_sc_hd__decap_12
X_3971_ _2112_ VGND VGND VPWR VPWR _0639_ sky130_fd_sc_hd__clkbuf_1
XFILLER_0_9_307 VGND VGND VPWR VPWR sky130_fd_sc_hd__fill_2
XFILLER_0_57_221 VGND VGND VPWR VPWR sky130_fd_sc_hd__decap_3
X_2922_ _1166_ VGND VGND VPWR VPWR _0729_ sky130_fd_sc_hd__clkbuf_1
XFILLER_0_45_416 VGND VGND VPWR VPWR sky130_fd_sc_hd__decap_6
X_2853_ _1118_ net173 VGND VGND VPWR VPWR _1127_ sky130_fd_sc_hd__and2_1
X_2784_ _1059_ _1061_ _1066_ _1068_ _1075_ VGND VGND VPWR VPWR _1076_ sky130_fd_sc_hd__a221o_1
X_4523_ _2404_ _2401_ _2410_ _2398_ VGND VGND VPWR VPWR _0001_ sky130_fd_sc_hd__o211a_1
Xhold225 RF0.regs\[12\]\[5\] VGND VGND VPWR VPWR net273 sky130_fd_sc_hd__dlygate4sd3_1
XFILLER_0_40_121 VGND VGND VPWR VPWR sky130_fd_sc_hd__decap_4
Xhold203 RF0.regs\[6\]\[11\] VGND VGND VPWR VPWR net251 sky130_fd_sc_hd__dlygate4sd3_1
Xhold214 RF0.regs\[6\]\[24\] VGND VGND VPWR VPWR net262 sky130_fd_sc_hd__dlygate4sd3_1
XFILLER_0_40_176 VPWR VGND VPWR VGND sky130_ef_sc_hd__decap_12
X_4454_ _2365_ VGND VGND VPWR VPWR _0410_ sky130_fd_sc_hd__clkbuf_1
X_4385_ _2329_ VGND VGND VPWR VPWR _0443_ sky130_fd_sc_hd__clkbuf_1
XFILLER_0_21_390 VGND VGND VPWR VPWR sky130_fd_sc_hd__fill_2
X_3405_ RF0.regs\[4\]\[26\] _1241_ _1229_ RF0.regs\[15\]\[26\] _1598_ VGND VGND VPWR
+ VPWR _1599_ sky130_fd_sc_hd__a221o_1
X_3336_ _1504_ _1509_ _1524_ _1528_ _1531_ VGND VGND VPWR VPWR _1532_ sky130_fd_sc_hd__o311a_1
X_5006_ _2436_ VGND VGND VPWR VPWR _0389_ sky130_fd_sc_hd__inv_2
X_3267_ _1462_ _1362_ VGND VGND VPWR VPWR _1463_ sky130_fd_sc_hd__nor2_1
X_3198_ _1280_ _1392_ _1278_ _1393_ VGND VGND VPWR VPWR _1394_ sky130_fd_sc_hd__a22o_1
XTAP_TAPCELL_ROW_84_948 VGND VPWR sky130_fd_sc_hd__tapvpwrvgnd_1
XFILLER_0_36_405 VGND VGND VPWR VPWR sky130_fd_sc_hd__decap_3
XFILLER_0_36_416 VGND VGND VPWR VPWR sky130_fd_sc_hd__decap_4
XFILLER_0_63_246 VPWR VGND VPWR VGND sky130_ef_sc_hd__decap_12
XFILLER_0_16_184 VGND VGND VPWR VPWR sky130_fd_sc_hd__fill_1
XFILLER_0_16_195 VGND VGND VPWR VPWR sky130_fd_sc_hd__fill_1
XFILLER_0_31_187 VGND VGND VPWR VPWR sky130_fd_sc_hd__decap_3
XTAP_TAPCELL_ROW_55_683 VGND VPWR sky130_fd_sc_hd__tapvpwrvgnd_1
XFILLER_0_27_449 VGND VGND VPWR VPWR sky130_fd_sc_hd__decap_6
XFILLER_0_50_430 VGND VGND VPWR VPWR sky130_fd_sc_hd__decap_4
XFILLER_0_77_15 VPWR VGND VPWR VGND sky130_ef_sc_hd__decap_12
XFILLER_0_10_305 VGND VGND VPWR VPWR sky130_fd_sc_hd__decap_3
X_4170_ RF0.regs\[10\]\[25\] _1978_ _2211_ VGND VGND VPWR VPWR _2218_ sky130_fd_sc_hd__mux2_1
X_3121_ _1062_ _1065_ _1316_ _1258_ VGND VGND VPWR VPWR _1317_ sky130_fd_sc_hd__o31a_1
XTAP_TAPCELL_ROW_2_209 VGND VPWR sky130_fd_sc_hd__tapvpwrvgnd_1
XFILLER_0_26_41 VGND VGND VPWR VPWR sky130_fd_sc_hd__fill_2
X_3052_ RF0.regs\[25\]\[31\] _0807_ _1014_ _1247_ VGND VGND VPWR VPWR _1248_ sky130_fd_sc_hd__a211o_1
XFILLER_0_77_305 VGND VGND VPWR VPWR sky130_fd_sc_hd__decap_8
XTAP_TAPCELL_ROW_81_918 VGND VPWR sky130_fd_sc_hd__tapvpwrvgnd_1
XTAP_TAPCELL_ROW_18_352 VGND VPWR sky130_fd_sc_hd__tapvpwrvgnd_1
X_3954_ RF0.regs\[5\]\[30\] _1957_ _2102_ VGND VGND VPWR VPWR _2104_ sky130_fd_sc_hd__mux2_1
XFILLER_0_85_393 VPWR VGND VPWR VGND sky130_ef_sc_hd__decap_12
X_3885_ _1823_ _2050_ VGND VGND VPWR VPWR _2051_ sky130_fd_sc_hd__nand2_1
X_2905_ net128 VGND VGND VPWR VPWR _1158_ sky130_fd_sc_hd__clkbuf_1
X_2836_ _1117_ VGND VGND VPWR VPWR _1118_ sky130_fd_sc_hd__clkbuf_2
X_2767_ RF0.regs\[2\]\[20\] _0878_ _1057_ _1058_ VGND VGND VPWR VPWR _1059_ sky130_fd_sc_hd__a211o_1
XFILLER_0_41_430 VGND VGND VPWR VPWR sky130_fd_sc_hd__decap_4
XFILLER_0_77_3 VPWR VGND VPWR VGND sky130_ef_sc_hd__decap_12
XFILLER_0_13_165 VGND VGND VPWR VPWR sky130_fd_sc_hd__decap_3
X_2698_ RF0.regs\[5\]\[3\] _0876_ _0856_ RF0.regs\[15\]\[3\] VGND VGND VPWR VPWR _0990_
+ sky130_fd_sc_hd__a22o_1
XFILLER_0_41_463 VGND VGND VPWR VPWR sky130_fd_sc_hd__fill_1
X_4506_ disp.digits\[10\] _2386_ _2387_ disp.digits\[14\] VGND VGND VPWR VPWR _2395_
+ sky130_fd_sc_hd__a22o_1
X_4437_ _2356_ VGND VGND VPWR VPWR _0418_ sky130_fd_sc_hd__clkbuf_1
X_4368_ _2320_ VGND VGND VPWR VPWR _0451_ sky130_fd_sc_hd__clkbuf_1
X_4299_ _2284_ VGND VGND VPWR VPWR _0484_ sky130_fd_sc_hd__clkbuf_1
X_3319_ _1025_ _1514_ VGND VGND VPWR VPWR _1515_ sky130_fd_sc_hd__xnor2_1
XTAP_TAPCELL_ROW_52_653 VGND VPWR sky130_fd_sc_hd__tapvpwrvgnd_1
XFILLER_0_8_192 VGND VGND VPWR VPWR sky130_fd_sc_hd__decap_4
XFILLER_0_32_485 VGND VGND VPWR VPWR sky130_fd_sc_hd__decap_6
XFILLER_0_63_39 VPWR VGND VPWR VGND sky130_ef_sc_hd__decap_12
XTAP_TAPCELL_ROW_15_322 VGND VPWR sky130_fd_sc_hd__tapvpwrvgnd_1
XFILLER_0_82_352 VPWR VGND VPWR VGND sky130_ef_sc_hd__decap_12
X_3670_ RF0.regs\[7\]\[4\] _1243_ VGND VGND VPWR VPWR _1856_ sky130_fd_sc_hd__and2_1
XFILLER_0_12_65 VPWR VGND VPWR VGND sky130_ef_sc_hd__decap_12
X_2621_ RF0.regs\[10\]\[7\] _0809_ _0827_ RF0.regs\[25\]\[7\] VGND VGND VPWR VPWR
+ _0913_ sky130_fd_sc_hd__a22o_1
X_5340_ clknet_leaf_35_clk _0716_ _0332_ VGND VGND VPWR VPWR RF0.regs\[0\]\[3\] sky130_fd_sc_hd__dfrtp_1
X_2552_ _0843_ VGND VGND VPWR VPWR _0844_ sky130_fd_sc_hd__clkbuf_4
X_5271_ clknet_leaf_45_clk _0647_ _0263_ VGND VGND VPWR VPWR RF0.regs\[5\]\[30\] sky130_fd_sc_hd__dfrtp_1
X_4222_ RF0.regs\[10\]\[0\] VGND VGND VPWR VPWR _2245_ sky130_fd_sc_hd__clkbuf_1
X_4153_ net155 VGND VGND VPWR VPWR _2209_ sky130_fd_sc_hd__clkbuf_1
X_4084_ RF0.regs\[10\]\[0\] _0817_ _1225_ RF0.regs\[25\]\[0\] VGND VGND VPWR VPWR
+ _2172_ sky130_fd_sc_hd__a22o_1
X_3104_ _1266_ _1269_ net46 VGND VGND VPWR VPWR _1300_ sky130_fd_sc_hd__or3b_4
X_3035_ _1230_ VGND VGND VPWR VPWR _1231_ sky130_fd_sc_hd__clkbuf_4
XFILLER_0_77_113 VGND VGND VPWR VPWR sky130_fd_sc_hd__fill_1
X_4986_ _2487_ VGND VGND VPWR VPWR _0370_ sky130_fd_sc_hd__inv_2
XFILLER_0_46_500 VPWR VGND VPWR VGND sky130_ef_sc_hd__decap_12
XFILLER_0_58_360 VGND VGND VPWR VPWR sky130_fd_sc_hd__decap_4
X_3937_ RF0.regs\[4\]\[4\] _2092_ _2073_ VGND VGND VPWR VPWR _2093_ sky130_fd_sc_hd__mux2_1
XFILLER_0_58_371 VGND VGND VPWR VPWR sky130_fd_sc_hd__decap_8
X_3868_ _1008_ _1869_ _1870_ VGND VGND VPWR VPWR _2035_ sky130_fd_sc_hd__and3_1
X_2819_ _1108_ net184 VGND VGND VPWR VPWR _1109_ sky130_fd_sc_hd__and2_1
X_3799_ RF0.regs\[4\]\[25\] _1978_ _1953_ VGND VGND VPWR VPWR _1979_ sky130_fd_sc_hd__mux2_1
XFILLER_0_5_195 VGND VGND VPWR VPWR sky130_fd_sc_hd__fill_2
XTAP_TAPCELL_ROW_57_701 VGND VPWR sky130_fd_sc_hd__tapvpwrvgnd_1
XTAP_TAPCELL_ROW_29_447 VGND VPWR sky130_fd_sc_hd__tapvpwrvgnd_1
XFILLER_0_68_102 VPWR VGND VPWR VGND sky130_ef_sc_hd__decap_12
XPHY_EDGE_ROW_1_Left_89 VGND VGND VPWR VPWR sky130_fd_sc_hd__decap_3
XFILLER_0_83_105 VGND VGND VPWR VPWR sky130_fd_sc_hd__decap_6
XFILLER_0_49_393 VPWR VGND VPWR VGND sky130_ef_sc_hd__decap_12
XFILLER_0_20_400 VGND VGND VPWR VPWR sky130_fd_sc_hd__fill_1
XFILLER_0_20_433 VGND VGND VPWR VPWR sky130_fd_sc_hd__decap_8
XFILLER_0_20_455 VGND VGND VPWR VPWR sky130_fd_sc_hd__fill_1
XFILLER_0_20_477 VPWR VGND VPWR VGND sky130_ef_sc_hd__decap_12
XFILLER_0_74_27 VGND VGND VPWR VPWR sky130_fd_sc_hd__fill_1
XFILLER_0_87_433 VPWR VGND VPWR VGND sky130_ef_sc_hd__decap_12
XFILLER_0_87_477 VPWR VGND VPWR VGND sky130_ef_sc_hd__decap_12
X_4840_ reset VGND VGND VPWR VPWR _2471_ sky130_fd_sc_hd__clkbuf_4
XTAP_TAPCELL_ROW_63_759 VGND VPWR sky130_fd_sc_hd__tapvpwrvgnd_1
X_4771_ _2464_ VGND VGND VPWR VPWR _0178_ sky130_fd_sc_hd__inv_2
X_3722_ _0797_ _1831_ _1832_ _1829_ VGND VGND VPWR VPWR _1908_ sky130_fd_sc_hd__or4bb_1
XFILLER_0_43_514 VGND VGND VPWR VPWR sky130_fd_sc_hd__decap_3
XFILLER_0_82_182 VGND VGND VPWR VPWR sky130_fd_sc_hd__fill_2
XFILLER_0_70_333 VGND VGND VPWR VPWR sky130_fd_sc_hd__fill_1
X_3653_ RF0.regs\[0\]\[6\] _1216_ _1836_ _1838_ VGND VGND VPWR VPWR _1839_ sky130_fd_sc_hd__o22ai_4
X_2604_ RF0.regs\[10\]\[18\] _0884_ VGND VGND VPWR VPWR _0896_ sky130_fd_sc_hd__and2_1
X_3584_ _1771_ _1772_ _1774_ _1217_ RF0.regs\[0\]\[12\] VGND VGND VPWR VPWR _1775_
+ sky130_fd_sc_hd__o32a_1
X_5323_ clknet_leaf_13_clk _0699_ _0315_ VGND VGND VPWR VPWR RF0.regs\[2\]\[18\] sky130_fd_sc_hd__dfrtp_1
X_2535_ _0826_ VGND VGND VPWR VPWR _0827_ sky130_fd_sc_hd__buf_2
X_5254_ clknet_leaf_20_clk _0630_ _0246_ VGND VGND VPWR VPWR RF0.regs\[5\]\[13\] sky130_fd_sc_hd__dfrtp_1
X_5185_ clknet_leaf_30_clk _0561_ _0177_ VGND VGND VPWR VPWR RF0.regs\[7\]\[8\] sky130_fd_sc_hd__dfrtp_1
X_4205_ _2236_ VGND VGND VPWR VPWR _0530_ sky130_fd_sc_hd__clkbuf_1
XFILLER_0_48_94 VPWR VGND VPWR VGND sky130_ef_sc_hd__decap_12
X_4136_ _2200_ VGND VGND VPWR VPWR _0563_ sky130_fd_sc_hd__clkbuf_1
X_4067_ _2163_ VGND VGND VPWR VPWR _0594_ sky130_fd_sc_hd__clkbuf_1
X_3018_ _1214_ VGND VGND VPWR VPWR _0681_ sky130_fd_sc_hd__clkbuf_1
XFILLER_0_78_477 VPWR VGND VPWR VGND sky130_ef_sc_hd__decap_12
XFILLER_0_19_500 VGND VGND VPWR VPWR sky130_fd_sc_hd__decap_4
XFILLER_0_65_105 VGND VGND VPWR VPWR sky130_fd_sc_hd__decap_6
XTAP_TAPCELL_ROW_34_494 VGND VPWR sky130_fd_sc_hd__tapvpwrvgnd_1
X_4969_ _2485_ VGND VGND VPWR VPWR _0355_ sky130_fd_sc_hd__inv_2
XFILLER_0_80_108 VPWR VGND VPWR VGND sky130_ef_sc_hd__decap_12
XFILLER_0_14_260 VPWR VGND VPWR VGND sky130_ef_sc_hd__decap_12
XFILLER_0_69_411 VPWR VGND VPWR VGND sky130_ef_sc_hd__decap_12
XFILLER_0_56_105 VGND VGND VPWR VPWR sky130_fd_sc_hd__fill_1
XFILLER_0_69_499 VGND VGND VPWR VPWR sky130_fd_sc_hd__decap_4
XTAP_TAPCELL_ROW_60_729 VGND VPWR sky130_fd_sc_hd__tapvpwrvgnd_1
XFILLER_0_84_469 VGND VGND VPWR VPWR sky130_fd_sc_hd__decap_6
XFILLER_0_4_419 VGND VGND VPWR VPWR sky130_fd_sc_hd__fill_1
XFILLER_0_52_333 VPWR VGND VPWR VGND sky130_ef_sc_hd__decap_12
XFILLER_0_69_27 VGND VGND VPWR VPWR sky130_fd_sc_hd__decap_4
XFILLER_0_52_377 VGND VGND VPWR VPWR sky130_fd_sc_hd__decap_4
XFILLER_0_85_15 VPWR VGND VPWR VGND sky130_ef_sc_hd__decap_12
XTAP_TAPCELL_ROW_76_873 VGND VPWR sky130_fd_sc_hd__tapvpwrvgnd_1
X_4823_ _2469_ VGND VGND VPWR VPWR _0225_ sky130_fd_sc_hd__inv_2
XFILLER_0_28_374 VPWR VGND VPWR VGND sky130_ef_sc_hd__decap_12
X_4754_ _2457_ VGND VGND VPWR VPWR _2461_ sky130_fd_sc_hd__clkbuf_2
XFILLER_0_7_279 VGND VGND VPWR VPWR sky130_fd_sc_hd__fill_1
X_3705_ _1398_ _1890_ VGND VGND VPWR VPWR _1891_ sky130_fd_sc_hd__or2b_1
XTAP_TAPCELL_ROW_31_464 VGND VPWR sky130_fd_sc_hd__tapvpwrvgnd_1
XFILLER_0_70_141 VGND VGND VPWR VPWR sky130_fd_sc_hd__fill_1
X_4685_ _2452_ VGND VGND VPWR VPWR _0104_ sky130_fd_sc_hd__inv_2
XFILLER_0_43_377 VPWR VGND VPWR VGND sky130_ef_sc_hd__decap_12
XFILLER_0_3_441 VGND VGND VPWR VPWR sky130_fd_sc_hd__decap_6
X_3636_ _1820_ net32 VGND VGND VPWR VPWR _1823_ sky130_fd_sc_hd__xor2_2
XFILLER_0_3_485 VPWR VGND VPWR VGND sky130_ef_sc_hd__decap_12
X_3567_ _1757_ _1758_ VGND VGND VPWR VPWR _1759_ sky130_fd_sc_hd__nand2_2
X_5306_ clknet_leaf_39_clk _0682_ _0298_ VGND VGND VPWR VPWR RF0.regs\[2\]\[1\] sky130_fd_sc_hd__dfrtp_1
X_2518_ _0809_ VGND VGND VPWR VPWR _0810_ sky130_fd_sc_hd__clkbuf_4
X_3498_ _1689_ _1690_ VGND VGND VPWR VPWR _1691_ sky130_fd_sc_hd__and2b_2
X_5237_ clknet_leaf_0_clk _0613_ _0229_ VGND VGND VPWR VPWR RF0.regs\[6\]\[28\] sky130_fd_sc_hd__dfrtp_1
X_5168_ clknet_leaf_8_clk _0544_ _0160_ VGND VGND VPWR VPWR RF0.regs\[10\]\[23\] sky130_fd_sc_hd__dfrtp_4
X_4119_ net97 VGND VGND VPWR VPWR _2192_ sky130_fd_sc_hd__clkbuf_1
X_5099_ clknet_leaf_13_clk _0475_ _0091_ VGND VGND VPWR VPWR RF0.regs\[15\]\[18\]
+ sky130_fd_sc_hd__dfrtp_1
XTAP_TAPCELL_ROW_39_542 VGND VPWR sky130_fd_sc_hd__tapvpwrvgnd_1
XFILLER_0_78_241 VGND VGND VPWR VPWR sky130_fd_sc_hd__fill_1
XFILLER_0_53_119 VPWR VGND VPWR VGND sky130_ef_sc_hd__decap_12
XFILLER_0_19_396 VPWR VGND VPWR VGND sky130_ef_sc_hd__decap_12
XTAP_TAPCELL_ROW_73_843 VGND VPWR sky130_fd_sc_hd__tapvpwrvgnd_1
XPHY_EDGE_ROW_4_Left_92 VGND VGND VPWR VPWR sky130_fd_sc_hd__decap_3
XFILLER_0_44_108 VGND VGND VPWR VPWR sky130_fd_sc_hd__decap_3
XFILLER_0_4_205 VPWR VGND VPWR VGND sky130_ef_sc_hd__decap_12
XFILLER_0_37_193 VGND VGND VPWR VPWR sky130_fd_sc_hd__decap_4
XFILLER_0_25_366 VGND VGND VPWR VPWR sky130_fd_sc_hd__fill_1
XFILLER_0_52_141 VGND VGND VPWR VPWR sky130_fd_sc_hd__decap_6
X_4470_ RF0.regs\[25\]\[9\] _2080_ _2371_ VGND VGND VPWR VPWR _2374_ sky130_fd_sc_hd__mux2_1
X_3421_ _0798_ _1609_ _1614_ VGND VGND VPWR VPWR _1615_ sky130_fd_sc_hd__o21a_1
XFILLER_0_0_433 VPWR VGND VPWR VGND sky130_ef_sc_hd__decap_12
X_3352_ _1545_ _1347_ _1546_ _1547_ VGND VGND VPWR VPWR _1548_ sky130_fd_sc_hd__a211o_1
XFILLER_0_0_477 VPWR VGND VPWR VGND sky130_ef_sc_hd__decap_12
X_3283_ _1310_ _1478_ _1308_ VGND VGND VPWR VPWR _1479_ sky130_fd_sc_hd__mux2_1
X_5022_ clknet_leaf_37_clk _0398_ _0014_ VGND VGND VPWR VPWR RF0.regs\[25\]\[5\] sky130_fd_sc_hd__dfrtp_1
XFILLER_0_45_51 VGND VGND VPWR VPWR sky130_fd_sc_hd__fill_2
XTAP_TAPCELL_ROW_36_512 VGND VPWR sky130_fd_sc_hd__tapvpwrvgnd_1
XFILLER_0_75_222 VGND VGND VPWR VPWR sky130_fd_sc_hd__fill_2
XFILLER_0_75_244 VPWR VGND VPWR VGND sky130_ef_sc_hd__decap_12
XFILLER_0_0_53 VGND VGND VPWR VPWR sky130_fd_sc_hd__decap_3
XFILLER_0_0_97 VPWR VGND VPWR VGND sky130_ef_sc_hd__decap_12
X_4806_ _2467_ VGND VGND VPWR VPWR _0210_ sky130_fd_sc_hd__inv_2
XFILLER_0_63_406 VGND VGND VPWR VPWR sky130_fd_sc_hd__fill_2
X_2998_ _1204_ VGND VGND VPWR VPWR _0691_ sky130_fd_sc_hd__clkbuf_1
XFILLER_0_56_480 VPWR VGND VPWR VGND sky130_ef_sc_hd__decap_12
XFILLER_0_9_51 VGND VGND VPWR VPWR sky130_fd_sc_hd__decap_4
X_4737_ _2459_ VGND VGND VPWR VPWR _0149_ sky130_fd_sc_hd__inv_2
X_4668_ _2449_ VGND VGND VPWR VPWR _0090_ sky130_fd_sc_hd__inv_2
X_3619_ RF0.regs\[4\]\[9\] _1238_ _1231_ RF0.regs\[6\]\[9\] _1807_ VGND VGND VPWR
+ VPWR _1808_ sky130_fd_sc_hd__a221o_1
X_4599_ _2440_ VGND VGND VPWR VPWR _0030_ sky130_fd_sc_hd__inv_2
XTAP_TAPCELL_ROW_8_259 VGND VPWR sky130_fd_sc_hd__tapvpwrvgnd_1
XTAP_TAPCELL_ROW_87_979 VGND VPWR sky130_fd_sc_hd__tapvpwrvgnd_1
XTAP_TAPCELL_ROW_87_968 VGND VPWR sky130_fd_sc_hd__tapvpwrvgnd_1
XFILLER_0_19_160 VGND VGND VPWR VPWR sky130_fd_sc_hd__fill_1
XFILLER_0_34_141 VPWR VGND VPWR VGND sky130_ef_sc_hd__decap_12
XPHY_EDGE_ROW_13_Right_13 VGND VGND VPWR VPWR sky130_fd_sc_hd__decap_3
XFILLER_0_82_27 VGND VGND VPWR VPWR sky130_fd_sc_hd__fill_1
X_3970_ RF0.regs\[5\]\[22\] _1988_ _2102_ VGND VGND VPWR VPWR _2112_ sky130_fd_sc_hd__mux2_1
X_2921_ net110 VGND VGND VPWR VPWR _1166_ sky130_fd_sc_hd__clkbuf_1
X_2852_ _1126_ VGND VGND VPWR VPWR _0759_ sky130_fd_sc_hd__clkbuf_1
XFILLER_0_5_503 VGND VGND VPWR VPWR sky130_fd_sc_hd__fill_1
XFILLER_0_38_480 VGND VGND VPWR VPWR sky130_fd_sc_hd__decap_6
XFILLER_0_57_299 VPWR VGND VPWR VGND sky130_ef_sc_hd__decap_12
XPHY_EDGE_ROW_22_Right_22 VGND VGND VPWR VPWR sky130_fd_sc_hd__decap_3
X_2783_ _0917_ _0920_ _1072_ _1074_ VGND VGND VPWR VPWR _1075_ sky130_fd_sc_hd__a2bb2o_1
X_4522_ _2404_ _2409_ VGND VGND VPWR VPWR _2410_ sky130_fd_sc_hd__nand2_1
XFILLER_0_31_97 VGND VGND VPWR VPWR sky130_fd_sc_hd__decap_4
Xhold204 RF0.regs\[6\]\[19\] VGND VGND VPWR VPWR net252 sky130_fd_sc_hd__dlygate4sd3_1
Xhold226 RF0.regs\[6\]\[25\] VGND VGND VPWR VPWR net274 sky130_fd_sc_hd__dlygate4sd3_1
X_4453_ RF0.regs\[25\]\[17\] _2005_ _2360_ VGND VGND VPWR VPWR _2365_ sky130_fd_sc_hd__mux2_1
Xhold215 RF0.regs\[6\]\[4\] VGND VGND VPWR VPWR net263 sky130_fd_sc_hd__dlygate4sd3_1
X_3404_ RF0.regs\[5\]\[26\] _0867_ _1233_ RF0.regs\[6\]\[26\] VGND VGND VPWR VPWR
+ _1598_ sky130_fd_sc_hd__a22o_1
X_4384_ net258 _2002_ _2325_ VGND VGND VPWR VPWR _2329_ sky130_fd_sc_hd__mux2_1
XFILLER_0_40_188 VGND VGND VPWR VPWR sky130_fd_sc_hd__fill_2
X_3335_ _1530_ _1503_ VGND VGND VPWR VPWR _1531_ sky130_fd_sc_hd__or2_1
XPHY_EDGE_ROW_31_Right_31 VGND VGND VPWR VPWR sky130_fd_sc_hd__decap_3
X_3266_ _0937_ VGND VGND VPWR VPWR _1462_ sky130_fd_sc_hd__inv_2
X_5005_ _2436_ VGND VGND VPWR VPWR _0388_ sky130_fd_sc_hd__inv_2
XFILLER_0_22_3 VPWR VGND VPWR VGND sky130_ef_sc_hd__decap_12
X_3197_ _1263_ _1280_ _1281_ VGND VGND VPWR VPWR _1393_ sky130_fd_sc_hd__o21ai_2
XTAP_TAPCELL_ROW_84_949 VGND VPWR sky130_fd_sc_hd__tapvpwrvgnd_1
XFILLER_0_72_60 VPWR VGND VPWR VGND sky130_ef_sc_hd__decap_12
XFILLER_0_48_244 VGND VGND VPWR VPWR sky130_fd_sc_hd__decap_8
XPHY_EDGE_ROW_40_Right_40 VGND VGND VPWR VPWR sky130_fd_sc_hd__decap_3
XFILLER_0_63_225 VGND VGND VPWR VPWR sky130_fd_sc_hd__decap_3
XFILLER_0_16_141 VPWR VGND VPWR VGND sky130_ef_sc_hd__decap_12
XFILLER_0_63_258 VGND VGND VPWR VPWR sky130_fd_sc_hd__decap_3
XFILLER_0_31_111 VGND VGND VPWR VPWR sky130_fd_sc_hd__fill_1
XFILLER_0_86_306 VGND VGND VPWR VPWR sky130_fd_sc_hd__fill_2
XFILLER_0_39_200 VGND VGND VPWR VPWR sky130_fd_sc_hd__fill_2
XTAP_TAPCELL_ROW_55_684 VGND VPWR sky130_fd_sc_hd__tapvpwrvgnd_1
XFILLER_0_82_501 VPWR VGND VPWR VGND sky130_ef_sc_hd__decap_12
XTAP_TAPCELL_ROW_10_275 VGND VPWR sky130_fd_sc_hd__tapvpwrvgnd_1
XFILLER_0_77_27 VPWR VGND VPWR VGND sky130_ef_sc_hd__decap_12
XFILLER_0_10_317 VGND VGND VPWR VPWR sky130_fd_sc_hd__fill_2
X_3120_ RF0.regs\[2\]\[22\] _1238_ _0875_ RF0.regs\[5\]\[22\] _1063_ VGND VGND VPWR
+ VPWR _1316_ sky130_fd_sc_hd__a221o_1
X_3051_ _1246_ VGND VGND VPWR VPWR _1247_ sky130_fd_sc_hd__clkbuf_4
XTAP_TAPCELL_ROW_81_919 VGND VPWR sky130_fd_sc_hd__tapvpwrvgnd_1
XTAP_TAPCELL_ROW_18_353 VGND VPWR sky130_fd_sc_hd__tapvpwrvgnd_1
XFILLER_0_18_406 VPWR VGND VPWR VGND sky130_ef_sc_hd__decap_12
X_3953_ _2103_ VGND VGND VPWR VPWR _0648_ sky130_fd_sc_hd__clkbuf_1
X_3884_ _1148_ _1829_ _2026_ _2049_ VGND VGND VPWR VPWR _2050_ sky130_fd_sc_hd__a31o_1
XFILLER_0_42_85 VPWR VGND VPWR VGND sky130_ef_sc_hd__decap_12
XFILLER_0_45_225 VGND VGND VPWR VPWR sky130_fd_sc_hd__fill_1
X_2904_ _1157_ VGND VGND VPWR VPWR _0738_ sky130_fd_sc_hd__clkbuf_1
X_2835_ _1107_ VGND VGND VPWR VPWR _1117_ sky130_fd_sc_hd__clkbuf_2
XFILLER_0_13_100 VGND VGND VPWR VPWR sky130_fd_sc_hd__fill_1
X_2766_ RF0.regs\[10\]\[20\] _0884_ _0854_ RF0.regs\[15\]\[20\] VGND VGND VPWR VPWR
+ _1058_ sky130_fd_sc_hd__a22o_1
XFILLER_0_53_291 VGND VGND VPWR VPWR sky130_fd_sc_hd__fill_2
X_4505_ _2390_ _2393_ VGND VGND VPWR VPWR _2394_ sky130_fd_sc_hd__nand2_1
X_2697_ RF0.regs\[10\]\[3\] net55 net66 _0881_ VGND VGND VPWR VPWR _0989_ sky130_fd_sc_hd__and4_1
XFILLER_0_6_41 VPWR VGND VPWR VGND sky130_ef_sc_hd__decap_12
X_4436_ RF0.regs\[25\]\[25\] _1978_ _2349_ VGND VGND VPWR VPWR _2356_ sky130_fd_sc_hd__mux2_1
X_4367_ net212 _1975_ _2314_ VGND VGND VPWR VPWR _2320_ sky130_fd_sc_hd__mux2_1
XFILLER_0_6_85 VPWR VGND VPWR VGND sky130_ef_sc_hd__decap_12
X_3318_ _1315_ _1513_ _1312_ VGND VGND VPWR VPWR _1514_ sky130_fd_sc_hd__mux2_2
X_4298_ RF0.regs\[15\]\[27\] _1971_ _2279_ VGND VGND VPWR VPWR _2284_ sky130_fd_sc_hd__mux2_1
X_3249_ _0972_ _1444_ VGND VGND VPWR VPWR _1445_ sky130_fd_sc_hd__xor2_2
XFILLER_0_83_81 VPWR VGND VPWR VGND sky130_ef_sc_hd__decap_12
XTAP_TAPCELL_ROW_52_654 VGND VPWR sky130_fd_sc_hd__tapvpwrvgnd_1
XFILLER_0_32_475 VGND VGND VPWR VPWR sky130_fd_sc_hd__fill_1
XTAP_TAPCELL_ROW_15_323 VGND VPWR sky130_fd_sc_hd__tapvpwrvgnd_1
XFILLER_0_27_214 VGND VGND VPWR VPWR sky130_fd_sc_hd__fill_2
XFILLER_0_82_375 VGND VGND VPWR VPWR sky130_fd_sc_hd__decap_6
XFILLER_0_12_77 VGND VGND VPWR VPWR sky130_fd_sc_hd__decap_6
X_2620_ RF0.regs\[10\]\[7\] _0909_ _0856_ RF0.regs\[15\]\[7\] _0911_ VGND VGND VPWR
+ VPWR _0912_ sky130_fd_sc_hd__a221oi_2
XFILLER_0_23_453 VGND VGND VPWR VPWR sky130_fd_sc_hd__fill_1
X_2551_ _0842_ VGND VGND VPWR VPWR _0843_ sky130_fd_sc_hd__clkbuf_4
X_5270_ clknet_leaf_0_clk _0646_ _0262_ VGND VGND VPWR VPWR RF0.regs\[5\]\[29\] sky130_fd_sc_hd__dfrtp_1
X_4221_ _2244_ VGND VGND VPWR VPWR _0522_ sky130_fd_sc_hd__clkbuf_1
XFILLER_0_10_169 VGND VGND VPWR VPWR sky130_fd_sc_hd__fill_1
X_4152_ _2208_ VGND VGND VPWR VPWR _0555_ sky130_fd_sc_hd__clkbuf_1
X_4083_ _2171_ VGND VGND VPWR VPWR _0586_ sky130_fd_sc_hd__clkbuf_1
X_3103_ _1273_ _1298_ _1297_ VGND VGND VPWR VPWR _1299_ sky130_fd_sc_hd__nor3_2
X_3034_ _0800_ net55 net66 _0822_ VGND VGND VPWR VPWR _1230_ sky130_fd_sc_hd__and4_2
XTAP_TAPCELL_ROW_66_779 VGND VPWR sky130_fd_sc_hd__tapvpwrvgnd_1
X_4985_ _2487_ VGND VGND VPWR VPWR _0369_ sky130_fd_sc_hd__inv_2
XFILLER_0_18_203 VGND VGND VPWR VPWR sky130_fd_sc_hd__fill_1
X_3936_ _2033_ _1898_ VGND VGND VPWR VPWR _2092_ sky130_fd_sc_hd__xnor2_4
XFILLER_0_46_512 VGND VGND VPWR VPWR sky130_fd_sc_hd__fill_1
XFILLER_0_73_386 VGND VGND VPWR VPWR sky130_fd_sc_hd__decap_6
X_3867_ _1897_ _1867_ VGND VGND VPWR VPWR _2034_ sky130_fd_sc_hd__nor2_1
X_2818_ _1107_ VGND VGND VPWR VPWR _1108_ sky130_fd_sc_hd__clkbuf_2
XFILLER_0_26_291 VPWR VGND VPWR VGND sky130_ef_sc_hd__decap_12
X_3798_ _1618_ _1977_ VGND VGND VPWR VPWR _1978_ sky130_fd_sc_hd__xnor2_2
X_2749_ RF0.regs\[4\]\[8\] _0835_ _0843_ RF0.regs\[12\]\[8\] VGND VGND VPWR VPWR _1041_
+ sky130_fd_sc_hd__a22o_1
X_5399_ clknet_leaf_43_clk _0775_ _0391_ VGND VGND VPWR VPWR IM0.addr\[30\] sky130_fd_sc_hd__dfrtp_1
X_4419_ net175 _2099_ _1225_ VGND VGND VPWR VPWR _2347_ sky130_fd_sc_hd__mux2_1
XFILLER_0_1_391 VGND VGND VPWR VPWR sky130_fd_sc_hd__fill_1
XTAP_TAPCELL_ROW_57_702 VGND VPWR sky130_fd_sc_hd__tapvpwrvgnd_1
XTAP_TAPCELL_ROW_29_448 VGND VPWR sky130_fd_sc_hd__tapvpwrvgnd_1
XFILLER_0_68_114 VPWR VGND VPWR VGND sky130_ef_sc_hd__decap_12
XFILLER_0_56_309 VGND VGND VPWR VPWR sky130_fd_sc_hd__fill_1
XFILLER_0_24_217 VGND VGND VPWR VPWR sky130_fd_sc_hd__fill_1
XFILLER_0_52_515 VGND VGND VPWR VPWR sky130_fd_sc_hd__fill_2
XFILLER_0_24_228 VGND VGND VPWR VPWR sky130_fd_sc_hd__fill_1
XTAP_TAPCELL_ROW_20_370 VGND VPWR sky130_fd_sc_hd__tapvpwrvgnd_1
XFILLER_0_20_412 VGND VGND VPWR VPWR sky130_fd_sc_hd__fill_1
XFILLER_0_20_489 VGND VGND VPWR VPWR sky130_fd_sc_hd__decap_8
XFILLER_0_87_445 VGND VGND VPWR VPWR sky130_fd_sc_hd__decap_3
XFILLER_0_87_489 VPWR VGND VPWR VGND sky130_ef_sc_hd__decap_12
XFILLER_0_59_169 VGND VGND VPWR VPWR sky130_fd_sc_hd__fill_1
X_4770_ _2464_ VGND VGND VPWR VPWR _0177_ sky130_fd_sc_hd__inv_2
XFILLER_0_70_301 VGND VGND VPWR VPWR sky130_fd_sc_hd__decap_4
X_3721_ _1842_ _1905_ _1906_ VGND VGND VPWR VPWR _1907_ sky130_fd_sc_hd__o21a_1
X_3652_ RF0.regs\[5\]\[6\] _0865_ _1243_ RF0.regs\[7\]\[6\] _1837_ VGND VGND VPWR
+ VPWR _1838_ sky130_fd_sc_hd__a221o_1
X_2603_ RF0.regs\[2\]\[29\] _0879_ _0893_ _0894_ VGND VGND VPWR VPWR _0895_ sky130_fd_sc_hd__a211o_1
X_3583_ RF0.regs\[5\]\[12\] _0865_ _1223_ RF0.regs\[20\]\[12\] _1773_ VGND VGND VPWR
+ VPWR _1774_ sky130_fd_sc_hd__a221o_1
XFILLER_0_23_261 VPWR VGND VPWR VGND sky130_ef_sc_hd__decap_12
X_2534_ _0818_ _0825_ VGND VGND VPWR VPWR _0826_ sky130_fd_sc_hd__nor2_2
X_5322_ clknet_leaf_15_clk _0698_ _0314_ VGND VGND VPWR VPWR RF0.regs\[2\]\[17\] sky130_fd_sc_hd__dfrtp_1
X_5253_ clknet_leaf_24_clk _0629_ _0245_ VGND VGND VPWR VPWR RF0.regs\[5\]\[12\] sky130_fd_sc_hd__dfrtp_1
X_5184_ clknet_leaf_30_clk _0560_ _0176_ VGND VGND VPWR VPWR RF0.regs\[7\]\[7\] sky130_fd_sc_hd__dfrtp_1
X_4204_ RF0.regs\[10\]\[9\] _2080_ _2233_ VGND VGND VPWR VPWR _2236_ sky130_fd_sc_hd__mux2_1
X_4135_ net92 VGND VGND VPWR VPWR _2200_ sky130_fd_sc_hd__clkbuf_1
X_4066_ _2080_ net194 _2160_ VGND VGND VPWR VPWR _2163_ sky130_fd_sc_hd__mux2_1
X_3017_ net157 VGND VGND VPWR VPWR _1214_ sky130_fd_sc_hd__clkbuf_1
XFILLER_0_78_489 VPWR VGND VPWR VGND sky130_ef_sc_hd__decap_12
XFILLER_0_46_342 VGND VGND VPWR VPWR sky130_fd_sc_hd__decap_6
X_4968_ _2485_ VGND VGND VPWR VPWR _0354_ sky130_fd_sc_hd__inv_2
XTAP_TAPCELL_ROW_34_495 VGND VPWR sky130_fd_sc_hd__tapvpwrvgnd_1
X_4899_ _2477_ VGND VGND VPWR VPWR _0293_ sky130_fd_sc_hd__inv_2
X_3919_ _2079_ _2023_ VGND VGND VPWR VPWR _2080_ sky130_fd_sc_hd__xnor2_4
XFILLER_0_61_334 VGND VGND VPWR VPWR sky130_fd_sc_hd__fill_2
XFILLER_0_14_272 VGND VGND VPWR VPWR sky130_fd_sc_hd__fill_1
XFILLER_0_69_423 VGND VGND VPWR VPWR sky130_fd_sc_hd__decap_8
XPHY_EDGE_ROW_69_Right_69 VGND VGND VPWR VPWR sky130_fd_sc_hd__decap_3
XFILLER_0_37_320 VPWR VGND VPWR VGND sky130_ef_sc_hd__decap_12
XFILLER_0_71_109 VGND VGND VPWR VPWR sky130_fd_sc_hd__decap_3
XFILLER_0_25_515 VGND VGND VPWR VPWR sky130_fd_sc_hd__fill_2
XFILLER_0_52_345 VPWR VGND VPWR VGND sky130_ef_sc_hd__decap_12
XFILLER_0_64_194 VGND VGND VPWR VPWR sky130_fd_sc_hd__fill_2
XPHY_EDGE_ROW_78_Right_78 VGND VGND VPWR VPWR sky130_fd_sc_hd__decap_3
XFILLER_0_85_27 VPWR VGND VPWR VGND sky130_ef_sc_hd__decap_12
XTAP_TAPCELL_ROW_76_874 VGND VPWR sky130_fd_sc_hd__tapvpwrvgnd_1
XPHY_EDGE_ROW_87_Right_87 VGND VGND VPWR VPWR sky130_fd_sc_hd__decap_3
XFILLER_0_87_275 VGND VGND VPWR VPWR sky130_fd_sc_hd__decap_4
XFILLER_0_75_437 VGND VGND VPWR VPWR sky130_fd_sc_hd__decap_8
X_4822_ _2469_ VGND VGND VPWR VPWR _0224_ sky130_fd_sc_hd__inv_2
XFILLER_0_7_214 VGND VGND VPWR VPWR sky130_fd_sc_hd__fill_2
XFILLER_0_7_225 VGND VGND VPWR VPWR sky130_fd_sc_hd__fill_1
X_4753_ _2460_ VGND VGND VPWR VPWR _0164_ sky130_fd_sc_hd__inv_2
X_3704_ _1397_ _1393_ VGND VGND VPWR VPWR _1890_ sky130_fd_sc_hd__nand2_1
XFILLER_0_28_386 VGND VGND VPWR VPWR sky130_fd_sc_hd__decap_4
XTAP_TAPCELL_ROW_31_465 VGND VPWR sky130_fd_sc_hd__tapvpwrvgnd_1
X_4684_ _2452_ VGND VGND VPWR VPWR _0103_ sky130_fd_sc_hd__inv_2
X_3635_ _0797_ net64 _1822_ VGND VGND VPWR VPWR net32 sky130_fd_sc_hd__nor3_2
XFILLER_0_43_389 VGND VGND VPWR VPWR sky130_fd_sc_hd__decap_3
XFILLER_0_3_497 VGND VGND VPWR VPWR sky130_fd_sc_hd__decap_6
X_3566_ _0798_ _1741_ _1749_ _1756_ VGND VGND VPWR VPWR _1758_ sky130_fd_sc_hd__or4_2
X_3497_ _1681_ _1688_ VGND VGND VPWR VPWR _1690_ sky130_fd_sc_hd__or2_1
X_2517_ _0808_ VGND VGND VPWR VPWR _0809_ sky130_fd_sc_hd__buf_4
X_5305_ clknet_leaf_39_clk _0681_ _0297_ VGND VGND VPWR VPWR RF0.regs\[2\]\[0\] sky130_fd_sc_hd__dfrtp_1
XFILLER_0_52_3 VGND VGND VPWR VPWR sky130_fd_sc_hd__decap_8
X_5236_ clknet_leaf_7_clk _0612_ _0228_ VGND VGND VPWR VPWR RF0.regs\[6\]\[27\] sky130_fd_sc_hd__dfrtp_1
X_5167_ clknet_leaf_8_clk _0543_ _0159_ VGND VGND VPWR VPWR RF0.regs\[10\]\[22\] sky130_fd_sc_hd__dfrtp_1
X_4118_ _2191_ VGND VGND VPWR VPWR _0572_ sky130_fd_sc_hd__clkbuf_1
X_5098_ clknet_leaf_17_clk _0474_ _0090_ VGND VGND VPWR VPWR RF0.regs\[15\]\[17\]
+ sky130_fd_sc_hd__dfrtp_1
XTAP_TAPCELL_ROW_39_543 VGND VPWR sky130_fd_sc_hd__tapvpwrvgnd_1
X_4049_ _2005_ net234 _2149_ VGND VGND VPWR VPWR _2154_ sky130_fd_sc_hd__mux2_1
XFILLER_0_53_109 VGND VGND VPWR VPWR sky130_fd_sc_hd__decap_3
XTAP_TAPCELL_ROW_73_844 VGND VPWR sky130_fd_sc_hd__tapvpwrvgnd_1
XFILLER_0_84_289 VGND VGND VPWR VPWR sky130_fd_sc_hd__fill_2
XFILLER_0_72_418 VGND VGND VPWR VPWR sky130_fd_sc_hd__fill_2
XFILLER_0_25_334 VGND VGND VPWR VPWR sky130_fd_sc_hd__fill_2
XFILLER_0_37_172 VGND VGND VPWR VPWR sky130_fd_sc_hd__decap_8
XFILLER_0_4_217 VGND VGND VPWR VPWR sky130_fd_sc_hd__decap_8
XFILLER_0_20_88 VPWR VGND VPWR VGND sky130_ef_sc_hd__decap_12
XFILLER_0_40_348 VPWR VGND VPWR VGND sky130_ef_sc_hd__decap_12
X_3420_ RF0.regs\[0\]\[25\] _1218_ _1611_ _1613_ VGND VGND VPWR VPWR _1614_ sky130_fd_sc_hd__o22ai_2
XFILLER_0_0_445 VGND VGND VPWR VPWR sky130_fd_sc_hd__decap_3
X_3351_ _0892_ _1344_ VGND VGND VPWR VPWR _1547_ sky130_fd_sc_hd__nor2_1
XFILLER_0_0_489 VPWR VGND VPWR VGND sky130_ef_sc_hd__decap_12
X_3282_ _1221_ _1310_ VGND VGND VPWR VPWR _1478_ sky130_fd_sc_hd__nor2_1
X_5021_ clknet_leaf_37_clk _0397_ _0013_ VGND VGND VPWR VPWR RF0.regs\[25\]\[4\] sky130_fd_sc_hd__dfrtp_1
XTAP_TAPCELL_ROW_36_513 VGND VPWR sky130_fd_sc_hd__tapvpwrvgnd_1
XFILLER_0_48_404 VGND VGND VPWR VPWR sky130_fd_sc_hd__decap_6
XFILLER_0_48_426 VPWR VGND VPWR VGND sky130_ef_sc_hd__decap_12
XFILLER_0_75_234 VGND VGND VPWR VPWR sky130_fd_sc_hd__fill_2
XFILLER_0_8_501 VPWR VGND VPWR VGND sky130_ef_sc_hd__decap_12
XFILLER_0_75_278 VGND VGND VPWR VPWR sky130_fd_sc_hd__fill_2
XFILLER_0_75_256 VGND VGND VPWR VPWR sky130_fd_sc_hd__decap_4
XFILLER_0_35_109 VGND VGND VPWR VPWR sky130_fd_sc_hd__decap_3
X_4805_ _2467_ VGND VGND VPWR VPWR _0209_ sky130_fd_sc_hd__inv_2
X_2997_ net112 VGND VGND VPWR VPWR _1204_ sky130_fd_sc_hd__clkbuf_1
XFILLER_0_56_492 VPWR VGND VPWR VGND sky130_ef_sc_hd__decap_12
XFILLER_0_71_462 VGND VGND VPWR VPWR sky130_fd_sc_hd__fill_2
X_4736_ _2459_ VGND VGND VPWR VPWR _0148_ sky130_fd_sc_hd__inv_2
X_4667_ _2449_ VGND VGND VPWR VPWR _0089_ sky130_fd_sc_hd__inv_2
XFILLER_0_3_272 VGND VGND VPWR VPWR sky130_fd_sc_hd__decap_8
XFILLER_0_31_337 VGND VGND VPWR VPWR sky130_fd_sc_hd__decap_8
XFILLER_0_31_359 VGND VGND VPWR VPWR sky130_fd_sc_hd__fill_1
X_3618_ RF0.regs\[10\]\[9\] _0885_ _0811_ RF0.regs\[25\]\[9\] _0795_ VGND VGND VPWR
+ VPWR _1807_ sky130_fd_sc_hd__a221o_1
X_4598_ _2440_ VGND VGND VPWR VPWR _0029_ sky130_fd_sc_hd__inv_2
X_3549_ _1381_ _1739_ _1740_ _1380_ VGND VGND VPWR VPWR _1741_ sky130_fd_sc_hd__a211oi_1
X_5219_ clknet_leaf_23_clk _0595_ _0211_ VGND VGND VPWR VPWR RF0.regs\[6\]\[10\] sky130_fd_sc_hd__dfrtp_1
XTAP_TAPCELL_ROW_87_969 VGND VPWR sky130_fd_sc_hd__tapvpwrvgnd_1
XFILLER_0_39_437 VGND VGND VPWR VPWR sky130_fd_sc_hd__decap_3
XFILLER_0_47_470 VGND VGND VPWR VPWR sky130_fd_sc_hd__decap_3
XFILLER_0_47_481 VGND VGND VPWR VPWR sky130_fd_sc_hd__decap_6
XFILLER_0_34_153 VGND VGND VPWR VPWR sky130_fd_sc_hd__fill_2
Xclkbuf_2_3__f_clk clknet_0_clk VGND VGND VPWR VPWR clknet_2_3__leaf_clk sky130_fd_sc_hd__clkbuf_16
XFILLER_0_15_55 VGND VGND VPWR VPWR sky130_fd_sc_hd__fill_1
XFILLER_0_57_212 VGND VGND VPWR VPWR sky130_fd_sc_hd__fill_1
X_2920_ _1165_ VGND VGND VPWR VPWR _0730_ sky130_fd_sc_hd__clkbuf_1
XFILLER_0_72_237 VGND VGND VPWR VPWR sky130_fd_sc_hd__decap_4
X_2851_ _1118_ net162 VGND VGND VPWR VPWR _1126_ sky130_fd_sc_hd__and2_1
XTAP_TAPCELL_ROW_41_560 VGND VPWR sky130_fd_sc_hd__tapvpwrvgnd_1
X_2782_ RF0.regs\[10\]\[1\] _0809_ _0826_ RF0.regs\[25\]\[1\] _1073_ VGND VGND VPWR
+ VPWR _1074_ sky130_fd_sc_hd__a221oi_4
XFILLER_0_13_315 VGND VGND VPWR VPWR sky130_fd_sc_hd__decap_3
XFILLER_0_13_304 VGND VGND VPWR VPWR sky130_fd_sc_hd__fill_2
X_4521_ _2407_ _2394_ VGND VGND VPWR VPWR _2409_ sky130_fd_sc_hd__or2b_1
Xhold216 RF0.regs\[20\]\[4\] VGND VGND VPWR VPWR net264 sky130_fd_sc_hd__dlygate4sd3_1
Xhold205 RF0.regs\[20\]\[30\] VGND VGND VPWR VPWR net253 sky130_fd_sc_hd__dlygate4sd3_1
X_4452_ _2364_ VGND VGND VPWR VPWR _0411_ sky130_fd_sc_hd__clkbuf_1
Xhold227 RF0.regs\[6\]\[28\] VGND VGND VPWR VPWR net275 sky130_fd_sc_hd__dlygate4sd3_1
X_3403_ _1010_ _1595_ _1589_ VGND VGND VPWR VPWR _1597_ sky130_fd_sc_hd__and3_1
X_4383_ _2328_ VGND VGND VPWR VPWR _0444_ sky130_fd_sc_hd__clkbuf_1
XFILLER_0_0_253 VGND VGND VPWR VPWR sky130_fd_sc_hd__decap_8
X_3334_ RF0.regs\[4\]\[23\] _0838_ _1138_ RF0.regs\[12\]\[23\] _1529_ VGND VGND VPWR
+ VPWR _1530_ sky130_fd_sc_hd__a221oi_1
X_3265_ _1364_ _1382_ _1375_ _1460_ VGND VGND VPWR VPWR _1461_ sky130_fd_sc_hd__or4b_4
X_5004_ _2436_ VGND VGND VPWR VPWR _0387_ sky130_fd_sc_hd__inv_2
X_3196_ _1263_ _1072_ VGND VGND VPWR VPWR _1392_ sky130_fd_sc_hd__nor2_1
XFILLER_0_15_3 VPWR VGND VPWR VGND sky130_ef_sc_hd__decap_12
XFILLER_0_72_94 VGND VGND VPWR VPWR sky130_fd_sc_hd__decap_4
XFILLER_0_72_72 VPWR VGND VPWR VGND sky130_ef_sc_hd__decap_12
XFILLER_0_63_204 VGND VGND VPWR VPWR sky130_fd_sc_hd__decap_8
XFILLER_0_8_353 VGND VGND VPWR VPWR sky130_fd_sc_hd__decap_8
XFILLER_0_16_153 VGND VGND VPWR VPWR sky130_fd_sc_hd__fill_2
XPHY_EDGE_ROW_15_Left_103 VGND VGND VPWR VPWR sky130_fd_sc_hd__decap_3
XFILLER_0_31_101 VGND VGND VPWR VPWR sky130_fd_sc_hd__fill_1
X_4719_ _2456_ VGND VGND VPWR VPWR _0134_ sky130_fd_sc_hd__inv_2
XFILLER_0_44_473 VGND VGND VPWR VPWR sky130_fd_sc_hd__decap_3
XFILLER_0_71_281 VPWR VGND VPWR VGND sky130_ef_sc_hd__decap_12
XPHY_EDGE_ROW_24_Left_112 VGND VGND VPWR VPWR sky130_fd_sc_hd__decap_3
XTAP_TAPCELL_ROW_47_608 VGND VPWR sky130_fd_sc_hd__tapvpwrvgnd_1
XTAP_TAPCELL_ROW_55_685 VGND VPWR sky130_fd_sc_hd__tapvpwrvgnd_1
XFILLER_0_82_513 VGND VGND VPWR VPWR sky130_fd_sc_hd__decap_4
XPHY_EDGE_ROW_33_Left_121 VGND VGND VPWR VPWR sky130_fd_sc_hd__decap_3
XTAP_TAPCELL_ROW_10_276 VGND VPWR sky130_fd_sc_hd__tapvpwrvgnd_1
XFILLER_0_77_39 VPWR VGND VPWR VGND sky130_ef_sc_hd__decap_12
XPHY_EDGE_ROW_42_Left_130 VGND VGND VPWR VPWR sky130_fd_sc_hd__decap_3
X_3050_ _0795_ VGND VGND VPWR VPWR _1246_ sky130_fd_sc_hd__clkbuf_4
XTAP_TAPCELL_ROW_18_354 VGND VPWR sky130_fd_sc_hd__tapvpwrvgnd_1
XFILLER_0_9_139 VGND VGND VPWR VPWR sky130_fd_sc_hd__decap_8
XFILLER_0_18_418 VGND VGND VPWR VPWR sky130_fd_sc_hd__fill_2
X_3952_ RF0.regs\[5\]\[31\] _1952_ _2102_ VGND VGND VPWR VPWR _2103_ sky130_fd_sc_hd__mux2_1
X_3883_ _1834_ _2048_ VGND VGND VPWR VPWR _2049_ sky130_fd_sc_hd__nor2_1
X_2903_ net168 VGND VGND VPWR VPWR _1157_ sky130_fd_sc_hd__clkbuf_1
X_2834_ _1116_ VGND VGND VPWR VPWR _0767_ sky130_fd_sc_hd__clkbuf_1
XFILLER_0_42_97 VPWR VGND VPWR VGND sky130_ef_sc_hd__decap_12
X_2765_ RF0.regs\[5\]\[20\] _0874_ _0864_ RF0.regs\[4\]\[20\] VGND VGND VPWR VPWR
+ _1057_ sky130_fd_sc_hd__a22o_1
XFILLER_0_5_378 VPWR VGND VPWR VGND sky130_ef_sc_hd__decap_12
X_4504_ disp.digits\[0\] _0777_ _2392_ VGND VGND VPWR VPWR _2393_ sky130_fd_sc_hd__o21a_1
XFILLER_0_26_495 VGND VGND VPWR VPWR sky130_fd_sc_hd__fill_1
X_2696_ RF0.regs\[10\]\[3\] _0816_ _0830_ RF0.regs\[25\]\[3\] _0987_ VGND VGND VPWR
+ VPWR _0988_ sky130_fd_sc_hd__a221oi_1
X_4435_ _2355_ VGND VGND VPWR VPWR _0419_ sky130_fd_sc_hd__clkbuf_1
XFILLER_0_6_53 VPWR VGND VPWR VGND sky130_ef_sc_hd__decap_12
X_4366_ _2319_ VGND VGND VPWR VPWR _0452_ sky130_fd_sc_hd__clkbuf_1
XFILLER_0_6_97 VGND VGND VPWR VPWR sky130_fd_sc_hd__decap_6
X_3317_ _1221_ _1315_ VGND VGND VPWR VPWR _1513_ sky130_fd_sc_hd__nor2_1
X_4297_ _2283_ VGND VGND VPWR VPWR _0485_ sky130_fd_sc_hd__clkbuf_1
XTAP_TAPCELL_ROW_1_200 VGND VPWR sky130_fd_sc_hd__tapvpwrvgnd_1
X_3248_ _1440_ _1443_ VGND VGND VPWR VPWR _1444_ sky130_fd_sc_hd__nand2_2
X_3179_ _1368_ _1374_ VGND VGND VPWR VPWR _1375_ sky130_fd_sc_hd__nand2_1
XFILLER_0_83_93 VPWR VGND VPWR VGND sky130_ef_sc_hd__decap_12
XTAP_TAPCELL_ROW_52_655 VGND VPWR sky130_fd_sc_hd__tapvpwrvgnd_1
XFILLER_0_4_3 VPWR VGND VPWR VGND sky130_ef_sc_hd__decap_12
XFILLER_0_59_329 VGND VGND VPWR VPWR sky130_fd_sc_hd__fill_1
XTAP_TAPCELL_ROW_15_324 VGND VPWR sky130_fd_sc_hd__tapvpwrvgnd_1
XFILLER_0_55_502 VGND VGND VPWR VPWR sky130_fd_sc_hd__fill_2
XFILLER_0_82_321 VGND VGND VPWR VPWR sky130_fd_sc_hd__decap_3
XFILLER_0_82_365 VGND VGND VPWR VPWR sky130_fd_sc_hd__fill_1
XFILLER_0_70_516 VGND VGND VPWR VPWR sky130_fd_sc_hd__fill_1
X_2550_ _0833_ _0831_ _0841_ VGND VGND VPWR VPWR _0842_ sky130_fd_sc_hd__and3_2
XFILLER_0_23_498 VGND VGND VPWR VPWR sky130_fd_sc_hd__decap_3
X_4220_ RF0.regs\[10\]\[1\] _2099_ _0909_ VGND VGND VPWR VPWR _2244_ sky130_fd_sc_hd__mux2_1
X_4151_ net90 VGND VGND VPWR VPWR _2208_ sky130_fd_sc_hd__clkbuf_1
X_4082_ _2099_ net232 _2137_ VGND VGND VPWR VPWR _2171_ sky130_fd_sc_hd__mux2_1
X_3102_ _1257_ _0970_ VGND VGND VPWR VPWR _1298_ sky130_fd_sc_hd__and2_1
X_3033_ _1228_ VGND VGND VPWR VPWR _1229_ sky130_fd_sc_hd__clkbuf_4
XFILLER_0_77_137 VPWR VGND VPWR VGND sky130_ef_sc_hd__decap_12
X_4984_ _2487_ VGND VGND VPWR VPWR _0368_ sky130_fd_sc_hd__inv_2
X_3935_ _2091_ VGND VGND VPWR VPWR _0654_ sky130_fd_sc_hd__clkbuf_1
XFILLER_0_85_181 VGND VGND VPWR VPWR sky130_fd_sc_hd__fill_1
XFILLER_0_73_343 VGND VGND VPWR VPWR sky130_fd_sc_hd__decap_8
XFILLER_0_73_321 VGND VGND VPWR VPWR sky130_fd_sc_hd__fill_1
X_3866_ _2032_ _1860_ VGND VGND VPWR VPWR _2033_ sky130_fd_sc_hd__or2b_2
XFILLER_0_61_505 VGND VGND VPWR VPWR sky130_fd_sc_hd__decap_8
XFILLER_0_82_3 VPWR VGND VPWR VGND sky130_ef_sc_hd__decap_12
X_2817_ net1 VGND VGND VPWR VPWR _1107_ sky130_fd_sc_hd__inv_2
XFILLER_0_5_142 VGND VGND VPWR VPWR sky130_fd_sc_hd__decap_3
X_3797_ _1628_ _1968_ VGND VGND VPWR VPWR _1977_ sky130_fd_sc_hd__or2b_1
X_2748_ RF0.regs\[2\]\[8\] _0878_ _1038_ _1039_ VGND VGND VPWR VPWR _1040_ sky130_fd_sc_hd__a211oi_2
X_4418_ _2346_ VGND VGND VPWR VPWR _0427_ sky130_fd_sc_hd__clkbuf_1
X_2679_ RF0.regs\[4\]\[10\] _0835_ _0843_ RF0.regs\[12\]\[10\] VGND VGND VPWR VPWR
+ _0971_ sky130_fd_sc_hd__a22o_1
X_5398_ clknet_leaf_43_clk _0774_ _0390_ VGND VGND VPWR VPWR IM0.addr\[29\] sky130_fd_sc_hd__dfrtp_1
X_4349_ _2310_ VGND VGND VPWR VPWR _0460_ sky130_fd_sc_hd__clkbuf_1
XTAP_TAPCELL_ROW_57_703 VGND VPWR sky130_fd_sc_hd__tapvpwrvgnd_1
XTAP_TAPCELL_ROW_29_449 VGND VPWR sky130_fd_sc_hd__tapvpwrvgnd_1
XFILLER_0_68_126 VPWR VGND VPWR VGND sky130_ef_sc_hd__decap_12
XFILLER_0_83_118 VGND VGND VPWR VPWR sky130_fd_sc_hd__fill_1
XFILLER_0_37_502 VGND VGND VPWR VPWR sky130_fd_sc_hd__fill_2
XFILLER_0_76_192 VGND VGND VPWR VPWR sky130_fd_sc_hd__decap_4
XFILLER_0_64_365 VGND VGND VPWR VPWR sky130_fd_sc_hd__fill_1
XTAP_TAPCELL_ROW_20_371 VGND VPWR sky130_fd_sc_hd__tapvpwrvgnd_1
XFILLER_0_74_29 VPWR VGND VPWR VGND sky130_ef_sc_hd__decap_12
XFILLER_0_59_126 VGND VGND VPWR VPWR sky130_fd_sc_hd__fill_2
X_3720_ _1839_ _1841_ VGND VGND VPWR VPWR _1906_ sky130_fd_sc_hd__or2_1
Xclkbuf_leaf_40_clk clknet_2_0__leaf_clk VGND VGND VPWR VPWR clknet_leaf_40_clk sky130_fd_sc_hd__clkbuf_8
XFILLER_0_55_365 VGND VGND VPWR VPWR sky130_fd_sc_hd__decap_4
X_3651_ RF0.regs\[10\]\[6\] _0885_ _0807_ RF0.regs\[25\]\[6\] _0795_ VGND VGND VPWR
+ VPWR _1837_ sky130_fd_sc_hd__a221o_1
X_2602_ RF0.regs\[10\]\[29\] _0887_ _0855_ RF0.regs\[15\]\[29\] VGND VGND VPWR VPWR
+ _0894_ sky130_fd_sc_hd__a22o_1
X_3582_ RF0.regs\[10\]\[12\] _0886_ _0813_ RF0.regs\[25\]\[12\] _0795_ VGND VGND VPWR
+ VPWR _1773_ sky130_fd_sc_hd__a221o_1
XFILLER_0_23_251 VGND VGND VPWR VPWR sky130_fd_sc_hd__decap_6
XFILLER_0_23_273 VGND VGND VPWR VPWR sky130_fd_sc_hd__decap_6
X_2533_ _0824_ VGND VGND VPWR VPWR _0825_ sky130_fd_sc_hd__buf_6
X_5321_ clknet_leaf_17_clk _0697_ _0313_ VGND VGND VPWR VPWR RF0.regs\[2\]\[16\] sky130_fd_sc_hd__dfrtp_1
X_5252_ clknet_leaf_26_clk _0628_ _0244_ VGND VGND VPWR VPWR RF0.regs\[5\]\[11\] sky130_fd_sc_hd__dfrtp_1
XFILLER_0_48_52 VGND VGND VPWR VPWR sky130_fd_sc_hd__decap_3
X_5183_ clknet_leaf_31_clk _0559_ _0175_ VGND VGND VPWR VPWR RF0.regs\[7\]\[6\] sky130_fd_sc_hd__dfrtp_1
X_4203_ _2235_ VGND VGND VPWR VPWR _0531_ sky130_fd_sc_hd__clkbuf_1
X_4134_ _2199_ VGND VGND VPWR VPWR _0564_ sky130_fd_sc_hd__clkbuf_1
X_4065_ _2162_ VGND VGND VPWR VPWR _0595_ sky130_fd_sc_hd__clkbuf_1
XTAP_TAPCELL_ROW_26_419 VGND VPWR sky130_fd_sc_hd__tapvpwrvgnd_1
X_3016_ _1213_ VGND VGND VPWR VPWR _0682_ sky130_fd_sc_hd__clkbuf_1
XTAP_TAPCELL_ROW_62_750 VGND VPWR sky130_fd_sc_hd__tapvpwrvgnd_1
XFILLER_0_46_321 VGND VGND VPWR VPWR sky130_fd_sc_hd__fill_1
X_4967_ _2485_ VGND VGND VPWR VPWR _0353_ sky130_fd_sc_hd__inv_2
Xclkbuf_leaf_31_clk clknet_2_2__leaf_clk VGND VGND VPWR VPWR clknet_leaf_31_clk sky130_fd_sc_hd__clkbuf_8
XTAP_TAPCELL_ROW_34_496 VGND VPWR sky130_fd_sc_hd__tapvpwrvgnd_1
X_3918_ _1823_ _1909_ _1911_ VGND VGND VPWR VPWR _2079_ sky130_fd_sc_hd__a21o_1
X_4898_ _2477_ VGND VGND VPWR VPWR _0292_ sky130_fd_sc_hd__inv_2
XFILLER_0_46_365 VGND VGND VPWR VPWR sky130_fd_sc_hd__fill_2
X_3849_ _1769_ _2017_ VGND VGND VPWR VPWR _2018_ sky130_fd_sc_hd__and2b_2
XFILLER_0_37_332 VGND VGND VPWR VPWR sky130_fd_sc_hd__decap_4
Xclkbuf_leaf_22_clk clknet_2_3__leaf_clk VGND VGND VPWR VPWR clknet_leaf_22_clk sky130_fd_sc_hd__clkbuf_8
XFILLER_0_25_505 VGND VGND VPWR VPWR sky130_fd_sc_hd__fill_2
XFILLER_0_52_357 VGND VGND VPWR VPWR sky130_fd_sc_hd__decap_6
XFILLER_0_85_39 VPWR VGND VPWR VGND sky130_ef_sc_hd__decap_12
XFILLER_0_20_298 VGND VGND VPWR VPWR sky130_fd_sc_hd__decap_4
XFILLER_0_87_221 VGND VGND VPWR VPWR sky130_fd_sc_hd__decap_3
XTAP_TAPCELL_ROW_76_875 VGND VPWR sky130_fd_sc_hd__tapvpwrvgnd_1
XFILLER_0_34_32 VPWR VGND VPWR VGND sky130_ef_sc_hd__decap_12
XFILLER_0_87_287 VGND VGND VPWR VPWR sky130_fd_sc_hd__decap_8
XFILLER_0_87_265 VGND VGND VPWR VPWR sky130_fd_sc_hd__fill_1
X_4821_ _2469_ VGND VGND VPWR VPWR _0223_ sky130_fd_sc_hd__inv_2
XFILLER_0_47_129 VGND VGND VPWR VPWR sky130_fd_sc_hd__fill_1
Xclkbuf_leaf_13_clk clknet_2_1__leaf_clk VGND VGND VPWR VPWR clknet_leaf_13_clk sky130_fd_sc_hd__clkbuf_8
XFILLER_0_16_516 VGND VGND VPWR VPWR sky130_fd_sc_hd__fill_1
X_4752_ _2460_ VGND VGND VPWR VPWR _0163_ sky130_fd_sc_hd__inv_2
X_3703_ RF0.regs\[0\]\[0\] _1216_ _1886_ _1888_ VGND VGND VPWR VPWR _1889_ sky130_fd_sc_hd__o22a_1
X_4683_ _2452_ VGND VGND VPWR VPWR _0102_ sky130_fd_sc_hd__inv_2
XTAP_TAPCELL_ROW_31_466 VGND VPWR sky130_fd_sc_hd__tapvpwrvgnd_1
XFILLER_0_31_508 VGND VGND VPWR VPWR sky130_fd_sc_hd__fill_1
X_3634_ _1821_ _1437_ VGND VGND VPWR VPWR _1822_ sky130_fd_sc_hd__and2_1
XFILLER_0_51_390 VGND VGND VPWR VPWR sky130_fd_sc_hd__fill_2
X_3565_ _1750_ _1756_ VGND VGND VPWR VPWR _1757_ sky130_fd_sc_hd__nand2_1
X_3496_ _1681_ _1688_ VGND VGND VPWR VPWR _1689_ sky130_fd_sc_hd__and2_1
X_2516_ net55 net66 _0807_ VGND VGND VPWR VPWR _0808_ sky130_fd_sc_hd__and3_1
X_5304_ clknet_leaf_45_clk _0680_ _0296_ VGND VGND VPWR VPWR RF0.regs\[4\]\[31\] sky130_fd_sc_hd__dfrtp_1
X_5235_ clknet_leaf_6_clk _0611_ _0227_ VGND VGND VPWR VPWR RF0.regs\[6\]\[26\] sky130_fd_sc_hd__dfrtp_1
XFILLER_0_45_3 VGND VGND VPWR VPWR sky130_fd_sc_hd__decap_6
X_5166_ clknet_leaf_13_clk _0542_ _0158_ VGND VGND VPWR VPWR RF0.regs\[10\]\[21\]
+ sky130_fd_sc_hd__dfrtp_4
X_4117_ net124 VGND VGND VPWR VPWR _2191_ sky130_fd_sc_hd__clkbuf_1
X_5097_ clknet_leaf_18_clk _0473_ _0089_ VGND VGND VPWR VPWR RF0.regs\[15\]\[16\]
+ sky130_fd_sc_hd__dfrtp_1
XTAP_TAPCELL_ROW_39_544 VGND VPWR sky130_fd_sc_hd__tapvpwrvgnd_1
X_4048_ _2153_ VGND VGND VPWR VPWR _0603_ sky130_fd_sc_hd__clkbuf_1
XFILLER_0_78_287 VGND VGND VPWR VPWR sky130_fd_sc_hd__fill_1
XFILLER_0_66_438 VPWR VGND VPWR VGND sky130_ef_sc_hd__decap_12
XFILLER_0_74_460 VPWR VGND VPWR VGND sky130_ef_sc_hd__decap_12
XFILLER_0_34_346 VPWR VGND VPWR VGND sky130_ef_sc_hd__decap_12
XFILLER_0_34_368 VPWR VGND VPWR VGND sky130_ef_sc_hd__decap_12
XFILLER_0_6_292 VGND VGND VPWR VPWR sky130_fd_sc_hd__fill_1
XTAP_TAPCELL_ROW_73_845 VGND VPWR sky130_fd_sc_hd__tapvpwrvgnd_1
XFILLER_0_57_405 VGND VGND VPWR VPWR sky130_fd_sc_hd__fill_1
XFILLER_0_57_438 VGND VGND VPWR VPWR sky130_fd_sc_hd__decap_6
XFILLER_0_57_449 VGND VGND VPWR VPWR sky130_fd_sc_hd__decap_3
XFILLER_0_33_390 VGND VGND VPWR VPWR sky130_fd_sc_hd__fill_2
X_3350_ _0892_ _1344_ VGND VGND VPWR VPWR _1546_ sky130_fd_sc_hd__and2_1
X_5020_ clknet_leaf_37_clk _0396_ _0012_ VGND VGND VPWR VPWR RF0.regs\[25\]\[3\] sky130_fd_sc_hd__dfrtp_1
XFILLER_0_29_54 VGND VGND VPWR VPWR sky130_fd_sc_hd__fill_2
X_3281_ RF0.regs\[10\]\[19\] _0812_ _1254_ RF0.regs\[12\]\[19\] _1476_ VGND VGND VPWR
+ VPWR _1477_ sky130_fd_sc_hd__a221oi_4
Xclkbuf_leaf_2_clk clknet_2_0__leaf_clk VGND VGND VPWR VPWR clknet_leaf_2_clk sky130_fd_sc_hd__clkbuf_8
XFILLER_0_45_31 VGND VGND VPWR VPWR sky130_fd_sc_hd__fill_2
XFILLER_0_45_42 VGND VGND VPWR VPWR sky130_fd_sc_hd__fill_1
XFILLER_0_45_64 VGND VGND VPWR VPWR sky130_fd_sc_hd__fill_1
XTAP_TAPCELL_ROW_36_514 VGND VPWR sky130_fd_sc_hd__tapvpwrvgnd_1
XFILLER_0_75_202 VPWR VGND VPWR VGND sky130_ef_sc_hd__decap_12
XFILLER_0_8_513 VGND VGND VPWR VPWR sky130_fd_sc_hd__decap_4
XFILLER_0_48_438 VPWR VGND VPWR VGND sky130_ef_sc_hd__decap_12
XFILLER_0_61_52 VGND VGND VPWR VPWR sky130_fd_sc_hd__fill_1
X_4804_ _2467_ VGND VGND VPWR VPWR _0208_ sky130_fd_sc_hd__inv_2
XFILLER_0_63_419 VGND VGND VPWR VPWR sky130_fd_sc_hd__fill_2
XFILLER_0_16_302 VGND VGND VPWR VPWR sky130_fd_sc_hd__decap_3
XFILLER_0_28_184 VPWR VGND VPWR VGND sky130_ef_sc_hd__decap_12
X_2996_ _1203_ VGND VGND VPWR VPWR _0692_ sky130_fd_sc_hd__clkbuf_1
X_4735_ _2459_ VGND VGND VPWR VPWR _0147_ sky130_fd_sc_hd__inv_2
X_4666_ _2449_ VGND VGND VPWR VPWR _0088_ sky130_fd_sc_hd__inv_2
XFILLER_0_31_305 VPWR VGND VPWR VGND sky130_ef_sc_hd__decap_12
X_3617_ RF0.regs\[5\]\[9\] _0865_ _1227_ RF0.regs\[15\]\[9\] VGND VGND VPWR VPWR _1806_
+ sky130_fd_sc_hd__a22o_1
X_4597_ _2440_ VGND VGND VPWR VPWR _0028_ sky130_fd_sc_hd__inv_2
X_3548_ _1465_ _1373_ VGND VGND VPWR VPWR _1740_ sky130_fd_sc_hd__xnor2_1
X_3479_ _1009_ _1671_ _1672_ VGND VGND VPWR VPWR _1673_ sky130_fd_sc_hd__and3_1
X_5218_ clknet_leaf_29_clk _0594_ _0210_ VGND VGND VPWR VPWR RF0.regs\[6\]\[9\] sky130_fd_sc_hd__dfrtp_1
X_5149_ clknet_leaf_34_clk _0525_ _0141_ VGND VGND VPWR VPWR RF0.regs\[10\]\[4\] sky130_fd_sc_hd__dfrtp_1
XTAP_TAPCELL_ROW_70_815 VGND VPWR sky130_fd_sc_hd__tapvpwrvgnd_1
XFILLER_0_66_224 VGND VGND VPWR VPWR sky130_fd_sc_hd__decap_4
XFILLER_0_54_408 VPWR VGND VPWR VGND sky130_ef_sc_hd__decap_12
XFILLER_0_34_121 VGND VGND VPWR VPWR sky130_fd_sc_hd__fill_2
XFILLER_0_22_305 VGND VGND VPWR VPWR sky130_fd_sc_hd__decap_3
XFILLER_0_62_485 VGND VGND VPWR VPWR sky130_fd_sc_hd__decap_4
XTAP_TAPCELL_ROW_7_250 VGND VPWR sky130_fd_sc_hd__tapvpwrvgnd_1
XFILLER_0_82_29 VPWR VGND VPWR VGND sky130_ef_sc_hd__decap_12
X_2850_ _1125_ VGND VGND VPWR VPWR _0760_ sky130_fd_sc_hd__clkbuf_1
XFILLER_0_57_257 VGND VGND VPWR VPWR sky130_fd_sc_hd__fill_1
XFILLER_0_72_227 VGND VGND VPWR VPWR sky130_fd_sc_hd__fill_1
XFILLER_0_5_505 VPWR VGND VPWR VGND sky130_ef_sc_hd__decap_12
XFILLER_0_31_11 VGND VGND VPWR VPWR sky130_fd_sc_hd__fill_2
X_2781_ RF0.regs\[4\]\[1\] _0834_ _0842_ RF0.regs\[12\]\[1\] VGND VGND VPWR VPWR _1073_
+ sky130_fd_sc_hd__a22o_1
XTAP_TAPCELL_ROW_41_561 VGND VPWR sky130_fd_sc_hd__tapvpwrvgnd_1
X_4520_ _2398_ _2405_ _2407_ _2408_ VGND VGND VPWR VPWR _0000_ sky130_fd_sc_hd__a22o_1
XFILLER_0_53_474 VGND VGND VPWR VPWR sky130_fd_sc_hd__fill_1
XFILLER_0_80_293 VGND VGND VPWR VPWR sky130_fd_sc_hd__fill_2
Xhold217 RF0.regs\[20\]\[28\] VGND VGND VPWR VPWR net265 sky130_fd_sc_hd__dlygate4sd3_1
XFILLER_0_40_135 VGND VGND VPWR VPWR sky130_fd_sc_hd__decap_4
Xhold206 RF0.regs\[2\]\[22\] VGND VGND VPWR VPWR net254 sky130_fd_sc_hd__dlygate4sd3_1
X_4451_ RF0.regs\[25\]\[18\] _2002_ _2360_ VGND VGND VPWR VPWR _2364_ sky130_fd_sc_hd__mux2_1
XFILLER_0_0_221 VGND VGND VPWR VPWR sky130_fd_sc_hd__decap_3
Xhold228 RF0.regs\[10\]\[11\] VGND VGND VPWR VPWR net276 sky130_fd_sc_hd__dlygate4sd3_1
X_3402_ _1148_ _1589_ _1595_ VGND VGND VPWR VPWR _1596_ sky130_fd_sc_hd__a21oi_1
X_4382_ net239 _2000_ _2325_ VGND VGND VPWR VPWR _2328_ sky130_fd_sc_hd__mux2_1
X_3333_ RF0.regs\[10\]\[23\] _0813_ _1222_ RF0.regs\[25\]\[23\] VGND VGND VPWR VPWR
+ _1529_ sky130_fd_sc_hd__a22o_1
XPHY_EDGE_ROW_7_Right_7 VGND VGND VPWR VPWR sky130_fd_sc_hd__decap_3
X_3264_ _1454_ _1439_ _1459_ VGND VGND VPWR VPWR _1460_ sky130_fd_sc_hd__a21o_1
X_5003_ _2488_ VGND VGND VPWR VPWR _0386_ sky130_fd_sc_hd__inv_2
XFILLER_0_56_74 VGND VGND VPWR VPWR sky130_fd_sc_hd__fill_1
X_3195_ _1047_ _1389_ VGND VGND VPWR VPWR _1391_ sky130_fd_sc_hd__nand2_1
XFILLER_0_48_213 VPWR VGND VPWR VGND sky130_ef_sc_hd__decap_12
XFILLER_0_48_257 VGND VGND VPWR VPWR sky130_fd_sc_hd__fill_1
XFILLER_0_8_332 VPWR VGND VPWR VGND sky130_ef_sc_hd__decap_12
XFILLER_0_8_365 VGND VGND VPWR VPWR sky130_fd_sc_hd__decap_6
X_2979_ net138 VGND VGND VPWR VPWR _1195_ sky130_fd_sc_hd__clkbuf_1
X_4718_ _2456_ VGND VGND VPWR VPWR _0133_ sky130_fd_sc_hd__inv_2
XFILLER_0_71_293 VGND VGND VPWR VPWR sky130_fd_sc_hd__fill_2
X_4649_ _2447_ VGND VGND VPWR VPWR _2448_ sky130_fd_sc_hd__buf_4
XTAP_TAPCELL_ROW_47_609 VGND VPWR sky130_fd_sc_hd__tapvpwrvgnd_1
XTAP_TAPCELL_ROW_83_940 VGND VPWR sky130_fd_sc_hd__tapvpwrvgnd_1
XTAP_TAPCELL_ROW_55_686 VGND VPWR sky130_fd_sc_hd__tapvpwrvgnd_1
XFILLER_0_22_124 VGND VGND VPWR VPWR sky130_fd_sc_hd__fill_2
XTAP_TAPCELL_ROW_10_277 VGND VPWR sky130_fd_sc_hd__tapvpwrvgnd_1
XFILLER_0_22_157 VGND VGND VPWR VPWR sky130_fd_sc_hd__decap_8
XTAP_TAPCELL_ROW_18_355 VGND VPWR sky130_fd_sc_hd__tapvpwrvgnd_1
X_3951_ _0868_ VGND VGND VPWR VPWR _2102_ sky130_fd_sc_hd__buf_4
XFILLER_0_9_118 VGND VGND VPWR VPWR sky130_fd_sc_hd__fill_1
X_2902_ _1156_ VGND VGND VPWR VPWR _0739_ sky130_fd_sc_hd__clkbuf_1
X_3882_ _1842_ _2046_ _2047_ VGND VGND VPWR VPWR _2048_ sky130_fd_sc_hd__o21a_1
XFILLER_0_42_54 VGND VGND VPWR VPWR sky130_fd_sc_hd__fill_1
XFILLER_0_45_216 VGND VGND VPWR VPWR sky130_fd_sc_hd__fill_2
X_2833_ _1108_ net202 VGND VGND VPWR VPWR _1116_ sky130_fd_sc_hd__and2_1
XFILLER_0_5_335 VGND VGND VPWR VPWR sky130_fd_sc_hd__fill_1
X_2764_ _0912_ _0914_ _1045_ _1047_ _1055_ VGND VGND VPWR VPWR _1056_ sky130_fd_sc_hd__a221o_1
XFILLER_0_13_113 VGND VGND VPWR VPWR sky130_fd_sc_hd__fill_2
XFILLER_0_5_368 VGND VGND VPWR VPWR sky130_fd_sc_hd__fill_1
X_4503_ disp.digits\[4\] _2385_ _2391_ _2384_ VGND VGND VPWR VPWR _2392_ sky130_fd_sc_hd__a211o_1
XFILLER_0_13_157 VGND VGND VPWR VPWR sky130_fd_sc_hd__decap_8
X_2695_ RF0.regs\[4\]\[3\] _0839_ _0845_ RF0.regs\[12\]\[3\] VGND VGND VPWR VPWR _0987_
+ sky130_fd_sc_hd__a22o_1
XFILLER_0_41_455 VGND VGND VPWR VPWR sky130_fd_sc_hd__decap_8
X_4434_ RF0.regs\[25\]\[26\] _1975_ _2349_ VGND VGND VPWR VPWR _2355_ sky130_fd_sc_hd__mux2_1
XFILLER_0_6_65 VPWR VGND VPWR VGND sky130_ef_sc_hd__decap_12
X_4365_ net174 _1971_ _2314_ VGND VGND VPWR VPWR _2319_ sky130_fd_sc_hd__mux2_1
X_3316_ _1061_ _1511_ VGND VGND VPWR VPWR _1512_ sky130_fd_sc_hd__xnor2_1
X_4296_ RF0.regs\[15\]\[28\] _1965_ _2279_ VGND VGND VPWR VPWR _2283_ sky130_fd_sc_hd__mux2_1
X_3247_ _1297_ _1298_ _0828_ VGND VGND VPWR VPWR _1443_ sky130_fd_sc_hd__a21oi_1
XTAP_TAPCELL_ROW_1_201 VGND VPWR sky130_fd_sc_hd__tapvpwrvgnd_1
X_3178_ _1054_ _1373_ VGND VGND VPWR VPWR _1374_ sky130_fd_sc_hd__xnor2_1
Xrebuffer10 _1318_ VGND VGND VPWR VPWR net58 sky130_fd_sc_hd__clkbuf_1
XFILLER_0_68_319 VGND VGND VPWR VPWR sky130_fd_sc_hd__fill_1
XTAP_TAPCELL_ROW_80_910 VGND VPWR sky130_fd_sc_hd__tapvpwrvgnd_1
XFILLER_0_76_396 VGND VGND VPWR VPWR sky130_fd_sc_hd__fill_1
XFILLER_0_76_363 VGND VGND VPWR VPWR sky130_fd_sc_hd__fill_1
XTAP_TAPCELL_ROW_52_656 VGND VPWR sky130_fd_sc_hd__tapvpwrvgnd_1
XFILLER_0_32_477 VGND VGND VPWR VPWR sky130_fd_sc_hd__decap_4
XTAP_TAPCELL_ROW_15_325 VGND VPWR sky130_fd_sc_hd__tapvpwrvgnd_1
XFILLER_0_82_300 VGND VGND VPWR VPWR sky130_fd_sc_hd__fill_2
XFILLER_0_67_385 VGND VGND VPWR VPWR sky130_fd_sc_hd__decap_6
XFILLER_0_35_271 VGND VGND VPWR VPWR sky130_fd_sc_hd__decap_6
X_4150_ _2207_ VGND VGND VPWR VPWR _0556_ sky130_fd_sc_hd__clkbuf_1
X_3101_ _1264_ _1275_ _1296_ _1295_ VGND VGND VPWR VPWR _1297_ sky130_fd_sc_hd__o211ai_2
X_4081_ _2170_ VGND VGND VPWR VPWR _0587_ sky130_fd_sc_hd__clkbuf_1
XFILLER_0_37_76 VPWR VGND VPWR VGND sky130_ef_sc_hd__decap_12
X_3032_ _1227_ VGND VGND VPWR VPWR _1228_ sky130_fd_sc_hd__clkbuf_4
XFILLER_0_53_31 VGND VGND VPWR VPWR sky130_fd_sc_hd__fill_1
XFILLER_0_77_149 VPWR VGND VPWR VGND sky130_ef_sc_hd__decap_12
X_4983_ _2487_ VGND VGND VPWR VPWR _0367_ sky130_fd_sc_hd__inv_2
X_3934_ RF0.regs\[4\]\[5\] _2090_ _2073_ VGND VGND VPWR VPWR _2091_ sky130_fd_sc_hd__mux2_1
X_3865_ net28 _1859_ VGND VGND VPWR VPWR _2032_ sky130_fd_sc_hd__and2_1
X_2816_ _1106_ VGND VGND VPWR VPWR _0775_ sky130_fd_sc_hd__clkbuf_1
XFILLER_0_5_121 VGND VGND VPWR VPWR sky130_fd_sc_hd__fill_2
X_3796_ _1976_ VGND VGND VPWR VPWR _0675_ sky130_fd_sc_hd__clkbuf_1
X_2747_ RF0.regs\[10\]\[8\] _0883_ _0873_ RF0.regs\[5\]\[8\] VGND VGND VPWR VPWR _1039_
+ sky130_fd_sc_hd__a22o_1
XFILLER_0_75_3 VPWR VGND VPWR VGND sky130_ef_sc_hd__decap_12
XFILLER_0_14_477 VGND VGND VPWR VPWR sky130_fd_sc_hd__fill_2
X_2678_ RF0.regs\[2\]\[10\] _0878_ _0968_ _0969_ VGND VGND VPWR VPWR _0970_ sky130_fd_sc_hd__a211o_1
X_4417_ net201 _2097_ _2336_ VGND VGND VPWR VPWR _2346_ sky130_fd_sc_hd__mux2_1
X_5397_ clknet_leaf_43_clk _0773_ _0389_ VGND VGND VPWR VPWR IM0.addr\[28\] sky130_fd_sc_hd__dfrtp_1
XFILLER_0_1_393 VPWR VGND VPWR VGND sky130_ef_sc_hd__decap_12
X_4348_ RF0.regs\[15\]\[3\] _2094_ _2301_ VGND VGND VPWR VPWR _2310_ sky130_fd_sc_hd__mux2_1
X_4279_ _2273_ VGND VGND VPWR VPWR _0493_ sky130_fd_sc_hd__clkbuf_1
XTAP_TAPCELL_ROW_57_704 VGND VPWR sky130_fd_sc_hd__tapvpwrvgnd_1
XPHY_EDGE_ROW_61_Left_149 VGND VGND VPWR VPWR sky130_fd_sc_hd__decap_3
XFILLER_0_68_138 VGND VGND VPWR VPWR sky130_fd_sc_hd__fill_2
XTAP_TAPCELL_ROW_65_770 VGND VPWR sky130_fd_sc_hd__tapvpwrvgnd_1
XPHY_EDGE_ROW_70_Left_158 VGND VGND VPWR VPWR sky130_fd_sc_hd__decap_3
XTAP_TAPCELL_ROW_20_372 VGND VPWR sky130_fd_sc_hd__tapvpwrvgnd_1
XFILLER_0_20_447 VGND VGND VPWR VPWR sky130_fd_sc_hd__decap_8
XFILLER_0_67_160 VGND VGND VPWR VPWR sky130_fd_sc_hd__fill_2
XFILLER_0_82_152 VGND VGND VPWR VPWR sky130_fd_sc_hd__decap_3
X_3650_ RF0.regs\[20\]\[6\] _1221_ _1231_ RF0.regs\[6\]\[6\] _1835_ VGND VGND VPWR
+ VPWR _1836_ sky130_fd_sc_hd__a221o_1
X_3581_ RF0.regs\[7\]\[12\] _1243_ VGND VGND VPWR VPWR _1772_ sky130_fd_sc_hd__and2_1
X_2601_ RF0.regs\[5\]\[29\] _0875_ _0866_ RF0.regs\[4\]\[29\] VGND VGND VPWR VPWR
+ _0893_ sky130_fd_sc_hd__a22o_1
Xrebuffer1 _1304_ VGND VGND VPWR VPWR net49 sky130_fd_sc_hd__dlygate4sd1_1
XFILLER_0_2_146 VGND VGND VPWR VPWR sky130_fd_sc_hd__fill_2
X_2532_ _0823_ _0801_ VGND VGND VPWR VPWR _0824_ sky130_fd_sc_hd__or2_4
X_5320_ clknet_leaf_15_clk _0696_ _0312_ VGND VGND VPWR VPWR RF0.regs\[2\]\[15\] sky130_fd_sc_hd__dfrtp_1
XFILLER_0_11_447 VGND VGND VPWR VPWR sky130_fd_sc_hd__fill_1
XFILLER_0_2_168 VGND VGND VPWR VPWR sky130_fd_sc_hd__fill_1
X_5251_ clknet_leaf_24_clk _0627_ _0243_ VGND VGND VPWR VPWR RF0.regs\[5\]\[10\] sky130_fd_sc_hd__dfrtp_1
XFILLER_0_61_9 VGND VGND VPWR VPWR sky130_fd_sc_hd__fill_1
X_4202_ RF0.regs\[10\]\[10\] _2077_ _2233_ VGND VGND VPWR VPWR _2235_ sky130_fd_sc_hd__mux2_1
X_5182_ clknet_leaf_33_clk _0558_ _0174_ VGND VGND VPWR VPWR RF0.regs\[7\]\[5\] sky130_fd_sc_hd__dfrtp_1
XFILLER_0_48_75 VGND VGND VPWR VPWR sky130_fd_sc_hd__fill_2
X_4133_ net73 VGND VGND VPWR VPWR _2199_ sky130_fd_sc_hd__clkbuf_1
XFILLER_0_3_55 VGND VGND VPWR VPWR sky130_fd_sc_hd__fill_1
X_4064_ _2077_ net269 _2160_ VGND VGND VPWR VPWR _2162_ sky130_fd_sc_hd__mux2_1
X_3015_ net79 VGND VGND VPWR VPWR _1213_ sky130_fd_sc_hd__clkbuf_1
XFILLER_0_64_85 VPWR VGND VPWR VGND sky130_ef_sc_hd__decap_12
XTAP_TAPCELL_ROW_62_751 VGND VPWR sky130_fd_sc_hd__tapvpwrvgnd_1
X_4966_ _2485_ VGND VGND VPWR VPWR _0352_ sky130_fd_sc_hd__inv_2
XTAP_TAPCELL_ROW_34_497 VGND VPWR sky130_fd_sc_hd__tapvpwrvgnd_1
X_4897_ _2477_ VGND VGND VPWR VPWR _0291_ sky130_fd_sc_hd__inv_2
X_3917_ _2078_ VGND VGND VPWR VPWR _0659_ sky130_fd_sc_hd__clkbuf_1
X_3848_ _0799_ _2016_ _1765_ VGND VGND VPWR VPWR _2017_ sky130_fd_sc_hd__or3b_1
X_3779_ RF0.regs\[4\]\[29\] _1962_ _1953_ VGND VGND VPWR VPWR _1963_ sky130_fd_sc_hd__mux2_1
XFILLER_0_14_296 VGND VGND VPWR VPWR sky130_fd_sc_hd__decap_8
XFILLER_0_69_447 VGND VGND VPWR VPWR sky130_fd_sc_hd__fill_1
XFILLER_0_56_119 VGND VGND VPWR VPWR sky130_fd_sc_hd__fill_2
XFILLER_0_64_141 VGND VGND VPWR VPWR sky130_fd_sc_hd__decap_8
XFILLER_0_60_380 VPWR VGND VPWR VGND sky130_ef_sc_hd__decap_12
XFILLER_0_20_277 VGND VGND VPWR VPWR sky130_fd_sc_hd__fill_1
XTAP_TAPCELL_ROW_76_876 VGND VPWR sky130_fd_sc_hd__tapvpwrvgnd_1
XFILLER_0_87_233 VGND VGND VPWR VPWR sky130_fd_sc_hd__fill_1
XFILLER_0_34_44 VPWR VGND VPWR VGND sky130_ef_sc_hd__decap_12
X_4820_ _2469_ VGND VGND VPWR VPWR _0222_ sky130_fd_sc_hd__inv_2
XFILLER_0_83_461 VPWR VGND VPWR VGND sky130_ef_sc_hd__decap_12
X_4751_ _2460_ VGND VGND VPWR VPWR _0162_ sky130_fd_sc_hd__inv_2
X_3702_ RF0.regs\[5\]\[0\] _0863_ net47 RF0.regs\[7\]\[0\] _1887_ VGND VGND VPWR VPWR
+ _1888_ sky130_fd_sc_hd__a221o_1
XTAP_TAPCELL_ROW_31_467 VGND VPWR sky130_fd_sc_hd__tapvpwrvgnd_1
X_4682_ _2452_ VGND VGND VPWR VPWR _0101_ sky130_fd_sc_hd__inv_2
XFILLER_0_43_325 VGND VGND VPWR VPWR sky130_fd_sc_hd__decap_8
XFILLER_0_50_54 VGND VGND VPWR VPWR sky130_fd_sc_hd__decap_4
XFILLER_0_55_163 VGND VGND VPWR VPWR sky130_fd_sc_hd__decap_4
XFILLER_0_55_185 VGND VGND VPWR VPWR sky130_fd_sc_hd__fill_2
X_3633_ _1427_ _1431_ _1438_ VGND VGND VPWR VPWR _1821_ sky130_fd_sc_hd__a21o_1
X_3564_ RF0.regs\[0\]\[14\] _1217_ _1755_ VGND VGND VPWR VPWR _1756_ sky130_fd_sc_hd__o21ai_1
XFILLER_0_11_233 VGND VGND VPWR VPWR sky130_fd_sc_hd__decap_6
XFILLER_0_11_222 VGND VGND VPWR VPWR sky130_fd_sc_hd__fill_2
XFILLER_0_11_255 VPWR VGND VPWR VGND sky130_ef_sc_hd__decap_12
X_2515_ _0806_ VGND VGND VPWR VPWR _0807_ sky130_fd_sc_hd__clkbuf_4
X_5303_ clknet_leaf_45_clk _0679_ _0295_ VGND VGND VPWR VPWR RF0.regs\[4\]\[30\] sky130_fd_sc_hd__dfrtp_2
X_3495_ _0798_ _1686_ _1687_ VGND VGND VPWR VPWR _1688_ sky130_fd_sc_hd__or3_1
X_5234_ clknet_leaf_9_clk _0610_ _0226_ VGND VGND VPWR VPWR RF0.regs\[6\]\[25\] sky130_fd_sc_hd__dfrtp_1
XFILLER_0_11_277 VGND VGND VPWR VPWR sky130_fd_sc_hd__decap_3
X_5165_ clknet_leaf_13_clk _0541_ _0157_ VGND VGND VPWR VPWR RF0.regs\[10\]\[20\]
+ sky130_fd_sc_hd__dfrtp_2
X_4116_ _2190_ VGND VGND VPWR VPWR _0573_ sky130_fd_sc_hd__clkbuf_1
XFILLER_0_75_51 VGND VGND VPWR VPWR sky130_fd_sc_hd__decap_4
XFILLER_0_38_3 VGND VGND VPWR VPWR sky130_fd_sc_hd__decap_8
X_5096_ clknet_leaf_19_clk _0472_ _0088_ VGND VGND VPWR VPWR RF0.regs\[15\]\[15\]
+ sky130_fd_sc_hd__dfrtp_1
X_4047_ _2002_ net228 _2149_ VGND VGND VPWR VPWR _2153_ sky130_fd_sc_hd__mux2_1
XFILLER_0_38_119 VGND VGND VPWR VPWR sky130_fd_sc_hd__fill_2
XFILLER_0_19_355 VGND VGND VPWR VPWR sky130_fd_sc_hd__decap_8
X_4949_ _2480_ VGND VGND VPWR VPWR _2484_ sky130_fd_sc_hd__clkbuf_8
XFILLER_0_46_141 VPWR VGND VPWR VGND sky130_ef_sc_hd__decap_12
XFILLER_0_74_472 VGND VGND VPWR VPWR sky130_fd_sc_hd__decap_4
XFILLER_0_34_358 VGND VGND VPWR VPWR sky130_fd_sc_hd__decap_6
XTAP_TAPCELL_ROW_73_846 VGND VPWR sky130_fd_sc_hd__tapvpwrvgnd_1
XFILLER_0_25_314 VPWR VGND VPWR VGND sky130_ef_sc_hd__decap_12
XFILLER_0_65_461 VGND VGND VPWR VPWR sky130_fd_sc_hd__fill_1
X_3280_ RF0.regs\[4\]\[19\] _0836_ _1252_ RF0.regs\[25\]\[19\] VGND VGND VPWR VPWR
+ _1476_ sky130_fd_sc_hd__a22o_1
XTAP_TAPCELL_ROW_36_515 VGND VPWR sky130_fd_sc_hd__tapvpwrvgnd_1
XFILLER_0_75_214 VGND VGND VPWR VPWR sky130_fd_sc_hd__decap_4
X_4803_ _2467_ VGND VGND VPWR VPWR _0207_ sky130_fd_sc_hd__inv_2
XTAP_TAPCELL_ROW_44_581 VGND VPWR sky130_fd_sc_hd__tapvpwrvgnd_1
X_4734_ _2459_ VGND VGND VPWR VPWR _0146_ sky130_fd_sc_hd__inv_2
X_2995_ net216 VGND VGND VPWR VPWR _1203_ sky130_fd_sc_hd__clkbuf_1
X_4665_ _2449_ VGND VGND VPWR VPWR _0087_ sky130_fd_sc_hd__inv_2
XFILLER_0_31_317 VPWR VGND VPWR VGND sky130_ef_sc_hd__decap_12
X_3616_ _1800_ net3 VGND VGND VPWR VPWR _1805_ sky130_fd_sc_hd__nor2_1
X_4596_ _2440_ VGND VGND VPWR VPWR _0027_ sky130_fd_sc_hd__inv_2
XFILLER_0_3_296 VGND VGND VPWR VPWR sky130_fd_sc_hd__decap_8
X_3547_ _1363_ _1460_ _1463_ VGND VGND VPWR VPWR _1739_ sky130_fd_sc_hd__a21oi_2
XFILLER_0_86_83 VGND VGND VPWR VPWR sky130_fd_sc_hd__fill_1
X_3478_ _1515_ _1670_ VGND VGND VPWR VPWR _1672_ sky130_fd_sc_hd__or2_1
X_5217_ clknet_leaf_29_clk _0593_ _0209_ VGND VGND VPWR VPWR RF0.regs\[6\]\[8\] sky130_fd_sc_hd__dfrtp_1
X_5148_ clknet_leaf_37_clk _0524_ _0140_ VGND VGND VPWR VPWR RF0.regs\[10\]\[3\] sky130_fd_sc_hd__dfrtp_1
X_5079_ clknet_leaf_45_clk _0455_ _0071_ VGND VGND VPWR VPWR RF0.regs\[20\]\[30\]
+ sky130_fd_sc_hd__dfrtp_1
XTAP_TAPCELL_ROW_70_816 VGND VPWR sky130_fd_sc_hd__tapvpwrvgnd_1
XFILLER_0_19_141 VPWR VGND VPWR VGND sky130_ef_sc_hd__decap_12
XFILLER_0_62_475 VGND VGND VPWR VPWR sky130_fd_sc_hd__fill_1
XPHY_EDGE_ROW_8_Left_96 VGND VGND VPWR VPWR sky130_fd_sc_hd__decap_3
XTAP_TAPCELL_ROW_7_251 VGND VPWR sky130_fd_sc_hd__tapvpwrvgnd_1
XTAP_TAPCELL_ROW_86_960 VGND VPWR sky130_fd_sc_hd__tapvpwrvgnd_1
XFILLER_0_15_57 VPWR VGND VPWR VGND sky130_ef_sc_hd__decap_12
XFILLER_0_45_409 VGND VGND VPWR VPWR sky130_fd_sc_hd__decap_4
X_2780_ _1069_ _1070_ _1071_ VGND VGND VPWR VPWR _1072_ sky130_fd_sc_hd__or3_4
XTAP_TAPCELL_ROW_41_562 VGND VPWR sky130_fd_sc_hd__tapvpwrvgnd_1
XFILLER_0_80_250 VGND VGND VPWR VPWR sky130_fd_sc_hd__fill_2
XFILLER_0_80_283 VGND VGND VPWR VPWR sky130_fd_sc_hd__fill_1
X_4450_ _2363_ VGND VGND VPWR VPWR _0412_ sky130_fd_sc_hd__clkbuf_1
Xhold207 RF0.regs\[6\]\[0\] VGND VGND VPWR VPWR net255 sky130_fd_sc_hd__dlygate4sd3_1
XFILLER_0_40_125 VGND VGND VPWR VPWR sky130_fd_sc_hd__fill_1
X_4381_ _2327_ VGND VGND VPWR VPWR _0445_ sky130_fd_sc_hd__clkbuf_1
Xhold218 RF0.regs\[6\]\[31\] VGND VGND VPWR VPWR net266 sky130_fd_sc_hd__dlygate4sd3_1
Xhold229 disp.digit_select\[0\] VGND VGND VPWR VPWR net277 sky130_fd_sc_hd__dlygate4sd3_1
X_3401_ RF0.regs\[0\]\[27\] _1219_ _1591_ _1594_ VGND VGND VPWR VPWR _1595_ sky130_fd_sc_hd__o22a_1
X_3332_ _1089_ _1503_ _1525_ _1527_ VGND VGND VPWR VPWR _1528_ sky130_fd_sc_hd__a211o_1
XFILLER_0_0_266 VPWR VGND VPWR VGND sky130_ef_sc_hd__decap_12
X_3263_ _1442_ _1445_ _1456_ _1457_ _1458_ VGND VGND VPWR VPWR _1459_ sky130_fd_sc_hd__a311o_1
X_5002_ _2488_ VGND VGND VPWR VPWR _0385_ sky130_fd_sc_hd__inv_2
X_3194_ _1047_ _1389_ VGND VGND VPWR VPWR _1390_ sky130_fd_sc_hd__or2_1
XFILLER_0_76_501 VPWR VGND VPWR VGND sky130_ef_sc_hd__decap_12
XFILLER_0_48_225 VPWR VGND VPWR VGND sky130_ef_sc_hd__decap_12
XFILLER_0_8_344 VGND VGND VPWR VPWR sky130_fd_sc_hd__decap_6
X_2978_ _1194_ VGND VGND VPWR VPWR _0701_ sky130_fd_sc_hd__clkbuf_1
XFILLER_0_71_250 VGND VGND VPWR VPWR sky130_fd_sc_hd__decap_6
X_4717_ _2456_ VGND VGND VPWR VPWR _0132_ sky130_fd_sc_hd__inv_2
X_4648_ _2435_ VGND VGND VPWR VPWR _2447_ sky130_fd_sc_hd__buf_1
X_4579_ _2438_ VGND VGND VPWR VPWR _0012_ sky130_fd_sc_hd__inv_2
XTAP_TAPCELL_ROW_4_221 VGND VPWR sky130_fd_sc_hd__tapvpwrvgnd_1
XFILLER_0_39_225 VGND VGND VPWR VPWR sky130_fd_sc_hd__fill_2
XTAP_TAPCELL_ROW_55_687 VGND VPWR sky130_fd_sc_hd__tapvpwrvgnd_1
XTAP_TAPCELL_ROW_10_278 VGND VPWR sky130_fd_sc_hd__tapvpwrvgnd_1
XFILLER_0_10_309 VGND VGND VPWR VPWR sky130_fd_sc_hd__decap_8
Xhold90 RF0.regs\[2\]\[19\] VGND VGND VPWR VPWR net138 sky130_fd_sc_hd__dlygate4sd3_1
XFILLER_0_58_501 VPWR VGND VPWR VGND sky130_ef_sc_hd__decap_12
X_3950_ _2101_ VGND VGND VPWR VPWR _0649_ sky130_fd_sc_hd__clkbuf_1
XFILLER_0_42_11 VGND VGND VPWR VPWR sky130_fd_sc_hd__fill_1
X_2901_ net160 VGND VGND VPWR VPWR _1156_ sky130_fd_sc_hd__clkbuf_1
X_3881_ _0798_ _1839_ _1840_ _1427_ VGND VGND VPWR VPWR _2047_ sky130_fd_sc_hd__or4bb_1
X_2832_ _1115_ VGND VGND VPWR VPWR _0768_ sky130_fd_sc_hd__clkbuf_1
X_2763_ _0997_ _0999_ _1052_ _1054_ VGND VGND VPWR VPWR _1055_ sky130_fd_sc_hd__a22o_1
X_4502_ disp.digits\[8\] _2386_ _2387_ disp.digits\[12\] VGND VGND VPWR VPWR _2391_
+ sky130_fd_sc_hd__a22o_1
XFILLER_0_41_434 VGND VGND VPWR VPWR sky130_fd_sc_hd__fill_1
X_2694_ _0967_ _0973_ _0979_ _0985_ VGND VGND VPWR VPWR _0986_ sky130_fd_sc_hd__or4_1
XFILLER_0_13_169 VPWR VGND VPWR VGND sky130_ef_sc_hd__decap_12
X_4433_ _2354_ VGND VGND VPWR VPWR _0420_ sky130_fd_sc_hd__clkbuf_1
XFILLER_0_21_191 VGND VGND VPWR VPWR sky130_fd_sc_hd__decap_6
X_4364_ _2318_ VGND VGND VPWR VPWR _0453_ sky130_fd_sc_hd__clkbuf_1
XFILLER_0_6_77 VGND VGND VPWR VPWR sky130_fd_sc_hd__decap_6
X_4295_ _2282_ VGND VGND VPWR VPWR _0486_ sky130_fd_sc_hd__clkbuf_1
X_3315_ _1510_ _1311_ _1312_ _0841_ VGND VGND VPWR VPWR _1511_ sky130_fd_sc_hd__o211a_1
XFILLER_0_67_52 VGND VGND VPWR VPWR sky130_fd_sc_hd__decap_4
XFILLER_0_67_74 VGND VGND VPWR VPWR sky130_fd_sc_hd__fill_2
X_3246_ _1441_ _0978_ VGND VGND VPWR VPWR _1442_ sky130_fd_sc_hd__xor2_2
XFILLER_0_83_51 VGND VGND VPWR VPWR sky130_fd_sc_hd__decap_4
XTAP_TAPCELL_ROW_1_202 VGND VPWR sky130_fd_sc_hd__tapvpwrvgnd_1
XFILLER_0_20_3 VPWR VGND VPWR VGND sky130_ef_sc_hd__decap_12
X_3177_ _1369_ _1372_ _1300_ VGND VGND VPWR VPWR _1373_ sky130_fd_sc_hd__o21a_1
Xrebuffer11 _1318_ VGND VGND VPWR VPWR net59 sky130_fd_sc_hd__dlymetal6s2s_1
XFILLER_0_68_309 VGND VGND VPWR VPWR sky130_fd_sc_hd__decap_6
XTAP_TAPCELL_ROW_80_911 VGND VPWR sky130_fd_sc_hd__tapvpwrvgnd_1
XTAP_TAPCELL_ROW_52_657 VGND VPWR sky130_fd_sc_hd__tapvpwrvgnd_1
XFILLER_0_17_431 VGND VGND VPWR VPWR sky130_fd_sc_hd__fill_1
XFILLER_0_36_228 VGND VGND VPWR VPWR sky130_fd_sc_hd__fill_2
XFILLER_0_17_475 VGND VGND VPWR VPWR sky130_fd_sc_hd__fill_2
XFILLER_0_12_191 VGND VGND VPWR VPWR sky130_fd_sc_hd__fill_1
XFILLER_0_86_139 VGND VGND VPWR VPWR sky130_fd_sc_hd__fill_1
XTAP_TAPCELL_ROW_15_326 VGND VPWR sky130_fd_sc_hd__tapvpwrvgnd_1
XFILLER_0_27_206 VGND VGND VPWR VPWR sky130_fd_sc_hd__decap_8
XTAP_TAPCELL_ROW_23_392 VGND VPWR sky130_fd_sc_hd__tapvpwrvgnd_1
X_3100_ _1263_ _1040_ VGND VGND VPWR VPWR _1296_ sky130_fd_sc_hd__or2_1
X_4080_ _2097_ RF0.regs\[6\]\[2\] _2160_ VGND VGND VPWR VPWR _2170_ sky130_fd_sc_hd__mux2_1
X_3031_ _1226_ VGND VGND VPWR VPWR _1227_ sky130_fd_sc_hd__clkbuf_4
XFILLER_0_37_88 VPWR VGND VPWR VGND sky130_ef_sc_hd__decap_12
X_4982_ _2480_ VGND VGND VPWR VPWR _2487_ sky130_fd_sc_hd__buf_4
XFILLER_0_53_65 VPWR VGND VPWR VGND sky130_ef_sc_hd__decap_12
X_3933_ _2030_ _2045_ VGND VGND VPWR VPWR _2090_ sky130_fd_sc_hd__xor2_4
X_3864_ _2031_ VGND VGND VPWR VPWR net28 sky130_fd_sc_hd__buf_1
X_2815_ net176 _1104_ VGND VGND VPWR VPWR _1106_ sky130_fd_sc_hd__and2_1
XFILLER_0_5_111 VGND VGND VPWR VPWR sky130_fd_sc_hd__fill_1
XFILLER_0_26_261 VGND VGND VPWR VPWR sky130_fd_sc_hd__decap_6
X_3795_ RF0.regs\[4\]\[26\] _1975_ _1953_ VGND VGND VPWR VPWR _1976_ sky130_fd_sc_hd__mux2_1
X_2746_ RF0.regs\[15\]\[8\] _0853_ _0862_ RF0.regs\[4\]\[8\] VGND VGND VPWR VPWR _1038_
+ sky130_fd_sc_hd__a22o_1
X_2677_ RF0.regs\[10\]\[10\] _0883_ _0853_ RF0.regs\[15\]\[10\] VGND VGND VPWR VPWR
+ _0969_ sky130_fd_sc_hd__a22o_1
X_4416_ _2345_ VGND VGND VPWR VPWR _0428_ sky130_fd_sc_hd__clkbuf_1
XFILLER_0_1_361 VPWR VGND VPWR VGND sky130_ef_sc_hd__decap_12
XFILLER_0_68_3 VPWR VGND VPWR VGND sky130_ef_sc_hd__decap_12
X_5396_ clknet_leaf_43_clk _0772_ _0388_ VGND VGND VPWR VPWR IM0.addr\[27\] sky130_fd_sc_hd__dfrtp_1
X_4347_ _2309_ VGND VGND VPWR VPWR _0461_ sky130_fd_sc_hd__clkbuf_1
X_4278_ net126 VGND VGND VPWR VPWR _2273_ sky130_fd_sc_hd__clkbuf_1
X_3229_ _0946_ _1423_ VGND VGND VPWR VPWR _1425_ sky130_fd_sc_hd__nand2_1
XTAP_TAPCELL_ROW_57_705 VGND VPWR sky130_fd_sc_hd__tapvpwrvgnd_1
XTAP_TAPCELL_ROW_65_771 VGND VPWR sky130_fd_sc_hd__tapvpwrvgnd_1
XFILLER_0_64_301 VGND VGND VPWR VPWR sky130_fd_sc_hd__decap_6
XTAP_TAPCELL_ROW_20_373 VGND VPWR sky130_fd_sc_hd__tapvpwrvgnd_1
XFILLER_0_32_253 VGND VGND VPWR VPWR sky130_fd_sc_hd__decap_6
XFILLER_0_32_286 VPWR VGND VPWR VGND sky130_ef_sc_hd__decap_12
XFILLER_0_20_459 VPWR VGND VPWR VGND sky130_ef_sc_hd__decap_12
XTAP_TAPCELL_ROW_28_440 VGND VPWR sky130_fd_sc_hd__tapvpwrvgnd_1
XFILLER_0_74_109 VPWR VGND VPWR VGND sky130_ef_sc_hd__decap_12
XFILLER_0_23_35 VGND VGND VPWR VPWR sky130_fd_sc_hd__fill_1
XFILLER_0_23_57 VGND VGND VPWR VPWR sky130_fd_sc_hd__fill_2
XFILLER_0_55_334 VGND VGND VPWR VPWR sky130_fd_sc_hd__fill_2
XFILLER_0_67_172 VPWR VGND VPWR VGND sky130_ef_sc_hd__decap_12
XFILLER_0_82_164 VGND VGND VPWR VPWR sky130_fd_sc_hd__decap_6
XFILLER_0_2_103 VGND VGND VPWR VPWR sky130_fd_sc_hd__fill_1
X_2600_ RF0.regs\[10\]\[29\] _0815_ _0830_ RF0.regs\[25\]\[29\] _0891_ VGND VGND VPWR
+ VPWR _0892_ sky130_fd_sc_hd__a221oi_4
Xrebuffer2 _1368_ VGND VGND VPWR VPWR net50 sky130_fd_sc_hd__dlygate4sd1_1
X_3580_ RF0.regs\[15\]\[12\] _1228_ _1770_ VGND VGND VPWR VPWR _1771_ sky130_fd_sc_hd__a21o_1
X_2531_ _0819_ _0820_ _0822_ _0807_ VGND VGND VPWR VPWR _0823_ sky130_fd_sc_hd__a211o_1
X_5250_ clknet_leaf_28_clk _0626_ _0242_ VGND VGND VPWR VPWR RF0.regs\[5\]\[9\] sky130_fd_sc_hd__dfrtp_1
X_4201_ _2234_ VGND VGND VPWR VPWR _0532_ sky130_fd_sc_hd__clkbuf_1
X_5181_ clknet_leaf_33_clk _0557_ _0173_ VGND VGND VPWR VPWR RF0.regs\[7\]\[4\] sky130_fd_sc_hd__dfrtp_1
X_4132_ _2198_ VGND VGND VPWR VPWR _0565_ sky130_fd_sc_hd__clkbuf_1
X_4063_ _2161_ VGND VGND VPWR VPWR _0596_ sky130_fd_sc_hd__clkbuf_1
XTAP_TAPCELL_ROW_79_896 VGND VPWR sky130_fd_sc_hd__tapvpwrvgnd_1
X_3014_ _1212_ VGND VGND VPWR VPWR _0683_ sky130_fd_sc_hd__clkbuf_1
XFILLER_0_3_89 VGND VGND VPWR VPWR sky130_fd_sc_hd__decap_3
X_4965_ _2485_ VGND VGND VPWR VPWR _0351_ sky130_fd_sc_hd__inv_2
XFILLER_0_80_41 VPWR VGND VPWR VGND sky130_ef_sc_hd__decap_12
X_3916_ RF0.regs\[4\]\[10\] _2077_ _2073_ VGND VGND VPWR VPWR _2078_ sky130_fd_sc_hd__mux2_1
XFILLER_0_58_194 VGND VGND VPWR VPWR sky130_fd_sc_hd__fill_2
XFILLER_0_73_142 VGND VGND VPWR VPWR sky130_fd_sc_hd__decap_3
XTAP_TAPCELL_ROW_34_498 VGND VPWR sky130_fd_sc_hd__tapvpwrvgnd_1
X_4896_ _2471_ VGND VGND VPWR VPWR _2477_ sky130_fd_sc_hd__clkbuf_4
X_3847_ _2014_ _1739_ _2015_ _1380_ VGND VGND VPWR VPWR _2016_ sky130_fd_sc_hd__o22a_1
XFILLER_0_6_475 VGND VGND VPWR VPWR sky130_fd_sc_hd__fill_1
X_3778_ _1959_ _1961_ VGND VGND VPWR VPWR _1962_ sky130_fd_sc_hd__xnor2_2
XFILLER_0_61_337 VGND VGND VPWR VPWR sky130_fd_sc_hd__decap_6
X_2729_ RF0.regs\[5\]\[21\] _0901_ _0871_ VGND VGND VPWR VPWR _1021_ sky130_fd_sc_hd__and3_1
X_5379_ clknet_leaf_41_clk _0755_ _0371_ VGND VGND VPWR VPWR IM0.addr\[10\] sky130_fd_sc_hd__dfrtp_1
XPHY_EDGE_ROW_29_Right_29 VGND VGND VPWR VPWR sky130_fd_sc_hd__decap_3
XFILLER_0_84_407 VPWR VGND VPWR VGND sky130_ef_sc_hd__decap_12
XTAP_TAPCELL_ROW_25_410 VGND VPWR sky130_fd_sc_hd__tapvpwrvgnd_1
XFILLER_0_77_481 VPWR VGND VPWR VGND sky130_ef_sc_hd__decap_12
XPHY_EDGE_ROW_38_Right_38 VGND VGND VPWR VPWR sky130_fd_sc_hd__decap_3
XFILLER_0_64_175 VGND VGND VPWR VPWR sky130_fd_sc_hd__decap_4
XFILLER_0_64_186 VGND VGND VPWR VPWR sky130_fd_sc_hd__decap_8
XFILLER_0_64_197 VPWR VGND VPWR VGND sky130_ef_sc_hd__decap_12
XFILLER_0_60_392 VGND VGND VPWR VPWR sky130_fd_sc_hd__decap_8
XPHY_EDGE_ROW_47_Right_47 VGND VGND VPWR VPWR sky130_fd_sc_hd__decap_3
XTAP_TAPCELL_ROW_76_877 VGND VPWR sky130_fd_sc_hd__tapvpwrvgnd_1
XFILLER_0_34_56 VGND VGND VPWR VPWR sky130_fd_sc_hd__decap_4
XFILLER_0_7_206 VGND VGND VPWR VPWR sky130_fd_sc_hd__decap_8
X_4750_ _2460_ VGND VGND VPWR VPWR _0161_ sky130_fd_sc_hd__inv_2
XPHY_EDGE_ROW_56_Right_56 VGND VGND VPWR VPWR sky130_fd_sc_hd__decap_3
XFILLER_0_83_473 VPWR VGND VPWR VGND sky130_ef_sc_hd__decap_12
X_3701_ RF0.regs\[25\]\[0\] _0807_ _0954_ _0794_ VGND VGND VPWR VPWR _1887_ sky130_fd_sc_hd__a211o_1
XTAP_TAPCELL_ROW_31_468 VGND VPWR sky130_fd_sc_hd__tapvpwrvgnd_1
X_4681_ _2451_ VGND VGND VPWR VPWR _2452_ sky130_fd_sc_hd__buf_2
XFILLER_0_50_66 VGND VGND VPWR VPWR sky130_fd_sc_hd__decap_4
X_3632_ _1816_ _1817_ _1819_ _1216_ RF0.regs\[0\]\[8\] VGND VGND VPWR VPWR _1820_
+ sky130_fd_sc_hd__o32a_1
XFILLER_0_50_88 VGND VGND VPWR VPWR sky130_fd_sc_hd__fill_1
X_3563_ RF0.regs\[7\]\[14\] _1244_ _1752_ _1754_ VGND VGND VPWR VPWR _1755_ sky130_fd_sc_hd__a211o_1
XFILLER_0_11_212 VGND VGND VPWR VPWR sky130_fd_sc_hd__fill_1
X_5302_ clknet_leaf_0_clk _0678_ _0294_ VGND VGND VPWR VPWR RF0.regs\[4\]\[29\] sky130_fd_sc_hd__dfrtp_1
X_2514_ _0800_ _0802_ VGND VGND VPWR VPWR _0806_ sky130_fd_sc_hd__and2_1
X_3494_ _1684_ _1685_ VGND VGND VPWR VPWR _1687_ sky130_fd_sc_hd__nor2_1
XFILLER_0_11_267 VGND VGND VPWR VPWR sky130_fd_sc_hd__fill_2
X_5233_ clknet_leaf_7_clk _0609_ _0225_ VGND VGND VPWR VPWR RF0.regs\[6\]\[24\] sky130_fd_sc_hd__dfrtp_1
XPHY_EDGE_ROW_65_Right_65 VGND VGND VPWR VPWR sky130_fd_sc_hd__decap_3
X_5164_ clknet_leaf_13_clk _0540_ _0156_ VGND VGND VPWR VPWR RF0.regs\[10\]\[19\]
+ sky130_fd_sc_hd__dfrtp_2
X_4115_ net131 VGND VGND VPWR VPWR _2190_ sky130_fd_sc_hd__clkbuf_1
X_5095_ clknet_leaf_20_clk _0471_ _0087_ VGND VGND VPWR VPWR RF0.regs\[15\]\[14\]
+ sky130_fd_sc_hd__dfrtp_1
X_4046_ _2152_ VGND VGND VPWR VPWR _0604_ sky130_fd_sc_hd__clkbuf_1
Xclone7 _0792_ VGND VGND VPWR VPWR net55 sky130_fd_sc_hd__clkdlybuf4s15_2
XFILLER_0_78_278 VGND VGND VPWR VPWR sky130_fd_sc_hd__decap_6
XPHY_EDGE_ROW_74_Right_74 VGND VGND VPWR VPWR sky130_fd_sc_hd__decap_3
X_4948_ _2483_ VGND VGND VPWR VPWR _0336_ sky130_fd_sc_hd__inv_2
XFILLER_0_19_334 VGND VGND VPWR VPWR sky130_fd_sc_hd__fill_2
XFILLER_0_19_345 VGND VGND VPWR VPWR sky130_fd_sc_hd__fill_1
XFILLER_0_46_153 VPWR VGND VPWR VGND sky130_ef_sc_hd__decap_12
X_4879_ _2475_ VGND VGND VPWR VPWR _0275_ sky130_fd_sc_hd__inv_2
XFILLER_0_61_134 VGND VGND VPWR VPWR sky130_fd_sc_hd__decap_4
XPHY_EDGE_ROW_83_Right_83 VGND VGND VPWR VPWR sky130_fd_sc_hd__decap_3
XTAP_TAPCELL_ROW_73_847 VGND VPWR sky130_fd_sc_hd__tapvpwrvgnd_1
XFILLER_0_69_278 VGND VGND VPWR VPWR sky130_fd_sc_hd__fill_2
XFILLER_0_37_131 VGND VGND VPWR VPWR sky130_fd_sc_hd__decap_6
XFILLER_0_65_484 VPWR VGND VPWR VGND sky130_ef_sc_hd__decap_12
XFILLER_0_25_326 VGND VGND VPWR VPWR sky130_fd_sc_hd__decap_8
XFILLER_0_25_337 VGND VGND VPWR VPWR sky130_fd_sc_hd__fill_2
XFILLER_0_29_34 VPWR VGND VPWR VGND sky130_ef_sc_hd__decap_12
XTAP_TAPCELL_ROW_36_516 VGND VPWR sky130_fd_sc_hd__tapvpwrvgnd_1
XFILLER_0_0_57 VPWR VGND VPWR VGND sky130_ef_sc_hd__decap_12
X_4802_ _2467_ VGND VGND VPWR VPWR _0206_ sky130_fd_sc_hd__inv_2
XTAP_TAPCELL_ROW_44_582 VGND VPWR sky130_fd_sc_hd__tapvpwrvgnd_1
X_2994_ _1202_ VGND VGND VPWR VPWR _0693_ sky130_fd_sc_hd__clkbuf_1
X_4733_ _2459_ VGND VGND VPWR VPWR _0145_ sky130_fd_sc_hd__inv_2
XFILLER_0_56_473 VGND VGND VPWR VPWR sky130_fd_sc_hd__decap_3
XFILLER_0_28_197 VPWR VGND VPWR VGND sky130_ef_sc_hd__decap_12
X_4664_ _2449_ VGND VGND VPWR VPWR _0086_ sky130_fd_sc_hd__inv_2
XFILLER_0_9_77 VGND VGND VPWR VPWR sky130_fd_sc_hd__fill_1
XFILLER_0_9_55 VGND VGND VPWR VPWR sky130_fd_sc_hd__fill_1
XFILLER_0_43_167 VGND VGND VPWR VPWR sky130_fd_sc_hd__fill_1
XFILLER_0_3_231 VGND VGND VPWR VPWR sky130_fd_sc_hd__fill_1
XFILLER_0_3_242 VGND VGND VPWR VPWR sky130_fd_sc_hd__fill_2
XFILLER_0_31_329 VGND VGND VPWR VPWR sky130_fd_sc_hd__decap_6
X_4595_ _2437_ VGND VGND VPWR VPWR _2440_ sky130_fd_sc_hd__clkbuf_8
X_3615_ _1804_ VGND VGND VPWR VPWR net3 sky130_fd_sc_hd__buf_1
X_3546_ RF0.regs\[0\]\[15\] _1218_ _1737_ VGND VGND VPWR VPWR _1738_ sky130_fd_sc_hd__o21ai_1
X_3477_ _1515_ _1670_ VGND VGND VPWR VPWR _1671_ sky130_fd_sc_hd__nand2_1
X_5216_ clknet_leaf_28_clk _0592_ _0208_ VGND VGND VPWR VPWR RF0.regs\[6\]\[7\] sky130_fd_sc_hd__dfrtp_1
XFILLER_0_50_3 VGND VGND VPWR VPWR sky130_fd_sc_hd__fill_2
X_5147_ clknet_leaf_36_clk _0523_ _0139_ VGND VGND VPWR VPWR RF0.regs\[10\]\[2\] sky130_fd_sc_hd__dfrtp_1
X_5078_ clknet_leaf_0_clk _0454_ _0070_ VGND VGND VPWR VPWR RF0.regs\[20\]\[29\] sky130_fd_sc_hd__dfrtp_1
X_4029_ _2143_ VGND VGND VPWR VPWR _0612_ sky130_fd_sc_hd__clkbuf_1
XTAP_TAPCELL_ROW_70_817 VGND VPWR sky130_fd_sc_hd__tapvpwrvgnd_1
XFILLER_0_39_429 VGND VGND VPWR VPWR sky130_fd_sc_hd__decap_8
XFILLER_0_47_440 VGND VGND VPWR VPWR sky130_fd_sc_hd__fill_1
XFILLER_0_62_421 VGND VGND VPWR VPWR sky130_fd_sc_hd__fill_1
XTAP_TAPCELL_ROW_7_252 VGND VPWR sky130_fd_sc_hd__tapvpwrvgnd_1
XTAP_TAPCELL_ROW_86_961 VGND VPWR sky130_fd_sc_hd__tapvpwrvgnd_1
XFILLER_0_15_69 VPWR VGND VPWR VGND sky130_ef_sc_hd__decap_12
XFILLER_0_57_204 VGND VGND VPWR VPWR sky130_fd_sc_hd__decap_8
XFILLER_0_38_473 VGND VGND VPWR VPWR sky130_fd_sc_hd__decap_3
XFILLER_0_65_281 VPWR VGND VPWR VGND sky130_ef_sc_hd__decap_12
Xhold208 RF0.regs\[20\]\[29\] VGND VGND VPWR VPWR net256 sky130_fd_sc_hd__dlygate4sd3_1
X_4380_ RF0.regs\[20\]\[20\] _1996_ _2325_ VGND VGND VPWR VPWR _2327_ sky130_fd_sc_hd__mux2_1
Xhold219 RF0.regs\[6\]\[13\] VGND VGND VPWR VPWR net267 sky130_fd_sc_hd__dlygate4sd3_1
X_3400_ RF0.regs\[7\]\[27\] _1245_ _1593_ VGND VGND VPWR VPWR _1594_ sky130_fd_sc_hd__a21o_1
X_3331_ RF0.regs\[4\]\[22\] _0838_ _1138_ RF0.regs\[12\]\[22\] _1526_ VGND VGND VPWR
+ VPWR _1527_ sky130_fd_sc_hd__a221oi_1
XFILLER_0_0_278 VGND VGND VPWR VPWR sky130_fd_sc_hd__fill_2
X_3262_ _0978_ _1441_ VGND VGND VPWR VPWR _1458_ sky130_fd_sc_hd__and2_1
X_5001_ _2488_ VGND VGND VPWR VPWR _0384_ sky130_fd_sc_hd__inv_2
X_3193_ _0826_ _1387_ _1388_ VGND VGND VPWR VPWR _1389_ sky130_fd_sc_hd__or3_1
XTAP_TAPCELL_ROW_49_630 VGND VPWR sky130_fd_sc_hd__tapvpwrvgnd_1
XFILLER_0_72_42 VPWR VGND VPWR VGND sky130_ef_sc_hd__decap_12
XFILLER_0_76_513 VGND VGND VPWR VPWR sky130_fd_sc_hd__decap_4
XFILLER_0_48_237 VGND VGND VPWR VPWR sky130_fd_sc_hd__fill_2
XFILLER_0_44_421 VPWR VGND VPWR VGND sky130_ef_sc_hd__decap_12
X_2977_ net118 VGND VGND VPWR VPWR _1194_ sky130_fd_sc_hd__clkbuf_1
X_4716_ _2456_ VGND VGND VPWR VPWR _0131_ sky130_fd_sc_hd__inv_2
X_4647_ _2446_ VGND VGND VPWR VPWR _0072_ sky130_fd_sc_hd__inv_2
XFILLER_0_31_137 VGND VGND VPWR VPWR sky130_fd_sc_hd__fill_1
X_4578_ _2438_ VGND VGND VPWR VPWR _0011_ sky130_fd_sc_hd__inv_2
XFILLER_0_12_362 VGND VGND VPWR VPWR sky130_fd_sc_hd__fill_2
X_3529_ _1720_ VGND VGND VPWR VPWR _1721_ sky130_fd_sc_hd__inv_2
XTAP_TAPCELL_ROW_4_222 VGND VPWR sky130_fd_sc_hd__tapvpwrvgnd_1
XTAP_TAPCELL_ROW_55_688 VGND VPWR sky130_fd_sc_hd__tapvpwrvgnd_1
XFILLER_0_62_251 VGND VGND VPWR VPWR sky130_fd_sc_hd__fill_1
XFILLER_0_22_104 VPWR VGND VPWR VGND sky130_ef_sc_hd__decap_12
XTAP_TAPCELL_ROW_10_279 VGND VPWR sky130_fd_sc_hd__tapvpwrvgnd_1
XFILLER_0_50_457 VGND VGND VPWR VPWR sky130_fd_sc_hd__decap_4
Xhold91 IM0.addr\[25\] VGND VGND VPWR VPWR net139 sky130_fd_sc_hd__dlygate4sd3_1
XTAP_TAPCELL_ROW_46_600 VGND VPWR sky130_fd_sc_hd__tapvpwrvgnd_1
Xhold80 RF0.regs\[0\]\[24\] VGND VGND VPWR VPWR net128 sky130_fd_sc_hd__dlygate4sd3_1
XFILLER_0_58_513 VGND VGND VPWR VPWR sky130_fd_sc_hd__decap_4
XFILLER_0_42_23 VGND VGND VPWR VPWR sky130_fd_sc_hd__fill_2
XFILLER_0_42_34 VPWR VGND VPWR VGND sky130_ef_sc_hd__decap_12
X_2900_ _1155_ VGND VGND VPWR VPWR _0740_ sky130_fd_sc_hd__clkbuf_1
XFILLER_0_85_365 VPWR VGND VPWR VGND sky130_ef_sc_hd__decap_12
XFILLER_0_73_505 VPWR VGND VPWR VGND sky130_ef_sc_hd__decap_12
X_3880_ _2030_ _2045_ _2029_ VGND VGND VPWR VPWR _2046_ sky130_fd_sc_hd__a21oi_1
XFILLER_0_42_67 VPWR VGND VPWR VGND sky130_ef_sc_hd__decap_12
X_2831_ _1108_ net185 VGND VGND VPWR VPWR _1115_ sky130_fd_sc_hd__and2_1
XFILLER_0_26_421 VPWR VGND VPWR VGND sky130_ef_sc_hd__decap_12
XFILLER_0_5_337 VGND VGND VPWR VPWR sky130_fd_sc_hd__fill_2
X_2762_ RF0.regs\[10\]\[14\] _0811_ _0828_ RF0.regs\[25\]\[14\] _1053_ VGND VGND VPWR
+ VPWR _1054_ sky130_fd_sc_hd__a221o_2
X_4501_ disp.digits\[1\] _0777_ _2389_ VGND VGND VPWR VPWR _2390_ sky130_fd_sc_hd__o21a_1
XFILLER_0_41_468 VGND VGND VPWR VPWR sky130_fd_sc_hd__decap_3
X_2693_ _0982_ _0984_ VGND VGND VPWR VPWR _0985_ sky130_fd_sc_hd__xor2_1
X_4432_ RF0.regs\[25\]\[27\] _1971_ _2349_ VGND VGND VPWR VPWR _2354_ sky130_fd_sc_hd__mux2_1
XFILLER_0_53_295 VGND VGND VPWR VPWR sky130_fd_sc_hd__fill_1
X_4363_ net265 _1965_ _2314_ VGND VGND VPWR VPWR _2318_ sky130_fd_sc_hd__mux2_1
X_4294_ RF0.regs\[15\]\[29\] _1962_ _2279_ VGND VGND VPWR VPWR _2282_ sky130_fd_sc_hd__mux2_1
X_3314_ net51 _1310_ VGND VGND VPWR VPWR _1510_ sky130_fd_sc_hd__nor2_1
X_3245_ _1257_ _1273_ _1440_ _1299_ _1252_ VGND VGND VPWR VPWR _1441_ sky130_fd_sc_hd__a311o_2
Xrebuffer12 _1442_ VGND VGND VPWR VPWR net60 sky130_fd_sc_hd__dlygate4sd1_1
X_3176_ _1257_ _1371_ _1220_ VGND VGND VPWR VPWR _1372_ sky130_fd_sc_hd__a21oi_1
XFILLER_0_13_3 VPWR VGND VPWR VGND sky130_ef_sc_hd__decap_12
XTAP_TAPCELL_ROW_80_912 VGND VPWR sky130_fd_sc_hd__tapvpwrvgnd_1
XFILLER_0_76_365 VGND VGND VPWR VPWR sky130_fd_sc_hd__fill_1
XTAP_TAPCELL_ROW_52_658 VGND VPWR sky130_fd_sc_hd__tapvpwrvgnd_1
XFILLER_0_64_505 VPWR VGND VPWR VGND sky130_ef_sc_hd__decap_12
XFILLER_0_8_197 VPWR VGND VPWR VGND sky130_ef_sc_hd__decap_12
XFILLER_0_44_251 VGND VGND VPWR VPWR sky130_fd_sc_hd__fill_1
XFILLER_0_32_424 VGND VGND VPWR VPWR sky130_fd_sc_hd__fill_1
XFILLER_0_32_457 VPWR VGND VPWR VGND sky130_ef_sc_hd__decap_12
XFILLER_0_40_490 VGND VGND VPWR VPWR sky130_fd_sc_hd__decap_6
XTAP_TAPCELL_ROW_15_327 VGND VPWR sky130_fd_sc_hd__tapvpwrvgnd_1
XFILLER_0_55_505 VGND VGND VPWR VPWR sky130_fd_sc_hd__decap_8
XFILLER_0_67_365 VPWR VGND VPWR VGND sky130_ef_sc_hd__decap_12
XFILLER_0_12_15 VPWR VGND VPWR VGND sky130_ef_sc_hd__decap_12
XFILLER_0_70_508 VGND VGND VPWR VPWR sky130_fd_sc_hd__decap_8
XTAP_TAPCELL_ROW_23_393 VGND VPWR sky130_fd_sc_hd__tapvpwrvgnd_1
XFILLER_0_23_413 VGND VGND VPWR VPWR sky130_fd_sc_hd__fill_1
XFILLER_0_2_318 VGND VGND VPWR VPWR sky130_fd_sc_hd__fill_2
XFILLER_0_23_446 VGND VGND VPWR VPWR sky130_fd_sc_hd__fill_2
Xoutput2 net2 VGND VGND VPWR VPWR Result[0] sky130_fd_sc_hd__buf_2
X_3030_ _0819_ _0850_ _0849_ _1216_ VGND VGND VPWR VPWR _1226_ sky130_fd_sc_hd__o211a_2
X_4981_ _2486_ VGND VGND VPWR VPWR _0366_ sky130_fd_sc_hd__inv_2
XFILLER_0_53_55 VGND VGND VPWR VPWR sky130_fd_sc_hd__fill_1
XFILLER_0_53_77 VPWR VGND VPWR VGND sky130_ef_sc_hd__decap_12
XFILLER_0_58_321 VPWR VGND VPWR VGND sky130_ef_sc_hd__decap_12
Xclkbuf_leaf_43_clk clknet_2_0__leaf_clk VGND VGND VPWR VPWR clknet_leaf_43_clk sky130_fd_sc_hd__clkbuf_8
X_3932_ _2089_ VGND VGND VPWR VPWR _0655_ sky130_fd_sc_hd__clkbuf_1
XFILLER_0_73_313 VGND VGND VPWR VPWR sky130_fd_sc_hd__decap_8
X_3863_ _1008_ _1852_ _1853_ VGND VGND VPWR VPWR _2031_ sky130_fd_sc_hd__and3_1
X_2814_ _1105_ VGND VGND VPWR VPWR _0776_ sky130_fd_sc_hd__clkbuf_1
XFILLER_0_26_273 VGND VGND VPWR VPWR sky130_fd_sc_hd__decap_4
X_3794_ _1969_ _1974_ VGND VGND VPWR VPWR _1975_ sky130_fd_sc_hd__and2_1
XFILLER_0_14_446 VPWR VGND VPWR VGND sky130_ef_sc_hd__decap_12
XFILLER_0_14_424 VGND VGND VPWR VPWR sky130_fd_sc_hd__fill_2
X_2745_ RF0.regs\[10\]\[26\] _0817_ _0830_ RF0.regs\[25\]\[26\] _1036_ VGND VGND VPWR
+ VPWR _1037_ sky130_fd_sc_hd__a221oi_2
XFILLER_0_78_41 VPWR VGND VPWR VGND sky130_ef_sc_hd__decap_12
X_2676_ RF0.regs\[5\]\[10\] _0873_ _0862_ RF0.regs\[4\]\[10\] VGND VGND VPWR VPWR
+ _0968_ sky130_fd_sc_hd__a22o_1
XFILLER_0_78_85 VGND VGND VPWR VPWR sky130_fd_sc_hd__fill_2
X_5395_ clknet_leaf_43_clk _0771_ _0387_ VGND VGND VPWR VPWR IM0.addr\[26\] sky130_fd_sc_hd__dfrtp_1
X_4415_ net181 _2094_ _2336_ VGND VGND VPWR VPWR _2345_ sky130_fd_sc_hd__mux2_1
X_4346_ RF0.regs\[15\]\[4\] _2092_ _2301_ VGND VGND VPWR VPWR _2309_ sky130_fd_sc_hd__mux2_1
XFILLER_0_1_373 VPWR VGND VPWR VGND sky130_ef_sc_hd__decap_12
X_4277_ _2272_ VGND VGND VPWR VPWR _0494_ sky130_fd_sc_hd__clkbuf_1
X_3228_ _0946_ _1423_ VGND VGND VPWR VPWR _1424_ sky130_fd_sc_hd__or2_1
XTAP_TAPCELL_ROW_57_706 VGND VPWR sky130_fd_sc_hd__tapvpwrvgnd_1
X_3159_ _0829_ _1329_ _1354_ VGND VGND VPWR VPWR _1355_ sky130_fd_sc_hd__or3_1
XTAP_TAPCELL_ROW_65_772 VGND VPWR sky130_fd_sc_hd__tapvpwrvgnd_1
Xclkbuf_leaf_34_clk clknet_2_2__leaf_clk VGND VGND VPWR VPWR clknet_leaf_34_clk sky130_fd_sc_hd__clkbuf_8
XFILLER_0_37_505 VGND VGND VPWR VPWR sky130_fd_sc_hd__decap_3
XFILLER_0_37_516 VGND VGND VPWR VPWR sky130_fd_sc_hd__fill_1
XFILLER_0_49_376 VGND VGND VPWR VPWR sky130_fd_sc_hd__decap_3
XFILLER_0_9_495 VGND VGND VPWR VPWR sky130_fd_sc_hd__decap_8
XFILLER_0_32_265 VGND VGND VPWR VPWR sky130_fd_sc_hd__fill_1
XFILLER_0_32_298 VGND VGND VPWR VPWR sky130_fd_sc_hd__decap_8
XFILLER_0_2_3 VPWR VGND VPWR VGND sky130_ef_sc_hd__decap_12
XFILLER_0_87_405 VPWR VGND VPWR VGND sky130_ef_sc_hd__decap_12
XTAP_TAPCELL_ROW_28_441 VGND VPWR sky130_fd_sc_hd__tapvpwrvgnd_1
XFILLER_0_87_449 VPWR VGND VPWR VGND sky130_ef_sc_hd__decap_12
XFILLER_0_28_516 VGND VGND VPWR VPWR sky130_fd_sc_hd__fill_1
Xclkbuf_leaf_25_clk clknet_2_3__leaf_clk VGND VGND VPWR VPWR clknet_leaf_25_clk sky130_fd_sc_hd__clkbuf_8
XFILLER_0_67_184 VPWR VGND VPWR VGND sky130_ef_sc_hd__decap_12
XFILLER_0_43_508 VGND VGND VPWR VPWR sky130_fd_sc_hd__decap_3
Xrebuffer3 _1308_ VGND VGND VPWR VPWR net51 sky130_fd_sc_hd__dlygate4sd1_1
X_2530_ _0821_ _0796_ VGND VGND VPWR VPWR _0822_ sky130_fd_sc_hd__or2_1
XFILLER_0_23_287 VGND VGND VPWR VPWR sky130_fd_sc_hd__fill_1
XFILLER_0_48_33 VGND VGND VPWR VPWR sky130_fd_sc_hd__fill_1
X_4200_ net276 _2072_ _2233_ VGND VGND VPWR VPWR _2234_ sky130_fd_sc_hd__mux2_1
X_5180_ clknet_leaf_35_clk _0556_ _0172_ VGND VGND VPWR VPWR RF0.regs\[7\]\[3\] sky130_fd_sc_hd__dfrtp_1
X_4131_ net88 VGND VGND VPWR VPWR _2198_ sky130_fd_sc_hd__clkbuf_1
X_4062_ _2072_ net251 _2160_ VGND VGND VPWR VPWR _2161_ sky130_fd_sc_hd__mux2_1
XTAP_TAPCELL_ROW_79_897 VGND VPWR sky130_fd_sc_hd__tapvpwrvgnd_1
XFILLER_0_3_57 VPWR VGND VPWR VGND sky130_ef_sc_hd__decap_12
X_3013_ RF0.regs\[2\]\[2\] VGND VGND VPWR VPWR _1212_ sky130_fd_sc_hd__clkbuf_1
XFILLER_0_64_32 VPWR VGND VPWR VGND sky130_ef_sc_hd__decap_12
X_4964_ _2485_ VGND VGND VPWR VPWR _0350_ sky130_fd_sc_hd__inv_2
XFILLER_0_19_505 VGND VGND VPWR VPWR sky130_fd_sc_hd__decap_4
Xclkbuf_leaf_16_clk clknet_2_3__leaf_clk VGND VGND VPWR VPWR clknet_leaf_16_clk sky130_fd_sc_hd__clkbuf_8
XFILLER_0_80_53 VPWR VGND VPWR VGND sky130_ef_sc_hd__decap_12
X_3915_ _2075_ _2076_ VGND VGND VPWR VPWR _2077_ sky130_fd_sc_hd__xnor2_4
XTAP_TAPCELL_ROW_34_499 VGND VPWR sky130_fd_sc_hd__tapvpwrvgnd_1
X_4895_ _2476_ VGND VGND VPWR VPWR _0290_ sky130_fd_sc_hd__inv_2
XFILLER_0_6_432 VGND VGND VPWR VPWR sky130_fd_sc_hd__decap_3
X_3846_ _1381_ _1739_ VGND VGND VPWR VPWR _2015_ sky130_fd_sc_hd__nand2_1
XFILLER_0_80_3 VPWR VGND VPWR VGND sky130_ef_sc_hd__decap_12
X_3777_ _1586_ _1960_ VGND VGND VPWR VPWR _1961_ sky130_fd_sc_hd__nand2_1
X_2728_ _0947_ _0953_ _0960_ _1019_ VGND VGND VPWR VPWR _1020_ sky130_fd_sc_hd__or4_1
X_2659_ RF0.regs\[4\]\[5\] _0835_ _0843_ RF0.regs\[12\]\[5\] VGND VGND VPWR VPWR _0951_
+ sky130_fd_sc_hd__a22o_1
XFILLER_0_10_471 VGND VGND VPWR VPWR sky130_fd_sc_hd__decap_4
X_5378_ clknet_leaf_41_clk _0754_ _0370_ VGND VGND VPWR VPWR IM0.addr\[9\] sky130_fd_sc_hd__dfrtp_1
X_4329_ RF0.regs\[15\]\[12\] _2069_ _2290_ VGND VGND VPWR VPWR _2300_ sky130_fd_sc_hd__mux2_1
XFILLER_0_69_405 VGND VGND VPWR VPWR sky130_fd_sc_hd__decap_3
XFILLER_0_69_449 VGND VGND VPWR VPWR sky130_fd_sc_hd__fill_2
XFILLER_0_84_419 VGND VGND VPWR VPWR sky130_fd_sc_hd__fill_1
XTAP_TAPCELL_ROW_25_411 VGND VPWR sky130_fd_sc_hd__tapvpwrvgnd_1
XFILLER_0_77_493 VGND VGND VPWR VPWR sky130_fd_sc_hd__decap_8
XFILLER_0_9_281 VGND VGND VPWR VPWR sky130_fd_sc_hd__fill_1
XFILLER_0_45_390 VGND VGND VPWR VPWR sky130_fd_sc_hd__fill_2
XFILLER_0_87_279 VGND VGND VPWR VPWR sky130_fd_sc_hd__fill_1
XFILLER_0_68_482 VPWR VGND VPWR VGND sky130_ef_sc_hd__decap_12
X_3700_ RF0.regs\[6\]\[0\] _1230_ _1226_ RF0.regs\[15\]\[0\] _1885_ VGND VGND VPWR
+ VPWR _1886_ sky130_fd_sc_hd__a221o_1
XFILLER_0_83_485 VPWR VGND VPWR VGND sky130_ef_sc_hd__decap_12
X_4680_ _2435_ VGND VGND VPWR VPWR _2451_ sky130_fd_sc_hd__clkbuf_2
XFILLER_0_43_305 VGND VGND VPWR VPWR sky130_fd_sc_hd__decap_4
XFILLER_0_50_45 VGND VGND VPWR VPWR sky130_fd_sc_hd__fill_1
XTAP_TAPCELL_ROW_31_469 VGND VPWR sky130_fd_sc_hd__tapvpwrvgnd_1
X_3631_ RF0.regs\[5\]\[8\] _0865_ _1221_ RF0.regs\[20\]\[8\] _1818_ VGND VGND VPWR
+ VPWR _1819_ sky130_fd_sc_hd__a221o_1
X_3562_ RF0.regs\[4\]\[14\] _1239_ _1227_ RF0.regs\[15\]\[14\] _1753_ VGND VGND VPWR
+ VPWR _1754_ sky130_fd_sc_hd__a221o_1
X_2513_ _0799_ _0804_ VGND VGND VPWR VPWR _0805_ sky130_fd_sc_hd__nand2_1
X_5301_ clknet_leaf_1_clk _0677_ _0293_ VGND VGND VPWR VPWR RF0.regs\[4\]\[28\] sky130_fd_sc_hd__dfrtp_1
XFILLER_0_51_360 VPWR VGND VPWR VGND sky130_ef_sc_hd__decap_12
XFILLER_0_59_65 VPWR VGND VPWR VGND sky130_ef_sc_hd__decap_12
X_3493_ _1684_ _1685_ VGND VGND VPWR VPWR _1686_ sky130_fd_sc_hd__and2_1
X_5232_ clknet_leaf_10_clk _0608_ _0224_ VGND VGND VPWR VPWR RF0.regs\[6\]\[23\] sky130_fd_sc_hd__dfrtp_1
Xclkbuf_leaf_5_clk clknet_2_1__leaf_clk VGND VGND VPWR VPWR clknet_leaf_5_clk sky130_fd_sc_hd__clkbuf_8
X_5163_ clknet_leaf_13_clk _0539_ _0155_ VGND VGND VPWR VPWR RF0.regs\[10\]\[18\]
+ sky130_fd_sc_hd__dfrtp_1
X_4114_ _2189_ VGND VGND VPWR VPWR _0574_ sky130_fd_sc_hd__clkbuf_1
X_5094_ clknet_leaf_21_clk _0470_ _0086_ VGND VGND VPWR VPWR RF0.regs\[15\]\[13\]
+ sky130_fd_sc_hd__dfrtp_1
X_4045_ _2000_ net252 _2149_ VGND VGND VPWR VPWR _2152_ sky130_fd_sc_hd__mux2_1
XTAP_TAPCELL_ROW_39_536 VGND VPWR sky130_fd_sc_hd__tapvpwrvgnd_1
XFILLER_0_78_213 VGND VGND VPWR VPWR sky130_fd_sc_hd__fill_1
X_4947_ _2483_ VGND VGND VPWR VPWR _0335_ sky130_fd_sc_hd__inv_2
XFILLER_0_46_132 VGND VGND VPWR VPWR sky130_fd_sc_hd__fill_1
XFILLER_0_19_368 VGND VGND VPWR VPWR sky130_fd_sc_hd__fill_1
X_4878_ _2475_ VGND VGND VPWR VPWR _0274_ sky130_fd_sc_hd__inv_2
XPHY_EDGE_ROW_49_Left_137 VGND VGND VPWR VPWR sky130_fd_sc_hd__decap_3
X_3829_ _1719_ _1998_ VGND VGND VPWR VPWR _2002_ sky130_fd_sc_hd__xor2_2
XFILLER_0_6_251 VGND VGND VPWR VPWR sky130_fd_sc_hd__fill_1
XFILLER_0_34_338 VGND VGND VPWR VPWR sky130_fd_sc_hd__decap_4
XFILLER_0_61_113 VGND VGND VPWR VPWR sky130_fd_sc_hd__fill_1
XPHY_EDGE_ROW_58_Left_146 VGND VGND VPWR VPWR sky130_fd_sc_hd__decap_3
XTAP_TAPCELL_ROW_73_848 VGND VPWR sky130_fd_sc_hd__tapvpwrvgnd_1
XFILLER_0_69_246 VGND VGND VPWR VPWR sky130_fd_sc_hd__decap_4
XFILLER_0_37_121 VGND VGND VPWR VPWR sky130_fd_sc_hd__fill_2
XPHY_EDGE_ROW_67_Left_155 VGND VGND VPWR VPWR sky130_fd_sc_hd__decap_3
XFILLER_0_25_305 VGND VGND VPWR VPWR sky130_fd_sc_hd__decap_3
XFILLER_0_37_165 VGND VGND VPWR VPWR sky130_fd_sc_hd__decap_3
XFILLER_0_80_444 VPWR VGND VPWR VGND sky130_ef_sc_hd__decap_12
XFILLER_0_20_15 VPWR VGND VPWR VGND sky130_ef_sc_hd__decap_12
XFILLER_0_65_496 VGND VGND VPWR VPWR sky130_fd_sc_hd__decap_8
XFILLER_0_80_477 VPWR VGND VPWR VGND sky130_ef_sc_hd__decap_12
XFILLER_0_21_500 VGND VGND VPWR VPWR sky130_fd_sc_hd__decap_4
XFILLER_0_0_405 VPWR VGND VPWR VGND sky130_ef_sc_hd__decap_12
XPHY_EDGE_ROW_76_Left_164 VGND VGND VPWR VPWR sky130_fd_sc_hd__decap_3
XFILLER_0_0_449 VPWR VGND VPWR VGND sky130_ef_sc_hd__decap_12
XFILLER_0_29_46 VGND VGND VPWR VPWR sky130_fd_sc_hd__decap_8
XFILLER_0_29_57 VPWR VGND VPWR VGND sky130_ef_sc_hd__decap_12
XTAP_TAPCELL_ROW_36_517 VGND VPWR sky130_fd_sc_hd__tapvpwrvgnd_1
XPHY_EDGE_ROW_85_Left_173 VGND VGND VPWR VPWR sky130_fd_sc_hd__decap_3
XFILLER_0_61_22 VGND VGND VPWR VPWR sky130_fd_sc_hd__fill_2
X_4801_ _2467_ VGND VGND VPWR VPWR _0205_ sky130_fd_sc_hd__inv_2
XFILLER_0_0_69 VPWR VGND VPWR VGND sky130_ef_sc_hd__decap_12
XTAP_TAPCELL_ROW_44_583 VGND VPWR sky130_fd_sc_hd__tapvpwrvgnd_1
X_2993_ net154 VGND VGND VPWR VPWR _1202_ sky130_fd_sc_hd__clkbuf_1
XFILLER_0_61_77 VGND VGND VPWR VPWR sky130_fd_sc_hd__decap_4
X_4732_ _2457_ VGND VGND VPWR VPWR _2459_ sky130_fd_sc_hd__buf_4
XFILLER_0_43_102 VGND VGND VPWR VPWR sky130_fd_sc_hd__decap_6
X_4663_ _2449_ VGND VGND VPWR VPWR _0085_ sky130_fd_sc_hd__inv_2
XFILLER_0_71_477 VPWR VGND VPWR VGND sky130_ef_sc_hd__decap_12
X_3614_ _1008_ _1791_ _1803_ VGND VGND VPWR VPWR _1804_ sky130_fd_sc_hd__and3_1
X_4594_ _2439_ VGND VGND VPWR VPWR _0026_ sky130_fd_sc_hd__inv_2
XFILLER_0_12_511 VGND VGND VPWR VPWR sky130_fd_sc_hd__fill_2
XFILLER_0_3_221 VGND VGND VPWR VPWR sky130_fd_sc_hd__decap_3
XFILLER_0_24_371 VGND VGND VPWR VPWR sky130_fd_sc_hd__fill_1
X_3545_ RF0.regs\[7\]\[15\] _1244_ _1734_ _1736_ VGND VGND VPWR VPWR _1737_ sky130_fd_sc_hd__a211o_1
XFILLER_0_3_287 VGND VGND VPWR VPWR sky130_fd_sc_hd__fill_1
X_3476_ _1061_ _1511_ _1631_ VGND VGND VPWR VPWR _1670_ sky130_fd_sc_hd__o21a_1
XFILLER_0_86_41 VPWR VGND VPWR VGND sky130_ef_sc_hd__decap_12
X_5215_ clknet_leaf_33_clk _0591_ _0207_ VGND VGND VPWR VPWR RF0.regs\[6\]\[6\] sky130_fd_sc_hd__dfrtp_1
XFILLER_0_86_85 VPWR VGND VPWR VGND sky130_ef_sc_hd__decap_12
XFILLER_0_43_3 VGND VGND VPWR VPWR sky130_fd_sc_hd__decap_8
X_5146_ clknet_leaf_38_clk _0522_ _0138_ VGND VGND VPWR VPWR RF0.regs\[10\]\[1\] sky130_fd_sc_hd__dfrtp_1
X_5077_ clknet_leaf_0_clk _0453_ _0069_ VGND VGND VPWR VPWR RF0.regs\[20\]\[28\] sky130_fd_sc_hd__dfrtp_1
X_4028_ _1971_ net271 _2138_ VGND VGND VPWR VPWR _2143_ sky130_fd_sc_hd__mux2_1
XTAP_TAPCELL_ROW_70_818 VGND VPWR sky130_fd_sc_hd__tapvpwrvgnd_1
XFILLER_0_30_352 VPWR VGND VPWR VGND sky130_ef_sc_hd__decap_12
XTAP_TAPCELL_ROW_7_253 VGND VPWR sky130_fd_sc_hd__tapvpwrvgnd_1
XTAP_TAPCELL_ROW_86_962 VGND VPWR sky130_fd_sc_hd__tapvpwrvgnd_1
XFILLER_0_85_503 VGND VGND VPWR VPWR sky130_fd_sc_hd__fill_1
XFILLER_0_15_15 VPWR VGND VPWR VGND sky130_ef_sc_hd__decap_12
XFILLER_0_65_293 VPWR VGND VPWR VGND sky130_ef_sc_hd__decap_12
XFILLER_0_53_466 VGND VGND VPWR VPWR sky130_fd_sc_hd__decap_8
Xhold209 IM0.addr\[17\] VGND VGND VPWR VPWR net257 sky130_fd_sc_hd__dlygate4sd3_1
X_3330_ RF0.regs\[10\]\[22\] _0813_ _1222_ RF0.regs\[25\]\[22\] VGND VGND VPWR VPWR
+ _1526_ sky130_fd_sc_hd__a22o_1
XFILLER_0_21_396 VPWR VGND VPWR VGND sky130_ef_sc_hd__decap_12
X_5000_ _2488_ VGND VGND VPWR VPWR _0383_ sky130_fd_sc_hd__inv_2
X_3261_ _0978_ _1441_ _1444_ _0972_ VGND VGND VPWR VPWR _1457_ sky130_fd_sc_hd__o211a_1
X_3192_ _1291_ _1292_ VGND VGND VPWR VPWR _1388_ sky130_fd_sc_hd__and2_1
XFILLER_0_56_33 VGND VGND VPWR VPWR sky130_fd_sc_hd__fill_1
XTAP_TAPCELL_ROW_49_631 VGND VPWR sky130_fd_sc_hd__tapvpwrvgnd_1
XFILLER_0_72_54 VGND VGND VPWR VPWR sky130_fd_sc_hd__decap_3
XFILLER_0_72_98 VGND VGND VPWR VPWR sky130_fd_sc_hd__fill_1
XFILLER_0_44_433 VPWR VGND VPWR VGND sky130_ef_sc_hd__decap_12
X_2976_ _1193_ VGND VGND VPWR VPWR _0702_ sky130_fd_sc_hd__clkbuf_1
XFILLER_0_56_271 VGND VGND VPWR VPWR sky130_fd_sc_hd__fill_2
X_4715_ _2456_ VGND VGND VPWR VPWR _0130_ sky130_fd_sc_hd__inv_2
X_4646_ _2446_ VGND VGND VPWR VPWR _0071_ sky130_fd_sc_hd__inv_2
XFILLER_0_24_190 VGND VGND VPWR VPWR sky130_fd_sc_hd__decap_6
X_4577_ _2438_ VGND VGND VPWR VPWR _0010_ sky130_fd_sc_hd__inv_2
X_3528_ _1708_ _1719_ VGND VGND VPWR VPWR _1720_ sky130_fd_sc_hd__or2_1
X_3459_ RF0.regs\[5\]\[20\] _0961_ _1139_ VGND VGND VPWR VPWR _1653_ sky130_fd_sc_hd__and3_1
XTAP_TAPCELL_ROW_4_223 VGND VPWR sky130_fd_sc_hd__tapvpwrvgnd_1
X_5129_ clknet_leaf_16_clk _0505_ _0121_ VGND VGND VPWR VPWR RF0.regs\[12\]\[16\]
+ sky130_fd_sc_hd__dfrtp_1
XTAP_TAPCELL_ROW_83_932 VGND VPWR sky130_fd_sc_hd__tapvpwrvgnd_1
XFILLER_0_79_374 VGND VGND VPWR VPWR sky130_fd_sc_hd__decap_4
XFILLER_0_35_444 VGND VGND VPWR VPWR sky130_fd_sc_hd__decap_4
XFILLER_0_22_116 VGND VGND VPWR VPWR sky130_fd_sc_hd__decap_8
XFILLER_0_22_138 VGND VGND VPWR VPWR sky130_fd_sc_hd__fill_2
Xhold81 RF0.regs\[7\]\[3\] VGND VGND VPWR VPWR net129 sky130_fd_sc_hd__dlygate4sd3_1
Xhold92 RF0.regs\[0\]\[8\] VGND VGND VPWR VPWR net140 sky130_fd_sc_hd__dlygate4sd3_1
Xhold70 RF0.regs\[2\]\[20\] VGND VGND VPWR VPWR net118 sky130_fd_sc_hd__dlygate4sd3_1
XTAP_TAPCELL_ROW_46_601 VGND VPWR sky130_fd_sc_hd__tapvpwrvgnd_1
XTAP_TAPCELL_ROW_18_347 VGND VPWR sky130_fd_sc_hd__tapvpwrvgnd_1
XFILLER_0_85_377 VPWR VGND VPWR VGND sky130_ef_sc_hd__decap_12
X_2830_ _1114_ VGND VGND VPWR VPWR _0769_ sky130_fd_sc_hd__clkbuf_1
XFILLER_0_42_46 VGND VGND VPWR VPWR sky130_fd_sc_hd__decap_8
XFILLER_0_42_79 VGND VGND VPWR VPWR sky130_fd_sc_hd__decap_4
XFILLER_0_26_433 VGND VGND VPWR VPWR sky130_fd_sc_hd__decap_3
X_2761_ RF0.regs\[4\]\[14\] _0836_ _0843_ RF0.regs\[12\]\[14\] VGND VGND VPWR VPWR
+ _1053_ sky130_fd_sc_hd__a22o_1
X_4500_ disp.digits\[5\] _2385_ _2388_ _2384_ VGND VGND VPWR VPWR _2389_ sky130_fd_sc_hd__a211o_1
XFILLER_0_26_477 VPWR VGND VPWR VGND sky130_ef_sc_hd__decap_12
X_2692_ RF0.regs\[10\]\[9\] _0810_ _0827_ RF0.regs\[25\]\[9\] _0983_ VGND VGND VPWR
+ VPWR _0984_ sky130_fd_sc_hd__a221o_1
XFILLER_0_53_263 VPWR VGND VPWR VGND sky130_ef_sc_hd__decap_12
XFILLER_0_13_149 VGND VGND VPWR VPWR sky130_fd_sc_hd__fill_2
X_4431_ _2353_ VGND VGND VPWR VPWR _0421_ sky130_fd_sc_hd__clkbuf_1
XANTENNA_1 _0860_ VGND VGND VPWR VPWR sky130_fd_sc_hd__diode_2
X_4362_ _2317_ VGND VGND VPWR VPWR _0454_ sky130_fd_sc_hd__clkbuf_1
X_4293_ _2281_ VGND VGND VPWR VPWR _0487_ sky130_fd_sc_hd__clkbuf_1
X_3313_ _1506_ _1508_ VGND VGND VPWR VPWR _1509_ sky130_fd_sc_hd__xnor2_1
X_3244_ _1297_ _1298_ VGND VGND VPWR VPWR _1440_ sky130_fd_sc_hd__or2_1
X_3175_ RF0.regs\[10\]\[14\] _0884_ _1237_ RF0.regs\[2\]\[14\] _1370_ VGND VGND VPWR
+ VPWR _1371_ sky130_fd_sc_hd__a221o_1
Xrebuffer13 net60 VGND VGND VPWR VPWR net61 sky130_fd_sc_hd__clkbuf_1
XFILLER_0_49_503 VGND VGND VPWR VPWR sky130_fd_sc_hd__fill_1
XTAP_TAPCELL_ROW_80_913 VGND VPWR sky130_fd_sc_hd__tapvpwrvgnd_1
XTAP_TAPCELL_ROW_52_659 VGND VPWR sky130_fd_sc_hd__tapvpwrvgnd_1
XFILLER_0_36_219 VGND VGND VPWR VPWR sky130_fd_sc_hd__decap_3
X_2959_ net127 VGND VGND VPWR VPWR _1185_ sky130_fd_sc_hd__clkbuf_1
X_4629_ _2444_ VGND VGND VPWR VPWR _0056_ sky130_fd_sc_hd__inv_2
XFILLER_0_32_469 VGND VGND VPWR VPWR sky130_fd_sc_hd__decap_6
XFILLER_0_12_160 VGND VGND VPWR VPWR sky130_fd_sc_hd__decap_4
XTAP_TAPCELL_ROW_15_328 VGND VPWR sky130_fd_sc_hd__tapvpwrvgnd_1
XFILLER_0_67_377 VGND VGND VPWR VPWR sky130_fd_sc_hd__decap_3
XFILLER_0_12_27 VGND VGND VPWR VPWR sky130_fd_sc_hd__fill_1
XFILLER_0_27_219 VGND VGND VPWR VPWR sky130_fd_sc_hd__decap_4
XTAP_TAPCELL_ROW_23_394 VGND VPWR sky130_fd_sc_hd__tapvpwrvgnd_1
Xoutput3 net3 VGND VGND VPWR VPWR Result[10] sky130_fd_sc_hd__buf_2
XFILLER_0_50_299 VGND VGND VPWR VPWR sky130_fd_sc_hd__fill_1
XFILLER_0_37_57 VGND VGND VPWR VPWR sky130_fd_sc_hd__fill_2
X_4980_ _2486_ VGND VGND VPWR VPWR _0365_ sky130_fd_sc_hd__inv_2
XFILLER_0_58_333 VGND VGND VPWR VPWR sky130_fd_sc_hd__decap_6
X_3931_ RF0.regs\[4\]\[6\] _2088_ _2073_ VGND VGND VPWR VPWR _2089_ sky130_fd_sc_hd__mux2_1
XFILLER_0_53_89 VPWR VGND VPWR VGND sky130_ef_sc_hd__decap_12
X_3862_ _2028_ _2029_ VGND VGND VPWR VPWR _2030_ sky130_fd_sc_hd__nor2_2
X_2813_ net205 _1104_ VGND VGND VPWR VPWR _1105_ sky130_fd_sc_hd__and2_1
XFILLER_0_5_113 VGND VGND VPWR VPWR sky130_fd_sc_hd__decap_3
X_3793_ _1606_ _1973_ VGND VGND VPWR VPWR _1974_ sky130_fd_sc_hd__nand2_1
X_2744_ RF0.regs\[4\]\[26\] _0838_ _0844_ RF0.regs\[12\]\[26\] VGND VGND VPWR VPWR
+ _1036_ sky130_fd_sc_hd__a22o_1
XFILLER_0_14_458 VPWR VGND VPWR VGND sky130_ef_sc_hd__decap_12
X_2675_ _0964_ _0966_ VGND VGND VPWR VPWR _0967_ sky130_fd_sc_hd__xor2_1
XFILLER_0_78_53 VPWR VGND VPWR VGND sky130_ef_sc_hd__decap_12
X_5394_ clknet_leaf_44_clk _0770_ _0386_ VGND VGND VPWR VPWR IM0.addr\[25\] sky130_fd_sc_hd__dfrtp_1
X_4414_ _2344_ VGND VGND VPWR VPWR _0429_ sky130_fd_sc_hd__clkbuf_1
X_4345_ _2308_ VGND VGND VPWR VPWR _0462_ sky130_fd_sc_hd__clkbuf_1
XFILLER_0_1_385 VGND VGND VPWR VPWR sky130_fd_sc_hd__decap_6
XPHY_EDGE_ROW_21_Left_109 VGND VGND VPWR VPWR sky130_fd_sc_hd__decap_3
X_4276_ net273 VGND VGND VPWR VPWR _2272_ sky130_fd_sc_hd__clkbuf_1
X_3227_ _0841_ _1421_ _1422_ VGND VGND VPWR VPWR _1423_ sky130_fd_sc_hd__nand3_2
X_3158_ _1324_ _1327_ _1328_ VGND VGND VPWR VPWR _1354_ sky130_fd_sc_hd__o21ba_1
X_3089_ _1078_ _1283_ _1284_ VGND VGND VPWR VPWR _1285_ sky130_fd_sc_hd__or3_1
XTAP_TAPCELL_ROW_65_773 VGND VPWR sky130_fd_sc_hd__tapvpwrvgnd_1
XPHY_EDGE_ROW_30_Left_118 VGND VGND VPWR VPWR sky130_fd_sc_hd__decap_3
XFILLER_0_49_388 VGND VGND VPWR VPWR sky130_fd_sc_hd__decap_4
XFILLER_0_87_417 VGND VGND VPWR VPWR sky130_fd_sc_hd__decap_3
XTAP_TAPCELL_ROW_28_442 VGND VPWR sky130_fd_sc_hd__tapvpwrvgnd_1
XFILLER_0_23_15 VPWR VGND VPWR VGND sky130_ef_sc_hd__decap_12
XFILLER_0_67_196 VGND VGND VPWR VPWR sky130_fd_sc_hd__fill_1
XFILLER_0_55_369 VGND VGND VPWR VPWR sky130_fd_sc_hd__fill_1
Xrebuffer4 net46 VGND VGND VPWR VPWR net52 sky130_fd_sc_hd__dlygate4sd1_1
XFILLER_0_11_417 VGND VGND VPWR VPWR sky130_fd_sc_hd__decap_3
X_4130_ _2197_ VGND VGND VPWR VPWR _0566_ sky130_fd_sc_hd__clkbuf_1
X_4061_ _2137_ VGND VGND VPWR VPWR _2160_ sky130_fd_sc_hd__buf_4
XTAP_TAPCELL_ROW_79_898 VGND VPWR sky130_fd_sc_hd__tapvpwrvgnd_1
XFILLER_0_3_69 VPWR VGND VPWR VGND sky130_ef_sc_hd__decap_12
X_3012_ _1211_ VGND VGND VPWR VPWR _0684_ sky130_fd_sc_hd__clkbuf_1
XFILLER_0_64_44 VGND VGND VPWR VPWR sky130_fd_sc_hd__decap_6
Xwire48 _0786_ VGND VGND VPWR VPWR net48 sky130_fd_sc_hd__buf_2
X_4963_ _2485_ VGND VGND VPWR VPWR _0349_ sky130_fd_sc_hd__inv_2
XFILLER_0_58_141 VPWR VGND VPWR VGND sky130_ef_sc_hd__decap_12
XTAP_TAPCELL_ROW_62_743 VGND VPWR sky130_fd_sc_hd__tapvpwrvgnd_1
XFILLER_0_80_65 VPWR VGND VPWR VGND sky130_ef_sc_hd__decap_12
X_3914_ _1805_ _1913_ VGND VGND VPWR VPWR _2076_ sky130_fd_sc_hd__or2b_2
X_4894_ _2476_ VGND VGND VPWR VPWR _0289_ sky130_fd_sc_hd__inv_2
X_3845_ _1380_ _1381_ VGND VGND VPWR VPWR _2014_ sky130_fd_sc_hd__and2b_1
XFILLER_0_73_199 VGND VGND VPWR VPWR sky130_fd_sc_hd__fill_1
XFILLER_0_6_477 VPWR VGND VPWR VGND sky130_ef_sc_hd__decap_12
X_3776_ _1587_ _1947_ VGND VGND VPWR VPWR _1960_ sky130_fd_sc_hd__or2_1
X_2727_ _0986_ _0994_ _1005_ _1018_ VGND VGND VPWR VPWR _1019_ sky130_fd_sc_hd__or4_1
XFILLER_0_73_3 VPWR VGND VPWR VGND sky130_ef_sc_hd__decap_12
X_2658_ RF0.regs\[4\]\[5\] _0862_ _0877_ RF0.regs\[2\]\[5\] _0949_ VGND VGND VPWR
+ VPWR _0950_ sky130_fd_sc_hd__a221o_1
X_2589_ _0821_ _0819_ IM0.addr\[1\] _0820_ VGND VGND VPWR VPWR _0881_ sky130_fd_sc_hd__nor4_1
X_5377_ clknet_leaf_42_clk _0753_ _0369_ VGND VGND VPWR VPWR IM0.addr\[8\] sky130_fd_sc_hd__dfrtp_1
X_4328_ _2299_ VGND VGND VPWR VPWR _0470_ sky130_fd_sc_hd__clkbuf_1
XFILLER_0_10_483 VGND VGND VPWR VPWR sky130_fd_sc_hd__fill_1
X_4259_ _2263_ VGND VGND VPWR VPWR _0503_ sky130_fd_sc_hd__clkbuf_1
XTAP_TAPCELL_ROW_25_412 VGND VPWR sky130_fd_sc_hd__tapvpwrvgnd_1
XFILLER_0_52_317 VGND VGND VPWR VPWR sky130_fd_sc_hd__decap_4
XFILLER_0_20_247 VGND VGND VPWR VPWR sky130_fd_sc_hd__fill_2
XFILLER_0_18_15 VPWR VGND VPWR VGND sky130_ef_sc_hd__decap_12
XFILLER_0_87_225 VGND VGND VPWR VPWR sky130_fd_sc_hd__decap_8
XFILLER_0_55_100 VGND VGND VPWR VPWR sky130_fd_sc_hd__fill_2
XFILLER_0_68_494 VPWR VGND VPWR VGND sky130_ef_sc_hd__decap_12
XFILLER_0_7_219 VGND VGND VPWR VPWR sky130_fd_sc_hd__fill_2
XFILLER_0_83_497 VGND VGND VPWR VPWR sky130_fd_sc_hd__decap_6
XFILLER_0_70_136 VGND VGND VPWR VPWR sky130_fd_sc_hd__decap_4
X_3630_ RF0.regs\[10\]\[8\] _0885_ _0811_ RF0.regs\[25\]\[8\] _0795_ VGND VGND VPWR
+ VPWR _1818_ sky130_fd_sc_hd__a221o_1
X_3561_ RF0.regs\[10\]\[14\] _0886_ _0813_ RF0.regs\[25\]\[14\] _1246_ VGND VGND VPWR
+ VPWR _1753_ sky130_fd_sc_hd__a221o_1
XFILLER_0_3_447 VGND VGND VPWR VPWR sky130_fd_sc_hd__fill_1
X_2512_ _0800_ _0801_ _0803_ VGND VGND VPWR VPWR _0804_ sky130_fd_sc_hd__or3_1
X_5300_ clknet_leaf_1_clk _0676_ _0292_ VGND VGND VPWR VPWR RF0.regs\[4\]\[27\] sky130_fd_sc_hd__dfrtp_2
XFILLER_0_51_372 VGND VGND VPWR VPWR sky130_fd_sc_hd__decap_3
XFILLER_0_59_77 VPWR VGND VPWR VGND sky130_ef_sc_hd__decap_12
X_3492_ _1471_ _1473_ _1475_ VGND VGND VPWR VPWR _1685_ sky130_fd_sc_hd__a21o_1
X_5231_ clknet_leaf_10_clk _0607_ _0223_ VGND VGND VPWR VPWR RF0.regs\[6\]\[22\] sky130_fd_sc_hd__dfrtp_1
X_5162_ clknet_leaf_17_clk _0538_ _0154_ VGND VGND VPWR VPWR RF0.regs\[10\]\[17\]
+ sky130_fd_sc_hd__dfrtp_1
X_4113_ net113 VGND VGND VPWR VPWR _2189_ sky130_fd_sc_hd__clkbuf_1
X_5093_ clknet_leaf_25_clk _0469_ _0085_ VGND VGND VPWR VPWR RF0.regs\[15\]\[12\]
+ sky130_fd_sc_hd__dfrtp_1
X_4044_ _2151_ VGND VGND VPWR VPWR _0605_ sky130_fd_sc_hd__clkbuf_1
XTAP_TAPCELL_ROW_39_537 VGND VPWR sky130_fd_sc_hd__tapvpwrvgnd_1
XFILLER_0_46_100 VGND VGND VPWR VPWR sky130_fd_sc_hd__decap_4
XFILLER_0_59_483 VGND VGND VPWR VPWR sky130_fd_sc_hd__fill_1
X_4946_ _2483_ VGND VGND VPWR VPWR _0334_ sky130_fd_sc_hd__inv_2
X_4877_ _2475_ VGND VGND VPWR VPWR _0273_ sky130_fd_sc_hd__inv_2
X_3828_ _2001_ VGND VGND VPWR VPWR _0668_ sky130_fd_sc_hd__clkbuf_1
X_3759_ _0798_ _1938_ _1943_ _1944_ VGND VGND VPWR VPWR _1945_ sky130_fd_sc_hd__or4_1
XTAP_TAPCELL_ROW_73_849 VGND VPWR sky130_fd_sc_hd__tapvpwrvgnd_1
XFILLER_0_84_206 VGND VGND VPWR VPWR sky130_fd_sc_hd__fill_1
XFILLER_0_37_100 VPWR VGND VPWR VGND sky130_ef_sc_hd__decap_12
XFILLER_0_65_420 VGND VGND VPWR VPWR sky130_fd_sc_hd__decap_6
XFILLER_0_80_456 VPWR VGND VPWR VGND sky130_ef_sc_hd__decap_12
XFILLER_0_20_27 VGND VGND VPWR VPWR sky130_fd_sc_hd__fill_1
XFILLER_0_20_49 VGND VGND VPWR VPWR sky130_fd_sc_hd__decap_3
XFILLER_0_40_309 VGND VGND VPWR VPWR sky130_fd_sc_hd__decap_6
XFILLER_0_52_147 VGND VGND VPWR VPWR sky130_fd_sc_hd__fill_1
XFILLER_0_80_489 VPWR VGND VPWR VGND sky130_ef_sc_hd__decap_12
XFILLER_0_0_417 VGND VGND VPWR VPWR sky130_fd_sc_hd__decap_3
XFILLER_0_29_69 VGND VGND VPWR VPWR sky130_fd_sc_hd__decap_3
XFILLER_0_0_15 VPWR VGND VPWR VGND sky130_ef_sc_hd__decap_12
X_4800_ _2467_ VGND VGND VPWR VPWR _0204_ sky130_fd_sc_hd__inv_2
XFILLER_0_75_239 VGND VGND VPWR VPWR sky130_fd_sc_hd__fill_2
X_2992_ _1201_ VGND VGND VPWR VPWR _0694_ sky130_fd_sc_hd__clkbuf_1
XTAP_TAPCELL_ROW_44_584 VGND VPWR sky130_fd_sc_hd__tapvpwrvgnd_1
XFILLER_0_28_144 VPWR VGND VPWR VGND sky130_ef_sc_hd__decap_12
X_4731_ _2458_ VGND VGND VPWR VPWR _0144_ sky130_fd_sc_hd__inv_2
X_4662_ _2449_ VGND VGND VPWR VPWR _0084_ sky130_fd_sc_hd__inv_2
XFILLER_0_9_57 VPWR VGND VPWR VGND sky130_ef_sc_hd__decap_12
X_3613_ _1455_ _1802_ _1452_ _1445_ VGND VGND VPWR VPWR _1803_ sky130_fd_sc_hd__a211o_1
XFILLER_0_71_489 VPWR VGND VPWR VGND sky130_ef_sc_hd__decap_12
X_4593_ _2439_ VGND VGND VPWR VPWR _0025_ sky130_fd_sc_hd__inv_2
XFILLER_0_43_169 VGND VGND VPWR VPWR sky130_fd_sc_hd__fill_2
X_3544_ RF0.regs\[5\]\[15\] _0866_ _1223_ RF0.regs\[20\]\[15\] _1735_ VGND VGND VPWR
+ VPWR _1736_ sky130_fd_sc_hd__a221o_1
X_3475_ _1665_ _1666_ _1668_ _1218_ RF0.regs\[0\]\[21\] VGND VGND VPWR VPWR _1669_
+ sky130_fd_sc_hd__o32a_2
XFILLER_0_86_53 VPWR VGND VPWR VGND sky130_ef_sc_hd__decap_12
X_5214_ clknet_leaf_34_clk _0590_ _0206_ VGND VGND VPWR VPWR RF0.regs\[6\]\[5\] sky130_fd_sc_hd__dfrtp_1
XFILLER_0_86_97 VPWR VGND VPWR VGND sky130_ef_sc_hd__decap_12
X_5145_ clknet_leaf_38_clk _0521_ _0137_ VGND VGND VPWR VPWR RF0.regs\[10\]\[0\] sky130_fd_sc_hd__dfrtp_1
X_5076_ clknet_leaf_7_clk _0452_ _0068_ VGND VGND VPWR VPWR RF0.regs\[20\]\[27\] sky130_fd_sc_hd__dfrtp_1
X_4027_ _2142_ VGND VGND VPWR VPWR _0613_ sky130_fd_sc_hd__clkbuf_1
XTAP_TAPCELL_ROW_70_819 VGND VPWR sky130_fd_sc_hd__tapvpwrvgnd_1
XFILLER_0_66_228 VGND VGND VPWR VPWR sky130_fd_sc_hd__fill_1
XFILLER_0_19_166 VGND VGND VPWR VPWR sky130_fd_sc_hd__fill_2
X_4929_ _2480_ VGND VGND VPWR VPWR _2482_ sky130_fd_sc_hd__buf_4
XFILLER_0_47_464 VGND VGND VPWR VPWR sky130_fd_sc_hd__decap_3
XFILLER_0_19_188 VGND VGND VPWR VPWR sky130_fd_sc_hd__fill_1
XFILLER_0_19_199 VGND VGND VPWR VPWR sky130_fd_sc_hd__fill_1
XFILLER_0_22_309 VGND VGND VPWR VPWR sky130_fd_sc_hd__decap_4
XFILLER_0_62_489 VGND VGND VPWR VPWR sky130_fd_sc_hd__fill_1
XFILLER_0_30_342 VGND VGND VPWR VPWR sky130_fd_sc_hd__fill_2
XTAP_TAPCELL_ROW_7_254 VGND VPWR sky130_fd_sc_hd__tapvpwrvgnd_1
XTAP_TAPCELL_ROW_86_963 VGND VPWR sky130_fd_sc_hd__tapvpwrvgnd_1
XFILLER_0_15_27 VPWR VGND VPWR VGND sky130_ef_sc_hd__decap_12
XFILLER_0_57_228 VGND VGND VPWR VPWR sky130_fd_sc_hd__decap_3
XFILLER_0_72_209 VPWR VGND VPWR VGND sky130_ef_sc_hd__decap_12
XFILLER_0_38_464 VGND VGND VPWR VPWR sky130_fd_sc_hd__decap_3
XFILLER_0_38_486 VGND VGND VPWR VPWR sky130_fd_sc_hd__fill_1
XTAP_TAPCELL_ROW_41_554 VGND VPWR sky130_fd_sc_hd__tapvpwrvgnd_1
XFILLER_0_53_423 VGND VGND VPWR VPWR sky130_fd_sc_hd__fill_1
XFILLER_0_80_253 VGND VGND VPWR VPWR sky130_fd_sc_hd__decap_8
XFILLER_0_40_139 VGND VGND VPWR VPWR sky130_fd_sc_hd__fill_1
XFILLER_0_0_225 VPWR VGND VPWR VGND sky130_ef_sc_hd__decap_12
X_3260_ _1436_ _1455_ _1452_ VGND VGND VPWR VPWR _1456_ sky130_fd_sc_hd__a21o_1
XFILLER_0_56_23 VGND VGND VPWR VPWR sky130_fd_sc_hd__fill_2
X_3191_ _1291_ _1292_ VGND VGND VPWR VPWR _1387_ sky130_fd_sc_hd__nor2_1
XTAP_TAPCELL_ROW_49_632 VGND VPWR sky130_fd_sc_hd__tapvpwrvgnd_1
XFILLER_0_72_88 VGND VGND VPWR VPWR sky130_fd_sc_hd__decap_3
XFILLER_0_29_497 VGND VGND VPWR VPWR sky130_fd_sc_hd__fill_2
X_2975_ net187 VGND VGND VPWR VPWR _1193_ sky130_fd_sc_hd__clkbuf_1
XFILLER_0_56_283 VPWR VGND VPWR VGND sky130_ef_sc_hd__decap_12
X_4714_ _2456_ VGND VGND VPWR VPWR _0129_ sky130_fd_sc_hd__inv_2
XFILLER_0_16_158 VGND VGND VPWR VPWR sky130_fd_sc_hd__decap_6
XFILLER_0_16_136 VGND VGND VPWR VPWR sky130_fd_sc_hd__decap_4
XFILLER_0_21_81 VGND VGND VPWR VPWR sky130_fd_sc_hd__decap_3
X_4645_ _2446_ VGND VGND VPWR VPWR _0070_ sky130_fd_sc_hd__inv_2
XFILLER_0_44_489 VGND VGND VPWR VPWR sky130_fd_sc_hd__fill_2
X_4576_ _2438_ VGND VGND VPWR VPWR _0009_ sky130_fd_sc_hd__inv_2
X_3527_ _1716_ _1718_ VGND VGND VPWR VPWR _1719_ sky130_fd_sc_hd__nand2_1
X_3458_ _1641_ _1650_ _1651_ VGND VGND VPWR VPWR _1652_ sky130_fd_sc_hd__or3b_1
XTAP_TAPCELL_ROW_4_224 VGND VPWR sky130_fd_sc_hd__tapvpwrvgnd_1
X_3389_ _1579_ _1580_ _1582_ _1219_ RF0.regs\[0\]\[28\] VGND VGND VPWR VPWR _1583_
+ sky130_fd_sc_hd__o32a_1
X_5128_ clknet_leaf_16_clk _0504_ _0120_ VGND VGND VPWR VPWR RF0.regs\[12\]\[15\]
+ sky130_fd_sc_hd__dfrtp_1
XTAP_TAPCELL_ROW_83_933 VGND VPWR sky130_fd_sc_hd__tapvpwrvgnd_1
X_5059_ clknet_leaf_24_clk _0435_ _0051_ VGND VGND VPWR VPWR RF0.regs\[20\]\[10\]
+ sky130_fd_sc_hd__dfrtp_1
XFILLER_0_79_364 VGND VGND VPWR VPWR sky130_fd_sc_hd__decap_3
XFILLER_0_35_434 VGND VGND VPWR VPWR sky130_fd_sc_hd__fill_1
XFILLER_0_62_275 VGND VGND VPWR VPWR sky130_fd_sc_hd__fill_1
XFILLER_0_15_191 VPWR VGND VPWR VGND sky130_ef_sc_hd__decap_12
XFILLER_0_30_183 VGND VGND VPWR VPWR sky130_fd_sc_hd__fill_1
XFILLER_0_30_194 VGND VGND VPWR VPWR sky130_fd_sc_hd__fill_2
XFILLER_0_26_15 VPWR VGND VPWR VGND sky130_ef_sc_hd__decap_12
Xhold60 RF0.regs\[7\]\[17\] VGND VGND VPWR VPWR net108 sky130_fd_sc_hd__dlygate4sd3_1
Xhold71 RF0.regs\[12\]\[7\] VGND VGND VPWR VPWR net119 sky130_fd_sc_hd__dlygate4sd3_1
Xhold82 RF0.regs\[12\]\[1\] VGND VGND VPWR VPWR net130 sky130_fd_sc_hd__dlygate4sd3_1
Xhold93 RF0.regs\[0\]\[21\] VGND VGND VPWR VPWR net141 sky130_fd_sc_hd__dlygate4sd3_1
XTAP_TAPCELL_ROW_46_602 VGND VPWR sky130_fd_sc_hd__tapvpwrvgnd_1
XTAP_TAPCELL_ROW_18_348 VGND VPWR sky130_fd_sc_hd__tapvpwrvgnd_1
XFILLER_0_85_389 VGND VGND VPWR VPWR sky130_fd_sc_hd__decap_3
XFILLER_0_26_412 VGND VGND VPWR VPWR sky130_fd_sc_hd__decap_8
X_2760_ RF0.regs\[10\]\[14\] _0884_ _0863_ RF0.regs\[4\]\[14\] _1051_ VGND VGND VPWR
+ VPWR _1052_ sky130_fd_sc_hd__a221oi_4
XFILLER_0_26_489 VGND VGND VPWR VPWR sky130_fd_sc_hd__decap_6
X_2691_ RF0.regs\[4\]\[9\] _0835_ _0843_ RF0.regs\[12\]\[9\] VGND VGND VPWR VPWR _0983_
+ sky130_fd_sc_hd__a22o_1
XFILLER_0_53_275 VGND VGND VPWR VPWR sky130_fd_sc_hd__decap_4
XANTENNA_2 _2421_ VGND VGND VPWR VPWR sky130_fd_sc_hd__diode_2
X_4430_ RF0.regs\[25\]\[28\] _1965_ _2349_ VGND VGND VPWR VPWR _2353_ sky130_fd_sc_hd__mux2_1
X_4361_ net256 _1962_ _2314_ VGND VGND VPWR VPWR _2317_ sky130_fd_sc_hd__mux2_1
XFILLER_0_67_11 VGND VGND VPWR VPWR sky130_fd_sc_hd__decap_3
X_4292_ RF0.regs\[15\]\[30\] _1957_ _2279_ VGND VGND VPWR VPWR _2281_ sky130_fd_sc_hd__mux2_1
X_3312_ net59 _1507_ VGND VGND VPWR VPWR _1508_ sky130_fd_sc_hd__nand2_1
XFILLER_0_67_66 VGND VGND VPWR VPWR sky130_fd_sc_hd__decap_8
X_3243_ _1427_ _1431_ _1438_ _1437_ VGND VGND VPWR VPWR _1439_ sky130_fd_sc_hd__a211oi_4
XFILLER_0_67_99 VGND VGND VPWR VPWR sky130_fd_sc_hd__fill_2
X_3174_ RF0.regs\[5\]\[14\] _0874_ _0863_ RF0.regs\[4\]\[14\] _1050_ VGND VGND VPWR
+ VPWR _1370_ sky130_fd_sc_hd__a221o_1
Xrebuffer14 _1439_ VGND VGND VPWR VPWR net62 sky130_fd_sc_hd__dlygate4sd1_1
X_2958_ _1184_ VGND VGND VPWR VPWR _0711_ sky130_fd_sc_hd__clkbuf_1
XFILLER_0_44_231 VGND VGND VPWR VPWR sky130_fd_sc_hd__fill_2
XFILLER_0_44_253 VGND VGND VPWR VPWR sky130_fd_sc_hd__decap_4
X_4628_ _2444_ VGND VGND VPWR VPWR _0055_ sky130_fd_sc_hd__inv_2
X_2889_ net1 _1149_ net67 VGND VGND VPWR VPWR _1150_ sky130_fd_sc_hd__a21oi_1
XFILLER_0_32_448 VGND VGND VPWR VPWR sky130_fd_sc_hd__decap_3
X_4559_ _1149_ _1534_ _1625_ VGND VGND VPWR VPWR _2429_ sky130_fd_sc_hd__and3_1
XFILLER_0_86_109 VPWR VGND VPWR VGND sky130_ef_sc_hd__decap_12
XFILLER_0_67_301 VGND VGND VPWR VPWR sky130_fd_sc_hd__decap_8
XTAP_TAPCELL_ROW_23_395 VGND VPWR sky130_fd_sc_hd__tapvpwrvgnd_1
XFILLER_0_23_426 VGND VGND VPWR VPWR sky130_fd_sc_hd__fill_2
XFILLER_0_50_256 VGND VGND VPWR VPWR sky130_fd_sc_hd__decap_6
Xoutput4 net4 VGND VGND VPWR VPWR Result[11] sky130_fd_sc_hd__buf_2
X_3930_ _1842_ _1905_ VGND VGND VPWR VPWR _2088_ sky130_fd_sc_hd__xor2_4
XFILLER_0_53_57 VGND VGND VPWR VPWR sky130_fd_sc_hd__fill_2
X_3861_ _1009_ _1850_ _1844_ VGND VGND VPWR VPWR _2029_ sky130_fd_sc_hd__and3_1
X_2812_ net1 _1103_ VGND VGND VPWR VPWR _1104_ sky130_fd_sc_hd__nand2_1
X_3792_ _1968_ _1936_ _1615_ VGND VGND VPWR VPWR _1973_ sky130_fd_sc_hd__a21o_1
XFILLER_0_26_253 VGND VGND VPWR VPWR sky130_fd_sc_hd__fill_1
X_2743_ RF0.regs\[4\]\[26\] _0865_ _0879_ RF0.regs\[2\]\[26\] _1034_ VGND VGND VPWR
+ VPWR _1035_ sky130_fd_sc_hd__a221o_1
X_2674_ RF0.regs\[10\]\[27\] _0815_ _0829_ RF0.regs\[25\]\[27\] _0965_ VGND VGND VPWR
+ VPWR _0966_ sky130_fd_sc_hd__a221o_1
XFILLER_0_78_76 VGND VGND VPWR VPWR sky130_fd_sc_hd__decap_8
XFILLER_0_78_65 VGND VGND VPWR VPWR sky130_fd_sc_hd__fill_2
X_4413_ net264 _2092_ _2336_ VGND VGND VPWR VPWR _2344_ sky130_fd_sc_hd__mux2_1
X_5393_ clknet_leaf_44_clk _0769_ _0385_ VGND VGND VPWR VPWR IM0.addr\[24\] sky130_fd_sc_hd__dfrtp_1
X_4344_ RF0.regs\[15\]\[5\] _2090_ _2301_ VGND VGND VPWR VPWR _2308_ sky130_fd_sc_hd__mux2_1
X_4275_ _2271_ VGND VGND VPWR VPWR _0495_ sky130_fd_sc_hd__clkbuf_1
X_3226_ _1293_ _1294_ VGND VGND VPWR VPWR _1422_ sky130_fd_sc_hd__nand2_1
X_3157_ RF0.regs\[10\]\[26\] _0815_ _0829_ RF0.regs\[25\]\[26\] _1036_ VGND VGND VPWR
+ VPWR _1353_ sky130_fd_sc_hd__a221o_1
X_3088_ RF0.regs\[4\]\[2\] _0901_ _0860_ _1270_ RF0.regs\[15\]\[2\] VGND VGND VPWR
+ VPWR _1284_ sky130_fd_sc_hd__a32o_1
XTAP_TAPCELL_ROW_65_774 VGND VPWR sky130_fd_sc_hd__tapvpwrvgnd_1
XFILLER_0_76_164 VPWR VGND VPWR VGND sky130_ef_sc_hd__decap_12
XFILLER_0_43_90 VPWR VGND VPWR VGND sky130_ef_sc_hd__decap_12
XFILLER_0_64_315 VPWR VGND VPWR VGND sky130_ef_sc_hd__decap_12
XFILLER_0_76_197 VPWR VGND VPWR VGND sky130_ef_sc_hd__decap_12
XFILLER_0_17_264 VGND VGND VPWR VPWR sky130_fd_sc_hd__fill_2
XFILLER_0_17_242 VGND VGND VPWR VPWR sky130_fd_sc_hd__fill_1
XFILLER_0_17_275 VGND VGND VPWR VPWR sky130_fd_sc_hd__decap_4
XTAP_TAPCELL_ROW_20_365 VGND VPWR sky130_fd_sc_hd__tapvpwrvgnd_1
XFILLER_0_32_201 VGND VGND VPWR VPWR sky130_fd_sc_hd__fill_1
XTAP_TAPCELL_ROW_28_443 VGND VPWR sky130_fd_sc_hd__tapvpwrvgnd_1
XFILLER_0_23_27 VGND VGND VPWR VPWR sky130_fd_sc_hd__decap_8
XFILLER_0_82_101 VGND VGND VPWR VPWR sky130_fd_sc_hd__fill_2
XFILLER_0_70_329 VGND VGND VPWR VPWR sky130_fd_sc_hd__decap_4
XFILLER_0_23_223 VGND VGND VPWR VPWR sky130_fd_sc_hd__fill_1
Xrebuffer5 _1308_ VGND VGND VPWR VPWR net53 sky130_fd_sc_hd__dlygate4sd1_1
XFILLER_0_63_381 VGND VGND VPWR VPWR sky130_fd_sc_hd__decap_4
XFILLER_0_3_15 VPWR VGND VPWR VGND sky130_ef_sc_hd__decap_12
X_4060_ _2159_ VGND VGND VPWR VPWR _0597_ sky130_fd_sc_hd__clkbuf_1
XTAP_TAPCELL_ROW_79_899 VGND VPWR sky130_fd_sc_hd__tapvpwrvgnd_1
X_3011_ net198 VGND VGND VPWR VPWR _1211_ sky130_fd_sc_hd__clkbuf_1
XFILLER_0_78_407 VPWR VGND VPWR VGND sky130_ef_sc_hd__decap_12
X_4962_ _2485_ VGND VGND VPWR VPWR _0348_ sky130_fd_sc_hd__inv_2
X_4893_ _2476_ VGND VGND VPWR VPWR _0288_ sky130_fd_sc_hd__inv_2
X_3913_ _1814_ _1912_ VGND VGND VPWR VPWR _2075_ sky130_fd_sc_hd__nor2_2
XFILLER_0_58_153 VPWR VGND VPWR VGND sky130_ef_sc_hd__decap_12
XTAP_TAPCELL_ROW_62_744 VGND VPWR sky130_fd_sc_hd__tapvpwrvgnd_1
XFILLER_0_80_77 VGND VGND VPWR VPWR sky130_fd_sc_hd__decap_4
X_3844_ _2013_ VGND VGND VPWR VPWR _0664_ sky130_fd_sc_hd__clkbuf_1
XFILLER_0_73_134 VGND VGND VPWR VPWR sky130_fd_sc_hd__fill_1
XFILLER_0_46_348 VGND VGND VPWR VPWR sky130_fd_sc_hd__fill_1
XFILLER_0_58_186 VGND VGND VPWR VPWR sky130_fd_sc_hd__decap_8
XFILLER_0_6_445 VPWR VGND VPWR VGND sky130_ef_sc_hd__decap_12
XFILLER_0_14_223 VGND VGND VPWR VPWR sky130_fd_sc_hd__decap_6
X_3775_ _1573_ _1948_ VGND VGND VPWR VPWR _1959_ sky130_fd_sc_hd__or2b_1
XFILLER_0_6_489 VPWR VGND VPWR VGND sky130_ef_sc_hd__decap_12
X_2726_ _0992_ _0988_ _1011_ _1017_ VGND VGND VPWR VPWR _1018_ sky130_fd_sc_hd__a211o_1
X_2657_ RF0.regs\[5\]\[5\] _0873_ _0853_ RF0.regs\[15\]\[5\] _0948_ VGND VGND VPWR
+ VPWR _0949_ sky130_fd_sc_hd__a221o_1
XFILLER_0_66_3 VPWR VGND VPWR VGND sky130_ef_sc_hd__decap_12
XFILLER_0_10_462 VGND VGND VPWR VPWR sky130_fd_sc_hd__fill_1
X_5376_ clknet_leaf_42_clk _0752_ _0368_ VGND VGND VPWR VPWR IM0.addr\[7\] sky130_fd_sc_hd__dfrtp_1
XFILLER_0_1_194 VPWR VGND VPWR VGND sky130_ef_sc_hd__decap_12
X_2588_ _0879_ VGND VGND VPWR VPWR _0880_ sky130_fd_sc_hd__clkbuf_4
X_4327_ RF0.regs\[15\]\[13\] _2066_ _2290_ VGND VGND VPWR VPWR _2299_ sky130_fd_sc_hd__mux2_1
X_4258_ net136 VGND VGND VPWR VPWR _2263_ sky130_fd_sc_hd__clkbuf_1
X_3209_ _1082_ _1403_ VGND VGND VPWR VPWR _1405_ sky130_fd_sc_hd__and2_1
X_4189_ RF0.regs\[10\]\[16\] _2008_ _2222_ VGND VGND VPWR VPWR _2228_ sky130_fd_sc_hd__mux2_1
XFILLER_0_77_440 VGND VGND VPWR VPWR sky130_fd_sc_hd__fill_2
XTAP_TAPCELL_ROW_25_413 VGND VPWR sky130_fd_sc_hd__tapvpwrvgnd_1
XFILLER_0_49_120 VGND VGND VPWR VPWR sky130_fd_sc_hd__decap_4
XFILLER_0_49_131 VGND VGND VPWR VPWR sky130_fd_sc_hd__fill_1
XFILLER_0_49_186 VGND VGND VPWR VPWR sky130_fd_sc_hd__decap_4
XTAP_TAPCELL_ROW_33_490 VGND VPWR sky130_fd_sc_hd__tapvpwrvgnd_1
XFILLER_0_52_307 VGND VGND VPWR VPWR sky130_fd_sc_hd__fill_1
Xhold190 IM0.addr\[6\] VGND VGND VPWR VPWR net238 sky130_fd_sc_hd__dlygate4sd3_1
XFILLER_0_18_49 VGND VGND VPWR VPWR sky130_fd_sc_hd__decap_3
XFILLER_0_18_27 VGND VGND VPWR VPWR sky130_fd_sc_hd__fill_1
XTAP_TAPCELL_ROW_76_869 VGND VPWR sky130_fd_sc_hd__tapvpwrvgnd_1
XPHY_EDGE_ROW_16_Right_16 VGND VGND VPWR VPWR sky130_fd_sc_hd__decap_3
XFILLER_0_87_248 VGND VGND VPWR VPWR sky130_fd_sc_hd__decap_4
XFILLER_0_68_440 VGND VGND VPWR VPWR sky130_fd_sc_hd__decap_8
XFILLER_0_50_58 VGND VGND VPWR VPWR sky130_fd_sc_hd__fill_1
XFILLER_0_55_167 VGND VGND VPWR VPWR sky130_fd_sc_hd__fill_1
XFILLER_0_43_318 VGND VGND VPWR VPWR sky130_fd_sc_hd__fill_1
X_3560_ RF0.regs\[20\]\[14\] _1222_ _1232_ RF0.regs\[6\]\[14\] _1751_ VGND VGND VPWR
+ VPWR _1752_ sky130_fd_sc_hd__a221o_1
XPHY_EDGE_ROW_25_Right_25 VGND VGND VPWR VPWR sky130_fd_sc_hd__decap_3
X_2511_ _0796_ _0802_ VGND VGND VPWR VPWR _0803_ sky130_fd_sc_hd__nor2_1
X_5230_ clknet_leaf_11_clk _0606_ _0222_ VGND VGND VPWR VPWR RF0.regs\[6\]\[21\] sky130_fd_sc_hd__dfrtp_1
X_3491_ _1683_ _1495_ VGND VGND VPWR VPWR _1684_ sky130_fd_sc_hd__and2_1
XFILLER_0_59_89 VPWR VGND VPWR VGND sky130_ef_sc_hd__decap_12
X_5161_ clknet_leaf_17_clk _0537_ _0153_ VGND VGND VPWR VPWR RF0.regs\[10\]\[16\]
+ sky130_fd_sc_hd__dfrtp_2
X_4112_ _2188_ VGND VGND VPWR VPWR _0575_ sky130_fd_sc_hd__clkbuf_1
XFILLER_0_75_55 VGND VGND VPWR VPWR sky130_fd_sc_hd__fill_1
X_5092_ clknet_leaf_25_clk _0468_ _0084_ VGND VGND VPWR VPWR RF0.regs\[15\]\[11\]
+ sky130_fd_sc_hd__dfrtp_1
X_4043_ _1996_ net272 _2149_ VGND VGND VPWR VPWR _2151_ sky130_fd_sc_hd__mux2_1
XPHY_EDGE_ROW_34_Right_34 VGND VGND VPWR VPWR sky130_fd_sc_hd__decap_3
XTAP_TAPCELL_ROW_39_538 VGND VPWR sky130_fd_sc_hd__tapvpwrvgnd_1
X_4945_ _2483_ VGND VGND VPWR VPWR _0333_ sky130_fd_sc_hd__inv_2
XFILLER_0_19_337 VGND VGND VPWR VPWR sky130_fd_sc_hd__decap_8
X_4876_ _2475_ VGND VGND VPWR VPWR _0272_ sky130_fd_sc_hd__inv_2
XFILLER_0_34_307 VGND VGND VPWR VPWR sky130_fd_sc_hd__fill_1
X_3827_ RF0.regs\[4\]\[19\] _2000_ _1993_ VGND VGND VPWR VPWR _2001_ sky130_fd_sc_hd__mux2_1
XFILLER_0_6_253 VPWR VGND VPWR VGND sky130_ef_sc_hd__decap_12
XPHY_EDGE_ROW_43_Right_43 VGND VGND VPWR VPWR sky130_fd_sc_hd__decap_3
XTAP_TAPCELL_ROW_30_460 VGND VPWR sky130_fd_sc_hd__tapvpwrvgnd_1
X_3758_ _1588_ _1542_ VGND VGND VPWR VPWR _1944_ sky130_fd_sc_hd__and2b_1
XFILLER_0_61_159 VGND VGND VPWR VPWR sky130_fd_sc_hd__fill_2
X_2709_ RF0.regs\[4\]\[24\] _0864_ _0878_ RF0.regs\[2\]\[24\] VGND VGND VPWR VPWR
+ _1001_ sky130_fd_sc_hd__a22o_1
X_3689_ RF0.regs\[4\]\[2\] _1237_ _1230_ RF0.regs\[6\]\[2\] _1874_ VGND VGND VPWR
+ VPWR _1875_ sky130_fd_sc_hd__a221o_1
X_5359_ clknet_leaf_10_clk _0735_ _0351_ VGND VGND VPWR VPWR RF0.regs\[0\]\[22\] sky130_fd_sc_hd__dfrtp_1
XPHY_EDGE_ROW_52_Right_52 VGND VGND VPWR VPWR sky130_fd_sc_hd__decap_3
XFILLER_0_77_281 VGND VGND VPWR VPWR sky130_fd_sc_hd__decap_6
XPHY_EDGE_ROW_61_Right_61 VGND VGND VPWR VPWR sky130_fd_sc_hd__decap_3
XFILLER_0_52_115 VGND VGND VPWR VPWR sky130_fd_sc_hd__fill_2
XFILLER_0_80_468 VGND VGND VPWR VPWR sky130_fd_sc_hd__decap_8
XFILLER_0_52_137 VGND VGND VPWR VPWR sky130_fd_sc_hd__decap_3
XFILLER_0_52_159 VPWR VGND VPWR VGND sky130_ef_sc_hd__decap_12
XPHY_EDGE_ROW_70_Right_70 VGND VGND VPWR VPWR sky130_fd_sc_hd__decap_3
XFILLER_0_75_218 VGND VGND VPWR VPWR sky130_fd_sc_hd__fill_1
XFILLER_0_0_27 VGND VGND VPWR VPWR sky130_fd_sc_hd__fill_1
X_2991_ net103 VGND VGND VPWR VPWR _1201_ sky130_fd_sc_hd__clkbuf_1
XFILLER_0_28_112 VGND VGND VPWR VPWR sky130_fd_sc_hd__fill_1
XFILLER_0_56_410 VGND VGND VPWR VPWR sky130_fd_sc_hd__fill_1
X_4730_ _2458_ VGND VGND VPWR VPWR _0143_ sky130_fd_sc_hd__inv_2
XFILLER_0_28_156 VPWR VGND VPWR VGND sky130_ef_sc_hd__decap_12
XTAP_TAPCELL_ROW_44_585 VGND VPWR sky130_fd_sc_hd__tapvpwrvgnd_1
XFILLER_0_83_262 VPWR VGND VPWR VGND sky130_ef_sc_hd__decap_12
XFILLER_0_71_424 VGND VGND VPWR VPWR sky130_fd_sc_hd__fill_1
XFILLER_0_71_402 VGND VGND VPWR VPWR sky130_fd_sc_hd__decap_3
XFILLER_0_16_329 VPWR VGND VPWR VGND sky130_ef_sc_hd__decap_12
X_4661_ _2449_ VGND VGND VPWR VPWR _0083_ sky130_fd_sc_hd__inv_2
XFILLER_0_9_69 VGND VGND VPWR VPWR sky130_fd_sc_hd__decap_8
X_3612_ _1801_ VGND VGND VPWR VPWR _1802_ sky130_fd_sc_hd__dlymetal6s2s_1
X_4592_ _2439_ VGND VGND VPWR VPWR _0024_ sky130_fd_sc_hd__inv_2
X_3543_ RF0.regs\[10\]\[15\] _0886_ _0814_ RF0.regs\[25\]\[15\] _1246_ VGND VGND VPWR
+ VPWR _1735_ sky130_fd_sc_hd__a221o_1
X_3474_ RF0.regs\[4\]\[21\] _1240_ _1224_ RF0.regs\[20\]\[21\] _1667_ VGND VGND VPWR
+ VPWR _1668_ sky130_fd_sc_hd__a221o_1
XFILLER_0_10_83 VGND VGND VPWR VPWR sky130_fd_sc_hd__fill_1
XFILLER_0_86_65 VPWR VGND VPWR VGND sky130_ef_sc_hd__decap_12
X_5213_ clknet_leaf_33_clk _0589_ _0205_ VGND VGND VPWR VPWR RF0.regs\[6\]\[4\] sky130_fd_sc_hd__dfrtp_1
X_5144_ clknet_leaf_2_clk _0520_ _0136_ VGND VGND VPWR VPWR RF0.regs\[12\]\[31\] sky130_fd_sc_hd__dfrtp_1
X_5075_ clknet_leaf_6_clk _0451_ _0067_ VGND VGND VPWR VPWR RF0.regs\[20\]\[26\] sky130_fd_sc_hd__dfrtp_1
XFILLER_0_29_3 VGND VGND VPWR VPWR sky130_fd_sc_hd__decap_4
X_4026_ _1965_ net275 _2138_ VGND VGND VPWR VPWR _2142_ sky130_fd_sc_hd__mux2_1
XFILLER_0_59_281 VGND VGND VPWR VPWR sky130_fd_sc_hd__decap_4
X_4928_ _2481_ VGND VGND VPWR VPWR _0318_ sky130_fd_sc_hd__inv_2
XFILLER_0_74_262 VGND VGND VPWR VPWR sky130_fd_sc_hd__fill_2
XFILLER_0_47_487 VGND VGND VPWR VPWR sky130_fd_sc_hd__fill_1
X_4859_ _2473_ VGND VGND VPWR VPWR _0257_ sky130_fd_sc_hd__inv_2
XFILLER_0_15_384 VGND VGND VPWR VPWR sky130_fd_sc_hd__fill_1
XFILLER_0_30_365 VGND VGND VPWR VPWR sky130_fd_sc_hd__decap_3
XTAP_TAPCELL_ROW_7_255 VGND VPWR sky130_fd_sc_hd__tapvpwrvgnd_1
XTAP_TAPCELL_ROW_86_964 VGND VPWR sky130_fd_sc_hd__tapvpwrvgnd_1
XFILLER_0_15_39 VPWR VGND VPWR VGND sky130_ef_sc_hd__decap_12
XFILLER_0_85_505 VPWR VGND VPWR VGND sky130_ef_sc_hd__decap_12
XFILLER_0_38_432 VGND VGND VPWR VPWR sky130_fd_sc_hd__decap_4
XFILLER_0_31_16 VGND VGND VPWR VPWR sky130_fd_sc_hd__fill_2
XTAP_TAPCELL_ROW_41_555 VGND VPWR sky130_fd_sc_hd__tapvpwrvgnd_1
XFILLER_0_53_435 VPWR VGND VPWR VGND sky130_ef_sc_hd__decap_12
XFILLER_0_53_457 VGND VGND VPWR VPWR sky130_fd_sc_hd__decap_3
XFILLER_0_40_129 VGND VGND VPWR VPWR sky130_fd_sc_hd__decap_3
XFILLER_0_0_237 VPWR VGND VPWR VGND sky130_ef_sc_hd__decap_12
X_3190_ _0952_ _1385_ VGND VGND VPWR VPWR _1386_ sky130_fd_sc_hd__nand2_1
XTAP_TAPCELL_ROW_49_633 VGND VPWR sky130_fd_sc_hd__tapvpwrvgnd_1
XFILLER_0_56_68 VGND VGND VPWR VPWR sky130_fd_sc_hd__decap_6
X_2974_ _1192_ VGND VGND VPWR VPWR _0703_ sky130_fd_sc_hd__clkbuf_1
XFILLER_0_56_251 VGND VGND VPWR VPWR sky130_fd_sc_hd__fill_1
X_4713_ _2456_ VGND VGND VPWR VPWR _0128_ sky130_fd_sc_hd__inv_2
XFILLER_0_71_221 VGND VGND VPWR VPWR sky130_fd_sc_hd__decap_3
XFILLER_0_56_295 VPWR VGND VPWR VGND sky130_ef_sc_hd__decap_12
XFILLER_0_71_265 VPWR VGND VPWR VGND sky130_ef_sc_hd__decap_12
X_4644_ _2446_ VGND VGND VPWR VPWR _0069_ sky130_fd_sc_hd__inv_2
X_4575_ _2437_ VGND VGND VPWR VPWR _2438_ sky130_fd_sc_hd__buf_4
X_3526_ _1009_ _1715_ _1717_ VGND VGND VPWR VPWR _1718_ sky130_fd_sc_hd__nand3_1
X_3457_ _1010_ _1640_ _1633_ _1634_ VGND VGND VPWR VPWR _1651_ sky130_fd_sc_hd__nand4_1
X_3388_ RF0.regs\[4\]\[28\] _1241_ _1224_ RF0.regs\[20\]\[28\] _1581_ VGND VGND VPWR
+ VPWR _1582_ sky130_fd_sc_hd__a221o_1
XTAP_TAPCELL_ROW_4_225 VGND VPWR sky130_fd_sc_hd__tapvpwrvgnd_1
X_5127_ clknet_leaf_16_clk _0503_ _0119_ VGND VGND VPWR VPWR RF0.regs\[12\]\[14\]
+ sky130_fd_sc_hd__dfrtp_1
XPHY_EDGE_ROW_2_Right_2 VGND VGND VPWR VPWR sky130_fd_sc_hd__decap_3
X_5058_ clknet_leaf_29_clk _0434_ _0050_ VGND VGND VPWR VPWR RF0.regs\[20\]\[9\] sky130_fd_sc_hd__dfrtp_1
XTAP_TAPCELL_ROW_83_934 VGND VPWR sky130_fd_sc_hd__tapvpwrvgnd_1
X_4009_ _2132_ VGND VGND VPWR VPWR _0621_ sky130_fd_sc_hd__clkbuf_1
XFILLER_0_67_505 VPWR VGND VPWR VGND sky130_ef_sc_hd__decap_12
XFILLER_0_1_81 VPWR VGND VPWR VGND sky130_ef_sc_hd__decap_12
XFILLER_0_47_273 VGND VGND VPWR VPWR sky130_fd_sc_hd__fill_1
XFILLER_0_35_479 VGND VGND VPWR VPWR sky130_fd_sc_hd__fill_2
XFILLER_0_50_405 VGND VGND VPWR VPWR sky130_fd_sc_hd__fill_2
XFILLER_0_50_416 VGND VGND VPWR VPWR sky130_fd_sc_hd__decap_4
XFILLER_0_43_490 VGND VGND VPWR VPWR sky130_fd_sc_hd__decap_6
Xhold50 RF0.regs\[7\]\[15\] VGND VGND VPWR VPWR net98 sky130_fd_sc_hd__dlygate4sd3_1
Xhold83 RF0.regs\[7\]\[20\] VGND VGND VPWR VPWR net131 sky130_fd_sc_hd__dlygate4sd3_1
Xhold61 RF0.regs\[2\]\[5\] VGND VGND VPWR VPWR net109 sky130_fd_sc_hd__dlygate4sd3_1
XFILLER_0_26_27 VGND VGND VPWR VPWR sky130_fd_sc_hd__fill_1
Xhold72 RF0.regs\[7\]\[24\] VGND VGND VPWR VPWR net120 sky130_fd_sc_hd__dlygate4sd3_1
Xhold94 RF0.regs\[0\]\[31\] VGND VGND VPWR VPWR net142 sky130_fd_sc_hd__dlygate4sd3_1
XTAP_TAPCELL_ROW_46_603 VGND VPWR sky130_fd_sc_hd__tapvpwrvgnd_1
XTAP_TAPCELL_ROW_18_349 VGND VPWR sky130_fd_sc_hd__tapvpwrvgnd_1
XFILLER_0_85_335 VGND VGND VPWR VPWR sky130_fd_sc_hd__fill_1
XFILLER_0_42_15 VGND VGND VPWR VPWR sky130_fd_sc_hd__decap_8
XFILLER_0_38_251 VGND VGND VPWR VPWR sky130_fd_sc_hd__fill_1
XFILLER_0_41_405 VGND VGND VPWR VPWR sky130_fd_sc_hd__fill_2
X_2690_ RF0.regs\[10\]\[9\] _0909_ _0867_ RF0.regs\[4\]\[9\] _0981_ VGND VGND VPWR
+ VPWR _0982_ sky130_fd_sc_hd__a221o_1
XFILLER_0_6_15 VPWR VGND VPWR VGND sky130_ef_sc_hd__decap_12
X_4360_ _2316_ VGND VGND VPWR VPWR _0455_ sky130_fd_sc_hd__clkbuf_1
X_3311_ _1312_ _1315_ _1317_ _1222_ VGND VGND VPWR VPWR _1507_ sky130_fd_sc_hd__o22ai_1
X_4291_ _2280_ VGND VGND VPWR VPWR _0488_ sky130_fd_sc_hd__clkbuf_1
X_3242_ _0914_ _1429_ VGND VGND VPWR VPWR _1438_ sky130_fd_sc_hd__nor2_2
X_3173_ net52 _1267_ _1268_ VGND VGND VPWR VPWR _1369_ sky130_fd_sc_hd__and3_1
XFILLER_0_83_55 VGND VGND VPWR VPWR sky130_fd_sc_hd__fill_1
Xrebuffer15 _1439_ VGND VGND VPWR VPWR net63 sky130_fd_sc_hd__dlygate4sd1_1
XFILLER_0_49_516 VGND VGND VPWR VPWR sky130_fd_sc_hd__fill_1
XFILLER_0_17_402 VGND VGND VPWR VPWR sky130_fd_sc_hd__decap_3
X_2957_ net169 VGND VGND VPWR VPWR _1184_ sky130_fd_sc_hd__clkbuf_1
XFILLER_0_17_457 VGND VGND VPWR VPWR sky130_fd_sc_hd__fill_2
X_2888_ _1148_ VGND VGND VPWR VPWR _1149_ sky130_fd_sc_hd__clkbuf_4
X_4627_ _2444_ VGND VGND VPWR VPWR _0054_ sky130_fd_sc_hd__inv_2
XFILLER_0_4_351 VPWR VGND VPWR VGND sky130_ef_sc_hd__decap_12
XFILLER_0_44_287 VPWR VGND VPWR VGND sky130_ef_sc_hd__decap_12
X_4558_ _2428_ VGND VGND VPWR VPWR net17 sky130_fd_sc_hd__clkbuf_1
XFILLER_0_12_195 VGND VGND VPWR VPWR sky130_fd_sc_hd__fill_1
X_4489_ _2383_ VGND VGND VPWR VPWR _0393_ sky130_fd_sc_hd__clkbuf_1
X_3509_ _1701_ _1473_ _1485_ _1494_ VGND VGND VPWR VPWR _1702_ sky130_fd_sc_hd__a22o_1
Xclkbuf_leaf_37_clk clknet_2_2__leaf_clk VGND VGND VPWR VPWR clknet_leaf_37_clk sky130_fd_sc_hd__clkbuf_8
XFILLER_0_82_305 VGND VGND VPWR VPWR sky130_fd_sc_hd__decap_3
XFILLER_0_12_29 VPWR VGND VPWR VGND sky130_ef_sc_hd__decap_12
XFILLER_0_35_210 VGND VGND VPWR VPWR sky130_fd_sc_hd__decap_6
XFILLER_0_35_232 VGND VGND VPWR VPWR sky130_fd_sc_hd__fill_1
XTAP_TAPCELL_ROW_51_650 VGND VPWR sky130_fd_sc_hd__tapvpwrvgnd_1
XTAP_TAPCELL_ROW_23_396 VGND VPWR sky130_fd_sc_hd__tapvpwrvgnd_1
XFILLER_0_23_449 VGND VGND VPWR VPWR sky130_fd_sc_hd__decap_4
Xoutput5 net5 VGND VGND VPWR VPWR Result[12] sky130_fd_sc_hd__buf_2
Xoutput40 net40 VGND VGND VPWR VPWR seg[2] sky130_fd_sc_hd__buf_2
Xclkbuf_leaf_28_clk clknet_2_2__leaf_clk VGND VGND VPWR VPWR clknet_leaf_28_clk sky130_fd_sc_hd__clkbuf_8
X_3860_ _1850_ net29 VGND VGND VPWR VPWR _2028_ sky130_fd_sc_hd__nor2_1
XFILLER_0_58_379 VGND VGND VPWR VPWR sky130_fd_sc_hd__decap_3
X_2811_ _0805_ _1102_ VGND VGND VPWR VPWR _1103_ sky130_fd_sc_hd__nand2_1
X_3791_ _1972_ VGND VGND VPWR VPWR _0676_ sky130_fd_sc_hd__clkbuf_1
XFILLER_0_5_126 VGND VGND VPWR VPWR sky130_fd_sc_hd__decap_3
XFILLER_0_26_243 VGND VGND VPWR VPWR sky130_fd_sc_hd__fill_2
X_2742_ RF0.regs\[5\]\[26\] _0875_ _0855_ RF0.regs\[15\]\[26\] _1033_ VGND VGND VPWR
+ VPWR _1034_ sky130_fd_sc_hd__a221o_1
X_4412_ _2343_ VGND VGND VPWR VPWR _0430_ sky130_fd_sc_hd__clkbuf_1
X_2673_ RF0.regs\[4\]\[27\] _0838_ _0844_ RF0.regs\[12\]\[27\] VGND VGND VPWR VPWR
+ _0965_ sky130_fd_sc_hd__a22o_1
X_5392_ clknet_leaf_42_clk _0768_ _0384_ VGND VGND VPWR VPWR IM0.addr\[23\] sky130_fd_sc_hd__dfrtp_1
X_4343_ _2307_ VGND VGND VPWR VPWR _0463_ sky130_fd_sc_hd__clkbuf_1
X_4274_ net74 VGND VGND VPWR VPWR _2271_ sky130_fd_sc_hd__clkbuf_1
X_3225_ _1293_ _1294_ VGND VGND VPWR VPWR _1421_ sky130_fd_sc_hd__or2_1
XFILLER_0_27_70 VGND VGND VPWR VPWR sky130_fd_sc_hd__fill_2
X_3156_ _1349_ _1351_ VGND VGND VPWR VPWR _1352_ sky130_fd_sc_hd__nand2_1
Xclkbuf_leaf_19_clk clknet_2_3__leaf_clk VGND VGND VPWR VPWR clknet_leaf_19_clk sky130_fd_sc_hd__clkbuf_8
X_3087_ RF0.regs\[5\]\[2\] _0901_ _0871_ _1236_ RF0.regs\[2\]\[2\] VGND VGND VPWR
+ VPWR _1283_ sky130_fd_sc_hd__a32o_1
XFILLER_0_11_3 VPWR VGND VPWR VGND sky130_ef_sc_hd__decap_12
XTAP_TAPCELL_ROW_65_775 VGND VPWR sky130_fd_sc_hd__tapvpwrvgnd_1
XFILLER_0_49_335 VGND VGND VPWR VPWR sky130_fd_sc_hd__fill_1
XFILLER_0_76_176 VPWR VGND VPWR VGND sky130_ef_sc_hd__decap_12
XFILLER_0_64_327 VGND VGND VPWR VPWR sky130_fd_sc_hd__decap_3
X_3989_ RF0.regs\[5\]\[13\] _2066_ _2113_ VGND VGND VPWR VPWR _2122_ sky130_fd_sc_hd__mux2_1
XTAP_TAPCELL_ROW_20_366 VGND VPWR sky130_fd_sc_hd__tapvpwrvgnd_1
XFILLER_0_13_460 VGND VGND VPWR VPWR sky130_fd_sc_hd__fill_1
XTAP_TAPCELL_ROW_28_444 VGND VPWR sky130_fd_sc_hd__tapvpwrvgnd_1
XFILLER_0_67_132 VGND VGND VPWR VPWR sky130_fd_sc_hd__decap_4
XFILLER_0_67_154 VGND VGND VPWR VPWR sky130_fd_sc_hd__fill_1
XFILLER_0_2_107 VGND VGND VPWR VPWR sky130_fd_sc_hd__fill_2
XFILLER_0_23_235 VPWR VGND VPWR VGND sky130_ef_sc_hd__decap_12
Xrebuffer6 _0871_ VGND VGND VPWR VPWR net54 sky130_fd_sc_hd__dlygate4sd1_1
XFILLER_0_23_279 VGND VGND VPWR VPWR sky130_fd_sc_hd__fill_1
XFILLER_0_3_27 VPWR VGND VPWR VGND sky130_ef_sc_hd__decap_12
X_3010_ _1210_ VGND VGND VPWR VPWR _0685_ sky130_fd_sc_hd__clkbuf_1
XFILLER_0_78_419 VGND VGND VPWR VPWR sky130_fd_sc_hd__fill_1
X_4961_ _2485_ VGND VGND VPWR VPWR _0347_ sky130_fd_sc_hd__inv_2
X_4892_ _2476_ VGND VGND VPWR VPWR _0287_ sky130_fd_sc_hd__inv_2
X_3912_ _2074_ VGND VGND VPWR VPWR _0660_ sky130_fd_sc_hd__clkbuf_1
XFILLER_0_58_165 VGND VGND VPWR VPWR sky130_fd_sc_hd__decap_3
XTAP_TAPCELL_ROW_62_745 VGND VPWR sky130_fd_sc_hd__tapvpwrvgnd_1
X_3843_ RF0.regs\[4\]\[15\] _2012_ _1993_ VGND VGND VPWR VPWR _2013_ sky130_fd_sc_hd__mux2_1
XFILLER_0_6_424 VGND VGND VPWR VPWR sky130_fd_sc_hd__decap_8
XFILLER_0_6_457 VPWR VGND VPWR VGND sky130_ef_sc_hd__decap_12
X_3774_ _1958_ VGND VGND VPWR VPWR _0679_ sky130_fd_sc_hd__clkbuf_1
XFILLER_0_61_319 VGND VGND VPWR VPWR sky130_fd_sc_hd__decap_6
XFILLER_0_81_190 VGND VGND VPWR VPWR sky130_fd_sc_hd__fill_1
X_2725_ _1013_ _1016_ VGND VGND VPWR VPWR _1017_ sky130_fd_sc_hd__xor2_1
X_2656_ RF0.regs\[10\]\[5\] _0882_ VGND VGND VPWR VPWR _0948_ sky130_fd_sc_hd__and2_1
Xclkbuf_leaf_8_clk clknet_2_1__leaf_clk VGND VGND VPWR VPWR clknet_leaf_8_clk sky130_fd_sc_hd__clkbuf_8
X_5375_ clknet_leaf_42_clk _0751_ _0367_ VGND VGND VPWR VPWR IM0.addr\[6\] sky130_fd_sc_hd__dfrtp_1
X_2587_ _0878_ VGND VGND VPWR VPWR _0879_ sky130_fd_sc_hd__buf_4
XFILLER_0_59_3 VGND VGND VPWR VPWR sky130_fd_sc_hd__decap_4
X_4326_ _2298_ VGND VGND VPWR VPWR _0471_ sky130_fd_sc_hd__clkbuf_1
X_4257_ _2262_ VGND VGND VPWR VPWR _0504_ sky130_fd_sc_hd__clkbuf_1
X_4188_ _2227_ VGND VGND VPWR VPWR _0538_ sky130_fd_sc_hd__clkbuf_1
X_3208_ _1082_ _1403_ VGND VGND VPWR VPWR _1404_ sky130_fd_sc_hd__or2_1
X_3139_ _1333_ _1334_ VGND VGND VPWR VPWR _1335_ sky130_fd_sc_hd__nor2_1
XTAP_TAPCELL_ROW_25_414 VGND VPWR sky130_fd_sc_hd__tapvpwrvgnd_1
XFILLER_0_49_198 VGND VGND VPWR VPWR sky130_fd_sc_hd__fill_2
XFILLER_0_64_113 VGND VGND VPWR VPWR sky130_fd_sc_hd__decap_3
XFILLER_0_9_295 VPWR VGND VPWR VGND sky130_ef_sc_hd__decap_12
XFILLER_0_64_179 VGND VGND VPWR VPWR sky130_fd_sc_hd__fill_1
XFILLER_0_45_393 VGND VGND VPWR VPWR sky130_fd_sc_hd__decap_6
Xhold180 RF0.regs\[6\]\[18\] VGND VGND VPWR VPWR net228 sky130_fd_sc_hd__dlygate4sd3_1
Xhold191 RF0.regs\[20\]\[19\] VGND VGND VPWR VPWR net239 sky130_fd_sc_hd__dlygate4sd3_1
XPHY_EDGE_ROW_0_Left_88 VGND VGND VPWR VPWR sky130_fd_sc_hd__decap_3
XFILLER_0_0_3 VPWR VGND VPWR VGND sky130_ef_sc_hd__decap_12
XFILLER_0_34_27 VGND VGND VPWR VPWR sky130_fd_sc_hd__fill_1
XFILLER_0_68_430 VGND VGND VPWR VPWR sky130_fd_sc_hd__decap_4
XFILLER_0_50_37 VGND VGND VPWR VPWR sky130_fd_sc_hd__decap_8
XFILLER_0_24_511 VGND VGND VPWR VPWR sky130_fd_sc_hd__fill_2
XFILLER_0_3_405 VPWR VGND VPWR VGND sky130_ef_sc_hd__decap_12
X_2510_ IM0.addr\[2\] IM0.addr\[1\] VGND VGND VPWR VPWR _0802_ sky130_fd_sc_hd__and2b_1
XFILLER_0_11_205 VGND VGND VPWR VPWR sky130_fd_sc_hd__decap_4
XFILLER_0_3_449 VPWR VGND VPWR VGND sky130_ef_sc_hd__decap_12
X_3490_ _1682_ VGND VGND VPWR VPWR _1683_ sky130_fd_sc_hd__inv_2
XFILLER_0_59_35 VGND VGND VPWR VPWR sky130_fd_sc_hd__fill_1
X_5160_ clknet_leaf_16_clk _0536_ _0152_ VGND VGND VPWR VPWR RF0.regs\[10\]\[15\]
+ sky130_fd_sc_hd__dfrtp_1
X_4111_ net96 VGND VGND VPWR VPWR _2188_ sky130_fd_sc_hd__clkbuf_1
XFILLER_0_45_9 VGND VGND VPWR VPWR sky130_fd_sc_hd__fill_1
X_5091_ clknet_leaf_25_clk _0467_ _0083_ VGND VGND VPWR VPWR RF0.regs\[15\]\[10\]
+ sky130_fd_sc_hd__dfrtp_1
X_4042_ _2150_ VGND VGND VPWR VPWR _0606_ sky130_fd_sc_hd__clkbuf_1
XFILLER_0_75_89 VPWR VGND VPWR VGND sky130_ef_sc_hd__decap_12
XTAP_TAPCELL_ROW_39_539 VGND VPWR sky130_fd_sc_hd__tapvpwrvgnd_1
X_4944_ _2483_ VGND VGND VPWR VPWR _0332_ sky130_fd_sc_hd__inv_2
XFILLER_0_74_433 VPWR VGND VPWR VGND sky130_ef_sc_hd__decap_12
X_4875_ _2475_ VGND VGND VPWR VPWR _0271_ sky130_fd_sc_hd__inv_2
X_3826_ _1708_ _1999_ VGND VGND VPWR VPWR _2000_ sky130_fd_sc_hd__xnor2_2
XFILLER_0_74_477 VPWR VGND VPWR VGND sky130_ef_sc_hd__decap_12
XFILLER_0_6_265 VGND VGND VPWR VPWR sky130_fd_sc_hd__decap_4
XFILLER_0_27_393 VGND VGND VPWR VPWR sky130_fd_sc_hd__decap_8
XTAP_TAPCELL_ROW_30_461 VGND VPWR sky130_fd_sc_hd__tapvpwrvgnd_1
X_3757_ _1542_ _1588_ VGND VGND VPWR VPWR _1943_ sky130_fd_sc_hd__and2b_1
XFILLER_0_54_190 VGND VGND VPWR VPWR sky130_fd_sc_hd__fill_1
XPHY_EDGE_ROW_18_Left_106 VGND VGND VPWR VPWR sky130_fd_sc_hd__decap_3
XFILLER_0_42_363 VGND VGND VPWR VPWR sky130_fd_sc_hd__fill_1
X_2708_ RF0.regs\[10\]\[24\] _0885_ _0855_ RF0.regs\[15\]\[24\] VGND VGND VPWR VPWR
+ _1000_ sky130_fd_sc_hd__a22o_1
X_3688_ RF0.regs\[25\]\[2\] _0810_ _1078_ _0794_ VGND VGND VPWR VPWR _1874_ sky130_fd_sc_hd__a211o_1
X_2639_ RF0.regs\[10\]\[16\] _0816_ _0830_ RF0.regs\[25\]\[16\] _0930_ VGND VGND VPWR
+ VPWR _0931_ sky130_fd_sc_hd__a221o_1
X_5358_ clknet_leaf_11_clk _0734_ _0350_ VGND VGND VPWR VPWR RF0.regs\[0\]\[21\] sky130_fd_sc_hd__dfrtp_1
X_4309_ _2289_ VGND VGND VPWR VPWR _0479_ sky130_fd_sc_hd__clkbuf_1
XFILLER_0_10_293 VPWR VGND VPWR VGND sky130_ef_sc_hd__decap_12
X_5289_ clknet_leaf_18_clk _0665_ _0281_ VGND VGND VPWR VPWR RF0.regs\[4\]\[16\] sky130_fd_sc_hd__dfrtp_2
XFILLER_0_69_205 VGND VGND VPWR VPWR sky130_fd_sc_hd__fill_1
XPHY_EDGE_ROW_27_Left_115 VGND VGND VPWR VPWR sky130_fd_sc_hd__decap_3
XFILLER_0_37_113 VGND VGND VPWR VPWR sky130_fd_sc_hd__decap_8
XFILLER_0_52_105 VGND VGND VPWR VPWR sky130_fd_sc_hd__decap_3
XFILLER_0_20_29 VPWR VGND VPWR VGND sky130_ef_sc_hd__decap_12
XPHY_EDGE_ROW_36_Left_124 VGND VGND VPWR VPWR sky130_fd_sc_hd__decap_3
XPHY_EDGE_ROW_45_Left_133 VGND VGND VPWR VPWR sky130_fd_sc_hd__decap_3
XTAP_TAPCELL_ROW_36_509 VGND VPWR sky130_fd_sc_hd__tapvpwrvgnd_1
XTAP_TAPCELL_ROW_72_840 VGND VPWR sky130_fd_sc_hd__tapvpwrvgnd_1
X_2990_ _1200_ VGND VGND VPWR VPWR _0695_ sky130_fd_sc_hd__clkbuf_1
XTAP_TAPCELL_ROW_44_586 VGND VPWR sky130_fd_sc_hd__tapvpwrvgnd_1
XFILLER_0_83_274 VGND VGND VPWR VPWR sky130_fd_sc_hd__decap_3
XFILLER_0_9_15 VPWR VGND VPWR VGND sky130_ef_sc_hd__decap_12
XFILLER_0_28_168 VGND VGND VPWR VPWR sky130_fd_sc_hd__decap_3
X_4660_ _2449_ VGND VGND VPWR VPWR _0082_ sky130_fd_sc_hd__inv_2
XPHY_EDGE_ROW_54_Left_142 VGND VGND VPWR VPWR sky130_fd_sc_hd__decap_3
X_3611_ _1436_ _1439_ VGND VGND VPWR VPWR _1801_ sky130_fd_sc_hd__or2_1
XFILLER_0_3_213 VGND VGND VPWR VPWR sky130_fd_sc_hd__decap_8
XFILLER_0_3_235 VGND VGND VPWR VPWR sky130_fd_sc_hd__fill_1
X_4591_ _2439_ VGND VGND VPWR VPWR _0023_ sky130_fd_sc_hd__inv_2
X_3542_ RF0.regs\[15\]\[15\] _1228_ _1733_ VGND VGND VPWR VPWR _1734_ sky130_fd_sc_hd__a21o_1
X_3473_ RF0.regs\[10\]\[21\] _0887_ _0815_ RF0.regs\[25\]\[21\] _1247_ VGND VGND VPWR
+ VPWR _1667_ sky130_fd_sc_hd__a221o_1
X_5212_ clknet_leaf_35_clk _0588_ _0204_ VGND VGND VPWR VPWR RF0.regs\[6\]\[3\] sky130_fd_sc_hd__dfrtp_1
XFILLER_0_86_77 VGND VGND VPWR VPWR sky130_fd_sc_hd__decap_6
X_5143_ clknet_leaf_2_clk _0519_ _0135_ VGND VGND VPWR VPWR RF0.regs\[12\]\[30\] sky130_fd_sc_hd__dfrtp_1
XPHY_EDGE_ROW_63_Left_151 VGND VGND VPWR VPWR sky130_fd_sc_hd__decap_3
X_5074_ clknet_leaf_9_clk _0450_ _0066_ VGND VGND VPWR VPWR RF0.regs\[20\]\[25\] sky130_fd_sc_hd__dfrtp_1
X_4025_ _2141_ VGND VGND VPWR VPWR _0614_ sky130_fd_sc_hd__clkbuf_1
XFILLER_0_19_113 VGND VGND VPWR VPWR sky130_fd_sc_hd__fill_1
XPHY_EDGE_ROW_72_Left_160 VGND VGND VPWR VPWR sky130_fd_sc_hd__decap_3
X_4927_ _2481_ VGND VGND VPWR VPWR _0317_ sky130_fd_sc_hd__inv_2
X_4858_ _2473_ VGND VGND VPWR VPWR _0256_ sky130_fd_sc_hd__inv_2
X_3809_ RF0.regs\[4\]\[23\] _1986_ _1953_ VGND VGND VPWR VPWR _1987_ sky130_fd_sc_hd__mux2_1
XFILLER_0_62_447 VPWR VGND VPWR VGND sky130_ef_sc_hd__decap_12
X_4789_ _2466_ VGND VGND VPWR VPWR _0194_ sky130_fd_sc_hd__inv_2
XFILLER_0_42_171 VGND VGND VPWR VPWR sky130_fd_sc_hd__fill_1
XTAP_TAPCELL_ROW_7_256 VGND VPWR sky130_fd_sc_hd__tapvpwrvgnd_1
XTAP_TAPCELL_ROW_86_965 VGND VPWR sky130_fd_sc_hd__tapvpwrvgnd_1
XTAP_TAPCELL_ROW_41_556 VGND VPWR sky130_fd_sc_hd__tapvpwrvgnd_1
XFILLER_0_53_447 VGND VGND VPWR VPWR sky130_fd_sc_hd__fill_1
XFILLER_0_21_311 VGND VGND VPWR VPWR sky130_fd_sc_hd__fill_1
XFILLER_0_0_249 VGND VGND VPWR VPWR sky130_fd_sc_hd__decap_3
XPHY_EDGE_ROW_3_Left_91 VGND VGND VPWR VPWR sky130_fd_sc_hd__decap_3
XTAP_TAPCELL_ROW_49_634 VGND VPWR sky130_fd_sc_hd__tapvpwrvgnd_1
X_2973_ net254 VGND VGND VPWR VPWR _1192_ sky130_fd_sc_hd__clkbuf_1
XFILLER_0_56_230 VGND VGND VPWR VPWR sky130_fd_sc_hd__fill_1
XFILLER_0_71_200 VGND VGND VPWR VPWR sky130_fd_sc_hd__decap_4
XFILLER_0_29_477 VPWR VGND VPWR VGND sky130_ef_sc_hd__decap_12
X_4712_ _2456_ VGND VGND VPWR VPWR _0127_ sky130_fd_sc_hd__inv_2
XFILLER_0_71_277 VGND VGND VPWR VPWR sky130_fd_sc_hd__decap_3
X_4643_ _2442_ VGND VGND VPWR VPWR _2446_ sky130_fd_sc_hd__buf_2
X_4574_ _2435_ VGND VGND VPWR VPWR _2437_ sky130_fd_sc_hd__dlymetal6s2s_1
X_3525_ _1703_ _1709_ VGND VGND VPWR VPWR _1717_ sky130_fd_sc_hd__xor2_1
X_3456_ _1647_ _1649_ VGND VGND VPWR VPWR _1650_ sky130_fd_sc_hd__xnor2_2
X_3387_ RF0.regs\[10\]\[28\] _0909_ _0816_ RF0.regs\[25\]\[28\] _1247_ VGND VGND VPWR
+ VPWR _1581_ sky130_fd_sc_hd__a221o_1
XTAP_TAPCELL_ROW_4_226 VGND VPWR sky130_fd_sc_hd__tapvpwrvgnd_1
X_5126_ clknet_leaf_16_clk _0502_ _0118_ VGND VGND VPWR VPWR RF0.regs\[12\]\[13\]
+ sky130_fd_sc_hd__dfrtp_1
X_5057_ clknet_leaf_29_clk _0433_ _0049_ VGND VGND VPWR VPWR RF0.regs\[20\]\[8\] sky130_fd_sc_hd__dfrtp_1
X_4008_ RF0.regs\[5\]\[4\] _2092_ _2124_ VGND VGND VPWR VPWR _2132_ sky130_fd_sc_hd__mux2_1
XTAP_TAPCELL_ROW_83_935 VGND VPWR sky130_fd_sc_hd__tapvpwrvgnd_1
XFILLER_0_79_344 VPWR VGND VPWR VGND sky130_ef_sc_hd__decap_12
XFILLER_0_1_93 VPWR VGND VPWR VGND sky130_ef_sc_hd__decap_12
XFILLER_0_30_163 VGND VGND VPWR VPWR sky130_fd_sc_hd__fill_2
Xhold40 RF0.regs\[7\]\[12\] VGND VGND VPWR VPWR net88 sky130_fd_sc_hd__dlygate4sd3_1
Xhold62 RF0.regs\[0\]\[16\] VGND VGND VPWR VPWR net110 sky130_fd_sc_hd__dlygate4sd3_1
Xhold73 RF0.regs\[0\]\[3\] VGND VGND VPWR VPWR net121 sky130_fd_sc_hd__dlygate4sd3_1
Xhold51 RF0.regs\[7\]\[31\] VGND VGND VPWR VPWR net99 sky130_fd_sc_hd__dlygate4sd3_1
Xhold84 RF0.regs\[0\]\[0\] VGND VGND VPWR VPWR net132 sky130_fd_sc_hd__dlygate4sd3_1
XTAP_TAPCELL_ROW_46_604 VGND VPWR sky130_fd_sc_hd__tapvpwrvgnd_1
Xhold95 RF0.regs\[0\]\[11\] VGND VGND VPWR VPWR net143 sky130_fd_sc_hd__dlygate4sd3_1
XFILLER_0_5_319 VPWR VGND VPWR VGND sky130_ef_sc_hd__decap_12
XFILLER_0_26_447 VGND VGND VPWR VPWR sky130_fd_sc_hd__decap_3
XFILLER_0_1_503 VGND VGND VPWR VPWR sky130_fd_sc_hd__fill_1
XFILLER_0_6_27 VGND VGND VPWR VPWR sky130_fd_sc_hd__fill_1
X_3310_ RF0.regs\[25\]\[22\] _1252_ _1254_ RF0.regs\[12\]\[22\] _1505_ VGND VGND VPWR
+ VPWR _1506_ sky130_fd_sc_hd__a221o_1
X_4290_ RF0.regs\[15\]\[31\] _1952_ _2279_ VGND VGND VPWR VPWR _2280_ sky130_fd_sc_hd__mux2_1
XFILLER_0_67_57 VGND VGND VPWR VPWR sky130_fd_sc_hd__fill_1
X_3241_ _1435_ _1436_ VGND VGND VPWR VPWR _1437_ sky130_fd_sc_hd__or2_1
X_3172_ _1367_ _0926_ VGND VGND VPWR VPWR _1368_ sky130_fd_sc_hd__xor2_1
Xrebuffer16 net63 VGND VGND VPWR VPWR net64 sky130_fd_sc_hd__dlygate4sd1_1
XTAP_TAPCELL_ROW_80_905 VGND VPWR sky130_fd_sc_hd__tapvpwrvgnd_1
XFILLER_0_76_303 VGND VGND VPWR VPWR sky130_fd_sc_hd__fill_1
XFILLER_0_16_83 VGND VGND VPWR VPWR sky130_fd_sc_hd__fill_1
XFILLER_0_84_380 VPWR VGND VPWR VGND sky130_ef_sc_hd__decap_12
X_2956_ _1183_ VGND VGND VPWR VPWR _0712_ sky130_fd_sc_hd__clkbuf_1
XFILLER_0_44_211 VGND VGND VPWR VPWR sky130_fd_sc_hd__decap_6
X_2887_ _1010_ VGND VGND VPWR VPWR _1148_ sky130_fd_sc_hd__buf_4
XFILLER_0_32_406 VGND VGND VPWR VPWR sky130_fd_sc_hd__fill_2
XFILLER_0_44_299 VGND VGND VPWR VPWR sky130_fd_sc_hd__decap_8
X_4626_ _2444_ VGND VGND VPWR VPWR _0053_ sky130_fd_sc_hd__inv_2
XFILLER_0_4_363 VGND VGND VPWR VPWR sky130_fd_sc_hd__fill_1
XFILLER_0_12_141 VGND VGND VPWR VPWR sky130_fd_sc_hd__decap_8
X_4557_ _1149_ _1633_ _1634_ VGND VGND VPWR VPWR _2428_ sky130_fd_sc_hd__and3_1
X_4488_ RF0.regs\[25\]\[0\] _2177_ _0817_ VGND VGND VPWR VPWR _2383_ sky130_fd_sc_hd__mux2_1
X_3508_ RF0.regs\[4\]\[16\] _0837_ _1138_ RF0.regs\[12\]\[16\] _1700_ VGND VGND VPWR
+ VPWR _1701_ sky130_fd_sc_hd__a221o_1
X_3439_ _1504_ _1630_ _1632_ VGND VGND VPWR VPWR _1633_ sky130_fd_sc_hd__nand3_1
X_5109_ clknet_leaf_0_clk _0485_ _0101_ VGND VGND VPWR VPWR RF0.regs\[15\]\[28\] sky130_fd_sc_hd__dfrtp_1
XFILLER_0_75_391 VGND VGND VPWR VPWR sky130_fd_sc_hd__fill_1
XTAP_TAPCELL_ROW_51_651 VGND VPWR sky130_fd_sc_hd__tapvpwrvgnd_1
XTAP_TAPCELL_ROW_23_397 VGND VPWR sky130_fd_sc_hd__tapvpwrvgnd_1
Xoutput6 net6 VGND VGND VPWR VPWR Result[13] sky130_fd_sc_hd__buf_2
Xoutput41 net41 VGND VGND VPWR VPWR seg[3] sky130_fd_sc_hd__buf_2
Xoutput30 net30 VGND VGND VPWR VPWR Result[6] sky130_fd_sc_hd__buf_2
XFILLER_0_58_303 VGND VGND VPWR VPWR sky130_fd_sc_hd__decap_4
XFILLER_0_85_111 VGND VGND VPWR VPWR sky130_fd_sc_hd__fill_1
X_2810_ _0941_ _1020_ _1077_ _1101_ VGND VGND VPWR VPWR _1102_ sky130_fd_sc_hd__or4b_2
X_3790_ RF0.regs\[4\]\[27\] _1971_ _1953_ VGND VGND VPWR VPWR _1972_ sky130_fd_sc_hd__mux2_1
X_2741_ RF0.regs\[10\]\[26\] _0885_ VGND VGND VPWR VPWR _1033_ sky130_fd_sc_hd__and2_1
X_4411_ net208 _2090_ _2336_ VGND VGND VPWR VPWR _2343_ sky130_fd_sc_hd__mux2_1
X_2672_ RF0.regs\[10\]\[27\] _0887_ _0867_ RF0.regs\[4\]\[27\] _0963_ VGND VGND VPWR
+ VPWR _0964_ sky130_fd_sc_hd__a221o_1
X_5391_ clknet_leaf_43_clk _0767_ _0383_ VGND VGND VPWR VPWR IM0.addr\[22\] sky130_fd_sc_hd__dfrtp_1
XFILLER_0_1_333 VGND VGND VPWR VPWR sky130_fd_sc_hd__decap_3
X_4342_ RF0.regs\[15\]\[6\] _2088_ _2301_ VGND VGND VPWR VPWR _2307_ sky130_fd_sc_hd__mux2_1
X_4273_ _2270_ VGND VGND VPWR VPWR _0496_ sky130_fd_sc_hd__clkbuf_1
X_3224_ _1390_ _1391_ _1413_ _1417_ _1419_ VGND VGND VPWR VPWR _1420_ sky130_fd_sc_hd__a41oi_2
.ends
