* NGSPICE file created from top.ext - technology: sky130A

* Black-box entry subcircuit for sky130_fd_sc_hd__clkbuf_1 abstract view
.subckt sky130_fd_sc_hd__clkbuf_1 A VGND VNB VPB VPWR X
.ends

* Black-box entry subcircuit for sky130_fd_sc_hd__buf_2 abstract view
.subckt sky130_fd_sc_hd__buf_2 A VGND VNB VPB VPWR X
.ends

* Black-box entry subcircuit for sky130_fd_sc_hd__mux2_1 abstract view
.subckt sky130_fd_sc_hd__mux2_1 A0 A1 S VGND VNB VPB VPWR X
.ends

* Black-box entry subcircuit for sky130_fd_sc_hd__fill_1 abstract view
.subckt sky130_fd_sc_hd__fill_1 VGND VNB VPB VPWR
.ends

* Black-box entry subcircuit for sky130_ef_sc_hd__decap_12 abstract view
.subckt sky130_ef_sc_hd__decap_12 VPWR VGND VPB VNB
.ends

* Black-box entry subcircuit for sky130_fd_sc_hd__tapvpwrvgnd_1 abstract view
.subckt sky130_fd_sc_hd__tapvpwrvgnd_1 VGND VPWR
.ends

* Black-box entry subcircuit for sky130_fd_sc_hd__fill_2 abstract view
.subckt sky130_fd_sc_hd__fill_2 VGND VNB VPB VPWR
.ends

* Black-box entry subcircuit for sky130_fd_sc_hd__dfxtp_1 abstract view
.subckt sky130_fd_sc_hd__dfxtp_1 CLK D VGND VNB VPB VPWR Q
.ends

* Black-box entry subcircuit for sky130_fd_sc_hd__decap_3 abstract view
.subckt sky130_fd_sc_hd__decap_3 VGND VNB VPB VPWR
.ends

* Black-box entry subcircuit for sky130_fd_sc_hd__decap_6 abstract view
.subckt sky130_fd_sc_hd__decap_6 VGND VNB VPB VPWR
.ends

* Black-box entry subcircuit for sky130_fd_sc_hd__nor2_1 abstract view
.subckt sky130_fd_sc_hd__nor2_1 A B VGND VNB VPB VPWR Y
.ends

* Black-box entry subcircuit for sky130_fd_sc_hd__mux4_1 abstract view
.subckt sky130_fd_sc_hd__mux4_1 A0 A1 A2 A3 S0 S1 VGND VNB VPB VPWR X
.ends

* Black-box entry subcircuit for sky130_fd_sc_hd__dlygate4sd3_1 abstract view
.subckt sky130_fd_sc_hd__dlygate4sd3_1 A VGND VNB VPB VPWR X
.ends

* Black-box entry subcircuit for sky130_fd_sc_hd__dlygate4sd1_1 abstract view
.subckt sky130_fd_sc_hd__dlygate4sd1_1 A VGND VNB VPB VPWR X
.ends

* Black-box entry subcircuit for sky130_fd_sc_hd__clkbuf_8 abstract view
.subckt sky130_fd_sc_hd__clkbuf_8 A VGND VNB VPB VPWR X
.ends

* Black-box entry subcircuit for sky130_fd_sc_hd__decap_8 abstract view
.subckt sky130_fd_sc_hd__decap_8 VGND VNB VPB VPWR
.ends

* Black-box entry subcircuit for sky130_fd_sc_hd__clkbuf_4 abstract view
.subckt sky130_fd_sc_hd__clkbuf_4 A VGND VNB VPB VPWR X
.ends

* Black-box entry subcircuit for sky130_fd_sc_hd__a21o_1 abstract view
.subckt sky130_fd_sc_hd__a21o_1 A1 A2 B1 VGND VNB VPB VPWR X
.ends

* Black-box entry subcircuit for sky130_fd_sc_hd__clkbuf_2 abstract view
.subckt sky130_fd_sc_hd__clkbuf_2 A VGND VNB VPB VPWR X
.ends

* Black-box entry subcircuit for sky130_fd_sc_hd__decap_4 abstract view
.subckt sky130_fd_sc_hd__decap_4 VGND VNB VPB VPWR
.ends

* Black-box entry subcircuit for sky130_fd_sc_hd__nand2_1 abstract view
.subckt sky130_fd_sc_hd__nand2_1 A B VGND VNB VPB VPWR Y
.ends

* Black-box entry subcircuit for sky130_fd_sc_hd__o2bb2a_2 abstract view
.subckt sky130_fd_sc_hd__o2bb2a_2 A1_N A2_N B1 B2 VGND VNB VPB VPWR X
.ends

* Black-box entry subcircuit for sky130_fd_sc_hd__o21ai_1 abstract view
.subckt sky130_fd_sc_hd__o21ai_1 A1 A2 B1 VGND VNB VPB VPWR Y
.ends

* Black-box entry subcircuit for sky130_fd_sc_hd__mux4_2 abstract view
.subckt sky130_fd_sc_hd__mux4_2 A0 A1 A2 A3 S0 S1 VGND VNB VPB VPWR X
.ends

* Black-box entry subcircuit for sky130_fd_sc_hd__buf_4 abstract view
.subckt sky130_fd_sc_hd__buf_4 A VGND VNB VPB VPWR X
.ends

* Black-box entry subcircuit for sky130_fd_sc_hd__a31o_1 abstract view
.subckt sky130_fd_sc_hd__a31o_1 A1 A2 A3 B1 VGND VNB VPB VPWR X
.ends

* Black-box entry subcircuit for sky130_fd_sc_hd__inv_8 abstract view
.subckt sky130_fd_sc_hd__inv_8 A VGND VNB VPB VPWR Y
.ends

* Black-box entry subcircuit for sky130_fd_sc_hd__buf_6 abstract view
.subckt sky130_fd_sc_hd__buf_6 A VGND VNB VPB VPWR X
.ends

* Black-box entry subcircuit for sky130_fd_sc_hd__nand2_2 abstract view
.subckt sky130_fd_sc_hd__nand2_2 A B VGND VNB VPB VPWR Y
.ends

* Black-box entry subcircuit for sky130_fd_sc_hd__o21a_1 abstract view
.subckt sky130_fd_sc_hd__o21a_1 A1 A2 B1 VGND VNB VPB VPWR X
.ends

* Black-box entry subcircuit for sky130_fd_sc_hd__inv_2 abstract view
.subckt sky130_fd_sc_hd__inv_2 A VGND VNB VPB VPWR Y
.ends

* Black-box entry subcircuit for sky130_fd_sc_hd__or2_1 abstract view
.subckt sky130_fd_sc_hd__or2_1 A B VGND VNB VPB VPWR X
.ends

* Black-box entry subcircuit for sky130_fd_sc_hd__a21oi_1 abstract view
.subckt sky130_fd_sc_hd__a21oi_1 A1 A2 B1 VGND VNB VPB VPWR Y
.ends

* Black-box entry subcircuit for sky130_fd_sc_hd__diode_2 abstract view
.subckt sky130_fd_sc_hd__diode_2 DIODE VGND VNB VPB VPWR
.ends

* Black-box entry subcircuit for sky130_fd_sc_hd__o21ba_1 abstract view
.subckt sky130_fd_sc_hd__o21ba_1 A1 A2 B1_N VGND VNB VPB VPWR X
.ends

* Black-box entry subcircuit for sky130_fd_sc_hd__o31ai_1 abstract view
.subckt sky130_fd_sc_hd__o31ai_1 A1 A2 A3 B1 VGND VNB VPB VPWR Y
.ends

* Black-box entry subcircuit for sky130_fd_sc_hd__xnor2_1 abstract view
.subckt sky130_fd_sc_hd__xnor2_1 A B VGND VNB VPB VPWR Y
.ends

* Black-box entry subcircuit for sky130_fd_sc_hd__a31o_4 abstract view
.subckt sky130_fd_sc_hd__a31o_4 A1 A2 A3 B1 VGND VNB VPB VPWR X
.ends

* Black-box entry subcircuit for sky130_fd_sc_hd__a21oi_2 abstract view
.subckt sky130_fd_sc_hd__a21oi_2 A1 A2 B1 VGND VNB VPB VPWR Y
.ends

* Black-box entry subcircuit for sky130_fd_sc_hd__o221a_1 abstract view
.subckt sky130_fd_sc_hd__o221a_1 A1 A2 B1 B2 C1 VGND VNB VPB VPWR X
.ends

* Black-box entry subcircuit for sky130_fd_sc_hd__a211o_1 abstract view
.subckt sky130_fd_sc_hd__a211o_1 A1 A2 B1 C1 VGND VNB VPB VPWR X
.ends

* Black-box entry subcircuit for sky130_fd_sc_hd__dlymetal6s2s_1 abstract view
.subckt sky130_fd_sc_hd__dlymetal6s2s_1 A VGND VNB VPB VPWR X
.ends

* Black-box entry subcircuit for sky130_fd_sc_hd__xnor2_2 abstract view
.subckt sky130_fd_sc_hd__xnor2_2 A B VGND VNB VPB VPWR Y
.ends

* Black-box entry subcircuit for sky130_fd_sc_hd__and2_1 abstract view
.subckt sky130_fd_sc_hd__and2_1 A B VGND VNB VPB VPWR X
.ends

* Black-box entry subcircuit for sky130_fd_sc_hd__clkinv_4 abstract view
.subckt sky130_fd_sc_hd__clkinv_4 A VGND VNB VPB VPWR Y
.ends

* Black-box entry subcircuit for sky130_fd_sc_hd__a32oi_4 abstract view
.subckt sky130_fd_sc_hd__a32oi_4 A1 A2 A3 B1 B2 VGND VNB VPB VPWR Y
.ends

* Black-box entry subcircuit for sky130_fd_sc_hd__o21ai_4 abstract view
.subckt sky130_fd_sc_hd__o21ai_4 A1 A2 B1 VGND VNB VPB VPWR Y
.ends

* Black-box entry subcircuit for sky130_fd_sc_hd__nand4b_4 abstract view
.subckt sky130_fd_sc_hd__nand4b_4 A_N B C D VGND VNB VPB VPWR Y
.ends

* Black-box entry subcircuit for sky130_fd_sc_hd__or2b_1 abstract view
.subckt sky130_fd_sc_hd__or2b_1 A B_N VGND VNB VPB VPWR X
.ends

* Black-box entry subcircuit for sky130_fd_sc_hd__or3_4 abstract view
.subckt sky130_fd_sc_hd__or3_4 A B C VGND VNB VPB VPWR X
.ends

* Black-box entry subcircuit for sky130_fd_sc_hd__o211a_1 abstract view
.subckt sky130_fd_sc_hd__o211a_1 A1 A2 B1 C1 VGND VNB VPB VPWR X
.ends

* Black-box entry subcircuit for sky130_fd_sc_hd__xor2_2 abstract view
.subckt sky130_fd_sc_hd__xor2_2 A B VGND VNB VPB VPWR X
.ends

* Black-box entry subcircuit for sky130_fd_sc_hd__buf_12 abstract view
.subckt sky130_fd_sc_hd__buf_12 A VGND VNB VPB VPWR X
.ends

* Black-box entry subcircuit for sky130_fd_sc_hd__or4_4 abstract view
.subckt sky130_fd_sc_hd__or4_4 A B C D VGND VNB VPB VPWR X
.ends

* Black-box entry subcircuit for sky130_fd_sc_hd__clkbuf_16 abstract view
.subckt sky130_fd_sc_hd__clkbuf_16 A VGND VNB VPB VPWR X
.ends

* Black-box entry subcircuit for sky130_fd_sc_hd__a221oi_4 abstract view
.subckt sky130_fd_sc_hd__a221oi_4 A1 A2 B1 B2 C1 VGND VNB VPB VPWR Y
.ends

* Black-box entry subcircuit for sky130_fd_sc_hd__inv_4 abstract view
.subckt sky130_fd_sc_hd__inv_4 A VGND VNB VPB VPWR Y
.ends

* Black-box entry subcircuit for sky130_fd_sc_hd__inv_6 abstract view
.subckt sky130_fd_sc_hd__inv_6 A VGND VNB VPB VPWR Y
.ends

* Black-box entry subcircuit for sky130_fd_sc_hd__clkinvlp_2 abstract view
.subckt sky130_fd_sc_hd__clkinvlp_2 A VGND VNB VPB VPWR Y
.ends

* Black-box entry subcircuit for sky130_fd_sc_hd__a21bo_1 abstract view
.subckt sky130_fd_sc_hd__a21bo_1 A1 A2 B1_N VGND VNB VPB VPWR X
.ends

* Black-box entry subcircuit for sky130_fd_sc_hd__or3b_4 abstract view
.subckt sky130_fd_sc_hd__or3b_4 A B C_N VGND VNB VPB VPWR X
.ends

* Black-box entry subcircuit for sky130_fd_sc_hd__a2bb2o_1 abstract view
.subckt sky130_fd_sc_hd__a2bb2o_1 A1_N A2_N B1 B2 VGND VNB VPB VPWR X
.ends

* Black-box entry subcircuit for sky130_fd_sc_hd__xor2_1 abstract view
.subckt sky130_fd_sc_hd__xor2_1 A B VGND VNB VPB VPWR X
.ends

* Black-box entry subcircuit for sky130_fd_sc_hd__a21oi_4 abstract view
.subckt sky130_fd_sc_hd__a21oi_4 A1 A2 B1 VGND VNB VPB VPWR Y
.ends

* Black-box entry subcircuit for sky130_fd_sc_hd__o22a_1 abstract view
.subckt sky130_fd_sc_hd__o22a_1 A1 A2 B1 B2 VGND VNB VPB VPWR X
.ends

* Black-box entry subcircuit for sky130_fd_sc_hd__bufinv_16 abstract view
.subckt sky130_fd_sc_hd__bufinv_16 A VGND VNB VPB VPWR Y
.ends

* Black-box entry subcircuit for sky130_fd_sc_hd__clkinvlp_4 abstract view
.subckt sky130_fd_sc_hd__clkinvlp_4 A VGND VNB VPB VPWR Y
.ends

* Black-box entry subcircuit for sky130_fd_sc_hd__nand2_4 abstract view
.subckt sky130_fd_sc_hd__nand2_4 A B VGND VNB VPB VPWR Y
.ends

* Black-box entry subcircuit for sky130_fd_sc_hd__and4b_2 abstract view
.subckt sky130_fd_sc_hd__and4b_2 A_N B C D VGND VNB VPB VPWR X
.ends

* Black-box entry subcircuit for sky130_fd_sc_hd__a22o_1 abstract view
.subckt sky130_fd_sc_hd__a22o_1 A1 A2 B1 B2 VGND VNB VPB VPWR X
.ends

* Black-box entry subcircuit for sky130_fd_sc_hd__nor2_4 abstract view
.subckt sky130_fd_sc_hd__nor2_4 A B VGND VNB VPB VPWR Y
.ends

* Black-box entry subcircuit for sky130_fd_sc_hd__o22a_4 abstract view
.subckt sky130_fd_sc_hd__o22a_4 A1 A2 B1 B2 VGND VNB VPB VPWR X
.ends

* Black-box entry subcircuit for sky130_fd_sc_hd__mux2_2 abstract view
.subckt sky130_fd_sc_hd__mux2_2 A0 A1 S VGND VNB VPB VPWR X
.ends

* Black-box entry subcircuit for sky130_fd_sc_hd__a221o_1 abstract view
.subckt sky130_fd_sc_hd__a221o_1 A1 A2 B1 B2 C1 VGND VNB VPB VPWR X
.ends

* Black-box entry subcircuit for sky130_fd_sc_hd__and2b_1 abstract view
.subckt sky130_fd_sc_hd__and2b_1 A_N B VGND VNB VPB VPWR X
.ends

* Black-box entry subcircuit for sky130_fd_sc_hd__clkinv_8 abstract view
.subckt sky130_fd_sc_hd__clkinv_8 A VGND VNB VPB VPWR Y
.ends

* Black-box entry subcircuit for sky130_fd_sc_hd__or4bb_4 abstract view
.subckt sky130_fd_sc_hd__or4bb_4 A B C_N D_N VGND VNB VPB VPWR X
.ends

* Black-box entry subcircuit for sky130_fd_sc_hd__and3b_1 abstract view
.subckt sky130_fd_sc_hd__and3b_1 A_N B C VGND VNB VPB VPWR X
.ends

* Black-box entry subcircuit for sky130_fd_sc_hd__or3_1 abstract view
.subckt sky130_fd_sc_hd__or3_1 A B C VGND VNB VPB VPWR X
.ends

* Black-box entry subcircuit for sky130_fd_sc_hd__o32a_1 abstract view
.subckt sky130_fd_sc_hd__o32a_1 A1 A2 A3 B1 B2 VGND VNB VPB VPWR X
.ends

* Black-box entry subcircuit for sky130_fd_sc_hd__o21a_2 abstract view
.subckt sky130_fd_sc_hd__o21a_2 A1 A2 B1 VGND VNB VPB VPWR X
.ends

* Black-box entry subcircuit for sky130_fd_sc_hd__or2_2 abstract view
.subckt sky130_fd_sc_hd__or2_2 A B VGND VNB VPB VPWR X
.ends

* Black-box entry subcircuit for sky130_fd_sc_hd__nor4_4 abstract view
.subckt sky130_fd_sc_hd__nor4_4 A B C D VGND VNB VPB VPWR Y
.ends

* Black-box entry subcircuit for sky130_fd_sc_hd__o2bb2a_1 abstract view
.subckt sky130_fd_sc_hd__o2bb2a_1 A1_N A2_N B1 B2 VGND VNB VPB VPWR X
.ends

* Black-box entry subcircuit for sky130_fd_sc_hd__a21boi_2 abstract view
.subckt sky130_fd_sc_hd__a21boi_2 A1 A2 B1_N VGND VNB VPB VPWR Y
.ends

* Black-box entry subcircuit for sky130_fd_sc_hd__clkinv_1 abstract view
.subckt sky130_fd_sc_hd__clkinv_1 A VGND VNB VPB VPWR Y
.ends

* Black-box entry subcircuit for sky130_fd_sc_hd__o311a_1 abstract view
.subckt sky130_fd_sc_hd__o311a_1 A1 A2 A3 B1 C1 VGND VNB VPB VPWR X
.ends

* Black-box entry subcircuit for sky130_fd_sc_hd__o2bb2a_4 abstract view
.subckt sky130_fd_sc_hd__o2bb2a_4 A1_N A2_N B1 B2 VGND VNB VPB VPWR X
.ends

* Black-box entry subcircuit for sky130_fd_sc_hd__nand3_1 abstract view
.subckt sky130_fd_sc_hd__nand3_1 A B C VGND VNB VPB VPWR Y
.ends

* Black-box entry subcircuit for sky130_fd_sc_hd__nor2_2 abstract view
.subckt sky130_fd_sc_hd__nor2_2 A B VGND VNB VPB VPWR Y
.ends

* Black-box entry subcircuit for sky130_fd_sc_hd__o22ai_1 abstract view
.subckt sky130_fd_sc_hd__o22ai_1 A1 A2 B1 B2 VGND VNB VPB VPWR Y
.ends

* Black-box entry subcircuit for sky130_fd_sc_hd__a2bb2o_2 abstract view
.subckt sky130_fd_sc_hd__a2bb2o_2 A1_N A2_N B1 B2 VGND VNB VPB VPWR X
.ends

* Black-box entry subcircuit for sky130_fd_sc_hd__a211oi_1 abstract view
.subckt sky130_fd_sc_hd__a211oi_1 A1 A2 B1 C1 VGND VNB VPB VPWR Y
.ends

* Black-box entry subcircuit for sky130_fd_sc_hd__o41a_1 abstract view
.subckt sky130_fd_sc_hd__o41a_1 A1 A2 A3 A4 B1 VGND VNB VPB VPWR X
.ends

* Black-box entry subcircuit for sky130_fd_sc_hd__nor3b_4 abstract view
.subckt sky130_fd_sc_hd__nor3b_4 A B C_N VGND VNB VPB VPWR Y
.ends

* Black-box entry subcircuit for sky130_fd_sc_hd__a2bb2o_4 abstract view
.subckt sky130_fd_sc_hd__a2bb2o_4 A1_N A2_N B1 B2 VGND VNB VPB VPWR X
.ends

* Black-box entry subcircuit for sky130_fd_sc_hd__o21bai_1 abstract view
.subckt sky130_fd_sc_hd__o21bai_1 A1 A2 B1_N VGND VNB VPB VPWR Y
.ends

* Black-box entry subcircuit for sky130_fd_sc_hd__o21ai_2 abstract view
.subckt sky130_fd_sc_hd__o21ai_2 A1 A2 B1 VGND VNB VPB VPWR Y
.ends

* Black-box entry subcircuit for sky130_fd_sc_hd__buf_1 abstract view
.subckt sky130_fd_sc_hd__buf_1 A VGND VNB VPB VPWR X
.ends

* Black-box entry subcircuit for sky130_fd_sc_hd__o221ai_2 abstract view
.subckt sky130_fd_sc_hd__o221ai_2 A1 A2 B1 B2 C1 VGND VNB VPB VPWR Y
.ends

* Black-box entry subcircuit for sky130_fd_sc_hd__and3_1 abstract view
.subckt sky130_fd_sc_hd__and3_1 A B C VGND VNB VPB VPWR X
.ends

* Black-box entry subcircuit for sky130_fd_sc_hd__o311ai_4 abstract view
.subckt sky130_fd_sc_hd__o311ai_4 A1 A2 A3 B1 C1 VGND VNB VPB VPWR Y
.ends

* Black-box entry subcircuit for sky130_fd_sc_hd__nor2b_4 abstract view
.subckt sky130_fd_sc_hd__nor2b_4 A B_N VGND VNB VPB VPWR Y
.ends

* Black-box entry subcircuit for sky130_fd_sc_hd__and3_4 abstract view
.subckt sky130_fd_sc_hd__and3_4 A B C VGND VNB VPB VPWR X
.ends

* Black-box entry subcircuit for sky130_fd_sc_hd__o31a_1 abstract view
.subckt sky130_fd_sc_hd__o31a_1 A1 A2 A3 B1 VGND VNB VPB VPWR X
.ends

* Black-box entry subcircuit for sky130_fd_sc_hd__nand2b_4 abstract view
.subckt sky130_fd_sc_hd__nand2b_4 A_N B VGND VNB VPB VPWR Y
.ends

* Black-box entry subcircuit for sky130_fd_sc_hd__and2_2 abstract view
.subckt sky130_fd_sc_hd__and2_2 A B VGND VNB VPB VPWR X
.ends

* Black-box entry subcircuit for sky130_fd_sc_hd__and4b_1 abstract view
.subckt sky130_fd_sc_hd__and4b_1 A_N B C D VGND VNB VPB VPWR X
.ends

* Black-box entry subcircuit for sky130_fd_sc_hd__nand3_4 abstract view
.subckt sky130_fd_sc_hd__nand3_4 A B C VGND VNB VPB VPWR Y
.ends

* Black-box entry subcircuit for sky130_fd_sc_hd__a41o_1 abstract view
.subckt sky130_fd_sc_hd__a41o_1 A1 A2 A3 A4 B1 VGND VNB VPB VPWR X
.ends

* Black-box entry subcircuit for sky130_fd_sc_hd__and4_1 abstract view
.subckt sky130_fd_sc_hd__and4_1 A B C D VGND VNB VPB VPWR X
.ends

* Black-box entry subcircuit for sky130_fd_sc_hd__buf_8 abstract view
.subckt sky130_fd_sc_hd__buf_8 A VGND VNB VPB VPWR X
.ends

* Black-box entry subcircuit for sky130_fd_sc_hd__nand4_1 abstract view
.subckt sky130_fd_sc_hd__nand4_1 A B C D VGND VNB VPB VPWR Y
.ends

* Black-box entry subcircuit for sky130_fd_sc_hd__nand3_2 abstract view
.subckt sky130_fd_sc_hd__nand3_2 A B C VGND VNB VPB VPWR Y
.ends

* Black-box entry subcircuit for sky130_fd_sc_hd__or2b_2 abstract view
.subckt sky130_fd_sc_hd__or2b_2 A B_N VGND VNB VPB VPWR X
.ends

* Black-box entry subcircuit for sky130_fd_sc_hd__a22o_4 abstract view
.subckt sky130_fd_sc_hd__a22o_4 A1 A2 B1 B2 VGND VNB VPB VPWR X
.ends

* Black-box entry subcircuit for sky130_fd_sc_hd__o21bai_2 abstract view
.subckt sky130_fd_sc_hd__o21bai_2 A1 A2 B1_N VGND VNB VPB VPWR Y
.ends

* Black-box entry subcircuit for sky130_fd_sc_hd__a32o_1 abstract view
.subckt sky130_fd_sc_hd__a32o_1 A1 A2 A3 B1 B2 VGND VNB VPB VPWR X
.ends

* Black-box entry subcircuit for sky130_fd_sc_hd__a311o_1 abstract view
.subckt sky130_fd_sc_hd__a311o_1 A1 A2 A3 B1 C1 VGND VNB VPB VPWR X
.ends

* Black-box entry subcircuit for sky130_fd_sc_hd__and2_4 abstract view
.subckt sky130_fd_sc_hd__and2_4 A B VGND VNB VPB VPWR X
.ends

* Black-box entry subcircuit for sky130_fd_sc_hd__nand4b_1 abstract view
.subckt sky130_fd_sc_hd__nand4b_1 A_N B C D VGND VNB VPB VPWR Y
.ends

* Black-box entry subcircuit for sky130_fd_sc_hd__or3b_2 abstract view
.subckt sky130_fd_sc_hd__or3b_2 A B C_N VGND VNB VPB VPWR X
.ends

* Black-box entry subcircuit for sky130_fd_sc_hd__and3_2 abstract view
.subckt sky130_fd_sc_hd__and3_2 A B C VGND VNB VPB VPWR X
.ends

* Black-box entry subcircuit for sky130_fd_sc_hd__a32o_4 abstract view
.subckt sky130_fd_sc_hd__a32o_4 A1 A2 A3 B1 B2 VGND VNB VPB VPWR X
.ends

* Black-box entry subcircuit for sky130_fd_sc_hd__or3b_1 abstract view
.subckt sky130_fd_sc_hd__or3b_1 A B C_N VGND VNB VPB VPWR X
.ends

* Black-box entry subcircuit for sky130_fd_sc_hd__nor3_1 abstract view
.subckt sky130_fd_sc_hd__nor3_1 A B C VGND VNB VPB VPWR Y
.ends

* Black-box entry subcircuit for sky130_fd_sc_hd__or4b_4 abstract view
.subckt sky130_fd_sc_hd__or4b_4 A B C D_N VGND VNB VPB VPWR X
.ends

.subckt top A1[0] A1[1] A1[2] A1[3] A1[4] A2[0] A2[1] A2[2] A2[3] A2[4] A3[0] A3[1]
+ A3[2] A3[3] A3[4] CLK VGND VPWR WD3[0] WD3[10] WD3[11] WD3[12] WD3[13] WD3[14] WD3[15]
+ WD3[16] WD3[17] WD3[18] WD3[19] WD3[1] WD3[20] WD3[21] WD3[22] WD3[23] WD3[24] WD3[25]
+ WD3[26] WD3[27] WD3[28] WD3[29] WD3[2] WD3[30] WD3[31] WD3[3] WD3[4] WD3[5] WD3[6]
+ WD3[7] WD3[8] WD3[9] WE3 opcode[0] opcode[1] result[0] result[10] result[11] result[12]
+ result[13] result[14] result[15] result[16] result[17] result[18] result[19] result[1]
+ result[20] result[21] result[22] result[23] result[24] result[25] result[26] result[27]
+ result[28] result[29] result[2] result[30] result[31] result[3] result[4] result[5]
+ result[6] result[7] result[8] result[9]
X_7963_ _3950_ VGND VGND VPWR VPWR _0504_ sky130_fd_sc_hd__clkbuf_1
X_6914_ net34 VGND VGND VPWR VPWR _3379_ sky130_fd_sc_hd__buf_2
X_7894_ _3111_ net900 _3908_ VGND VGND VPWR VPWR _3914_ sky130_fd_sc_hd__mux2_1
XFILLER_0_77_634 VGND VGND VPWR VPWR sky130_fd_sc_hd__fill_1
XFILLER_0_92_615 VPWR VGND VPWR VGND sky130_ef_sc_hd__decap_12
XTAP_TAPCELL_ROW_81_1226 VGND VPWR sky130_fd_sc_hd__tapvpwrvgnd_1
X_6845_ net237 _2990_ _3306_ VGND VGND VPWR VPWR _3340_ sky130_fd_sc_hd__mux2_1
X_6776_ _3121_ net832 _3269_ VGND VGND VPWR VPWR _3303_ sky130_fd_sc_hd__mux2_1
XTAP_TAPCELL_ROW_61_982 VGND VPWR sky130_fd_sc_hd__tapvpwrvgnd_1
XTAP_TAPCELL_ROW_33_651 VGND VPWR sky130_fd_sc_hd__tapvpwrvgnd_1
XFILLER_0_45_531 VGND VGND VPWR VPWR sky130_fd_sc_hd__fill_2
XFILLER_0_57_391 VGND VGND VPWR VPWR sky130_fd_sc_hd__fill_1
X_5727_ _2400_ _2376_ _2198_ VGND VGND VPWR VPWR _2511_ sky130_fd_sc_hd__mux2_1
X_9495_ clknet_leaf_39_CLK _0728_ VGND VGND VPWR VPWR RF.reg_arr\[11\]\[25\] sky130_fd_sc_hd__dfxtp_1
X_8515_ clknet_leaf_80_CLK _0772_ VGND VGND VPWR VPWR RF.reg_arr\[1\]\[5\] sky130_fd_sc_hd__dfxtp_1
X_8446_ net191 net35 _4196_ VGND VGND VPWR VPWR _4206_ sky130_fd_sc_hd__mux2_1
XPHY_EDGE_ROW_107_Left_224 VGND VGND VPWR VPWR sky130_fd_sc_hd__decap_3
X_5658_ _1024_ VGND VGND VPWR VPWR _2445_ sky130_fd_sc_hd__buf_2
XFILLER_0_60_545 VGND VGND VPWR VPWR sky130_fd_sc_hd__decap_6
X_8377_ _4169_ VGND VGND VPWR VPWR _0699_ sky130_fd_sc_hd__clkbuf_1
X_5589_ _2198_ _2376_ VGND VGND VPWR VPWR _2377_ sky130_fd_sc_hd__nor2_1
XTAP_TAPCELL_ROW_79_1199 VGND VPWR sky130_fd_sc_hd__tapvpwrvgnd_1
X_4609_ RF.reg_arr\[0\]\[6\] RF.reg_arr\[1\]\[6\] RF.reg_arr\[2\]\[6\] RF.reg_arr\[3\]\[6\]
+ _1044_ _1046_ VGND VGND VPWR VPWR _1398_ sky130_fd_sc_hd__mux4_1
XFILLER_0_32_269 VGND VGND VPWR VPWR sky130_fd_sc_hd__fill_2
Xhold351 RF.reg_arr\[17\]\[20\] VGND VGND VPWR VPWR net433 sky130_fd_sc_hd__dlygate4sd3_1
Xhold362 RF.reg_arr\[31\]\[15\] VGND VGND VPWR VPWR net444 sky130_fd_sc_hd__dlygate4sd3_1
Xhold340 RF.reg_arr\[7\]\[13\] VGND VGND VPWR VPWR net422 sky130_fd_sc_hd__dlygate4sd3_1
X_7328_ _3612_ VGND VGND VPWR VPWR _0207_ sky130_fd_sc_hd__clkbuf_1
Xhold373 RF.reg_arr\[30\]\[24\] VGND VGND VPWR VPWR net455 sky130_fd_sc_hd__dlygate4sd3_1
XFILLER_0_111_691 VGND VGND VPWR VPWR sky130_fd_sc_hd__fill_1
XTAP_TAPCELL_ROW_92_1355 VGND VPWR sky130_fd_sc_hd__tapvpwrvgnd_1
Xhold384 RF.reg_arr\[22\]\[2\] VGND VGND VPWR VPWR net466 sky130_fd_sc_hd__dlygate4sd3_1
Xhold395 RF.reg_arr\[16\]\[8\] VGND VGND VPWR VPWR net477 sky130_fd_sc_hd__dlygate4sd3_1
X_7259_ _3092_ net542 _3569_ VGND VGND VPWR VPWR _3576_ sky130_fd_sc_hd__mux2_1
XFILLER_0_110_190 VGND VGND VPWR VPWR sky130_fd_sc_hd__decap_6
XTAP_TAPCELL_ROW_5_310 VGND VPWR sky130_fd_sc_hd__tapvpwrvgnd_1
Xhold1040 RF.reg_arr\[15\]\[18\] VGND VGND VPWR VPWR net1122 sky130_fd_sc_hd__dlygate4sd3_1
XPHY_EDGE_ROW_116_Left_233 VGND VGND VPWR VPWR sky130_fd_sc_hd__decap_3
XFILLER_0_99_258 VGND VGND VPWR VPWR sky130_fd_sc_hd__fill_1
XFILLER_0_67_166 VGND VGND VPWR VPWR sky130_fd_sc_hd__fill_2
XTAP_TAPCELL_ROW_101_1462 VGND VPWR sky130_fd_sc_hd__tapvpwrvgnd_1
Xrebuffer7 _2533_ VGND VGND VPWR VPWR net89 sky130_fd_sc_hd__dlygate4sd1_1
XTAP_TAPCELL_ROW_11_389 VGND VPWR sky130_fd_sc_hd__tapvpwrvgnd_1
XTAP_TAPCELL_ROW_11_378 VGND VPWR sky130_fd_sc_hd__tapvpwrvgnd_1
XFILLER_0_102_691 VGND VGND VPWR VPWR sky130_fd_sc_hd__fill_1
XFILLER_0_48_26 VGND VGND VPWR VPWR sky130_fd_sc_hd__fill_2
XTAP_TAPCELL_ROW_112_1591 VGND VPWR sky130_fd_sc_hd__tapvpwrvgnd_1
XFILLER_0_3_39 VGND VGND VPWR VPWR sky130_fd_sc_hd__decap_6
Xclkbuf_leaf_6_CLK clknet_3_0__leaf_CLK VGND VGND VPWR VPWR clknet_leaf_6_CLK sky130_fd_sc_hd__clkbuf_8
XFILLER_0_59_612 VGND VGND VPWR VPWR sky130_fd_sc_hd__fill_1
X_4960_ RF.reg_arr\[4\]\[26\] RF.reg_arr\[5\]\[26\] RF.reg_arr\[6\]\[26\] RF.reg_arr\[7\]\[26\]
+ _1626_ _1628_ VGND VGND VPWR VPWR _1749_ sky130_fd_sc_hd__mux4_1
XTAP_TAPCELL_ROW_19_478 VGND VPWR sky130_fd_sc_hd__tapvpwrvgnd_1
XFILLER_0_74_615 VGND VGND VPWR VPWR sky130_fd_sc_hd__decap_8
XFILLER_0_59_667 VGND VGND VPWR VPWR sky130_fd_sc_hd__fill_2
X_4891_ _1679_ VGND VGND VPWR VPWR _1680_ sky130_fd_sc_hd__clkbuf_4
X_6630_ net532 _2982_ _3218_ VGND VGND VPWR VPWR _3225_ sky130_fd_sc_hd__mux2_1
XFILLER_0_46_317 VGND VGND VPWR VPWR sky130_fd_sc_hd__fill_1
X_6561_ _3188_ VGND VGND VPWR VPWR _0888_ sky130_fd_sc_hd__clkbuf_1
XFILLER_0_73_169 VGND VGND VPWR VPWR sky130_fd_sc_hd__fill_1
XTAP_TAPCELL_ROW_30_610 VGND VPWR sky130_fd_sc_hd__tapvpwrvgnd_1
XFILLER_0_39_391 VGND VGND VPWR VPWR sky130_fd_sc_hd__fill_1
X_8300_ net225 _3371_ _4124_ VGND VGND VPWR VPWR _4129_ sky130_fd_sc_hd__mux2_1
X_5512_ RF.reg_arr\[8\]\[2\] RF.reg_arr\[9\]\[2\] RF.reg_arr\[10\]\[2\] RF.reg_arr\[11\]\[2\]
+ _1674_ _1680_ VGND VGND VPWR VPWR _2301_ sky130_fd_sc_hd__mux4_1
X_6492_ net103 VGND VGND VPWR VPWR _3151_ sky130_fd_sc_hd__clkbuf_1
X_9280_ clknet_leaf_69_CLK _0513_ VGND VGND VPWR VPWR RF.reg_arr\[25\]\[2\] sky130_fd_sc_hd__dfxtp_1
X_8231_ _4092_ VGND VGND VPWR VPWR _0630_ sky130_fd_sc_hd__clkbuf_1
X_5443_ _1864_ _2231_ _1844_ VGND VGND VPWR VPWR _2232_ sky130_fd_sc_hd__a21o_1
X_8162_ net348 _3437_ _4052_ VGND VGND VPWR VPWR _4056_ sky130_fd_sc_hd__mux2_1
X_5374_ RF.reg_arr\[28\]\[12\] RF.reg_arr\[29\]\[12\] RF.reg_arr\[30\]\[12\] RF.reg_arr\[31\]\[12\]
+ _1622_ _1595_ VGND VGND VPWR VPWR _2163_ sky130_fd_sc_hd__mux4_1
XFILLER_0_22_280 VGND VGND VPWR VPWR sky130_fd_sc_hd__fill_2
X_4325_ _1113_ VGND VGND VPWR VPWR _1114_ sky130_fd_sc_hd__clkbuf_2
X_7113_ _3498_ VGND VGND VPWR VPWR _0106_ sky130_fd_sc_hd__clkbuf_1
X_8093_ _4019_ VGND VGND VPWR VPWR _0565_ sky130_fd_sc_hd__clkbuf_1
X_7044_ net495 _3412_ _3460_ VGND VGND VPWR VPWR _3462_ sky130_fd_sc_hd__mux2_1
X_4256_ A2[1] VGND VGND VPWR VPWR _1045_ sky130_fd_sc_hd__clkbuf_4
XTAP_TAPCELL_ROW_38_710 VGND VPWR sky130_fd_sc_hd__tapvpwrvgnd_1
X_8995_ clknet_leaf_74_CLK _0228_ VGND VGND VPWR VPWR RF.reg_arr\[27\]\[5\] sky130_fd_sc_hd__dfxtp_1
XFILLER_0_77_442 VGND VGND VPWR VPWR sky130_fd_sc_hd__decap_6
X_7946_ _3941_ VGND VGND VPWR VPWR _0496_ sky130_fd_sc_hd__clkbuf_1
XFILLER_0_65_615 VGND VGND VPWR VPWR sky130_fd_sc_hd__fill_1
X_7877_ _3094_ net1113 _3897_ VGND VGND VPWR VPWR _3905_ sky130_fd_sc_hd__mux2_1
XFILLER_0_37_306 VGND VGND VPWR VPWR sky130_fd_sc_hd__fill_2
X_6828_ _3331_ VGND VGND VPWR VPWR _1012_ sky130_fd_sc_hd__clkbuf_1
XFILLER_0_49_177 VGND VGND VPWR VPWR sky130_fd_sc_hd__fill_1
XFILLER_0_92_467 VGND VGND VPWR VPWR sky130_fd_sc_hd__fill_1
XFILLER_0_52_309 VGND VGND VPWR VPWR sky130_fd_sc_hd__fill_2
XFILLER_0_92_489 VGND VGND VPWR VPWR sky130_fd_sc_hd__fill_2
X_6759_ _3294_ VGND VGND VPWR VPWR _0980_ sky130_fd_sc_hd__clkbuf_1
XFILLER_0_80_629 VGND VGND VPWR VPWR sky130_fd_sc_hd__fill_1
XFILLER_0_33_512 VPWR VGND VPWR VGND sky130_ef_sc_hd__decap_12
X_9478_ clknet_leaf_86_CLK _0711_ VGND VGND VPWR VPWR RF.reg_arr\[11\]\[8\] sky130_fd_sc_hd__dfxtp_1
X_8429_ _4197_ VGND VGND VPWR VPWR _0723_ sky130_fd_sc_hd__clkbuf_1
Xhold170 RF.reg_arr\[3\]\[31\] VGND VGND VPWR VPWR net252 sky130_fd_sc_hd__dlygate4sd3_1
Xhold181 RF.reg_arr\[5\]\[21\] VGND VGND VPWR VPWR net263 sky130_fd_sc_hd__dlygate4sd3_1
Xhold192 RF.reg_arr\[12\]\[18\] VGND VGND VPWR VPWR net274 sky130_fd_sc_hd__dlygate4sd3_1
XFILLER_0_18_29 VGND VGND VPWR VPWR sky130_fd_sc_hd__fill_2
XFILLER_0_87_206 VGND VGND VPWR VPWR sky130_fd_sc_hd__decap_4
XTAP_TAPCELL_ROW_16_448 VGND VPWR sky130_fd_sc_hd__tapvpwrvgnd_1
XTAP_TAPCELL_ROW_44_779 VGND VPWR sky130_fd_sc_hd__tapvpwrvgnd_1
XFILLER_0_50_27 VGND VGND VPWR VPWR sky130_fd_sc_hd__fill_1
XFILLER_0_36_361 VGND VGND VPWR VPWR sky130_fd_sc_hd__decap_3
XFILLER_0_63_191 VGND VGND VPWR VPWR sky130_fd_sc_hd__fill_2
XTAP_TAPCELL_ROW_114_1620 VGND VPWR sky130_fd_sc_hd__tapvpwrvgnd_1
X_5090_ RF.reg_arr\[4\]\[23\] RF.reg_arr\[5\]\[23\] RF.reg_arr\[6\]\[23\] RF.reg_arr\[7\]\[23\]
+ _1591_ _1878_ VGND VGND VPWR VPWR _1879_ sky130_fd_sc_hd__mux4_1
XFILLER_0_75_13 VGND VGND VPWR VPWR sky130_fd_sc_hd__fill_2
XFILLER_0_78_217 VGND VGND VPWR VPWR sky130_fd_sc_hd__fill_2
X_5992_ _1997_ _2740_ VGND VGND VPWR VPWR _2763_ sky130_fd_sc_hd__nand2_1
X_8780_ clknet_leaf_95_CLK _0013_ VGND VGND VPWR VPWR RF.reg_arr\[5\]\[14\] sky130_fd_sc_hd__dfxtp_1
X_7800_ _3086_ net506 _3860_ VGND VGND VPWR VPWR _3864_ sky130_fd_sc_hd__mux2_1
XTAP_TAPCELL_ROW_65_1029 VGND VPWR sky130_fd_sc_hd__tapvpwrvgnd_1
X_7731_ _3827_ VGND VGND VPWR VPWR _0395_ sky130_fd_sc_hd__clkbuf_1
X_4943_ RF.reg_arr\[8\]\[1\] RF.reg_arr\[9\]\[1\] RF.reg_arr\[10\]\[1\] RF.reg_arr\[11\]\[1\]
+ _1262_ _1045_ VGND VGND VPWR VPWR _1732_ sky130_fd_sc_hd__mux4_1
XFILLER_0_74_401 VGND VGND VPWR VPWR sky130_fd_sc_hd__decap_3
X_7662_ _3084_ net1026 _3788_ VGND VGND VPWR VPWR _3791_ sky130_fd_sc_hd__mux2_1
XFILLER_0_24_72 VGND VGND VPWR VPWR sky130_fd_sc_hd__fill_2
X_9401_ clknet_leaf_36_CLK _0634_ VGND VGND VPWR VPWR RF.reg_arr\[13\]\[27\] sky130_fd_sc_hd__dfxtp_1
X_4874_ _1587_ _1654_ _1658_ _1662_ VGND VGND VPWR VPWR _1663_ sky130_fd_sc_hd__o2bb2a_2
X_6613_ net487 _3035_ _3207_ VGND VGND VPWR VPWR _3216_ sky130_fd_sc_hd__mux2_1
XFILLER_0_6_211 VGND VGND VPWR VPWR sky130_fd_sc_hd__decap_4
XFILLER_0_15_501 VGND VGND VPWR VPWR sky130_fd_sc_hd__decap_3
XFILLER_0_27_372 VGND VGND VPWR VPWR sky130_fd_sc_hd__decap_3
X_7593_ _3754_ VGND VGND VPWR VPWR _0330_ sky130_fd_sc_hd__clkbuf_1
X_9332_ clknet_leaf_60_CLK _0565_ VGND VGND VPWR VPWR RF.reg_arr\[20\]\[22\] sky130_fd_sc_hd__dfxtp_1
X_6544_ _3179_ VGND VGND VPWR VPWR _0880_ sky130_fd_sc_hd__clkbuf_1
X_9263_ clknet_leaf_106_CLK _0496_ VGND VGND VPWR VPWR RF.reg_arr\[21\]\[17\] sky130_fd_sc_hd__dfxtp_1
XFILLER_0_15_578 VGND VGND VPWR VPWR sky130_fd_sc_hd__fill_1
X_6475_ _3142_ VGND VGND VPWR VPWR _0848_ sky130_fd_sc_hd__clkbuf_1
XTAP_TAPCELL_ROW_76_1158 VGND VPWR sky130_fd_sc_hd__tapvpwrvgnd_1
XFILLER_0_71_3 VGND VGND VPWR VPWR sky130_fd_sc_hd__decap_4
X_8214_ _4083_ VGND VGND VPWR VPWR _0622_ sky130_fd_sc_hd__clkbuf_1
X_5426_ _1844_ _2214_ _1642_ VGND VGND VPWR VPWR _2215_ sky130_fd_sc_hd__o21ai_1
XFILLER_0_100_425 VGND VGND VPWR VPWR sky130_fd_sc_hd__fill_1
XFILLER_0_100_403 VGND VGND VPWR VPWR sky130_fd_sc_hd__fill_1
XTAP_TAPCELL_ROW_76_1169 VGND VPWR sky130_fd_sc_hd__tapvpwrvgnd_1
X_9194_ clknet_leaf_99_CLK _0427_ VGND VGND VPWR VPWR RF.reg_arr\[24\]\[12\] sky130_fd_sc_hd__dfxtp_1
X_8145_ net193 _3420_ _4041_ VGND VGND VPWR VPWR _4047_ sky130_fd_sc_hd__mux2_1
X_5357_ RF.reg_arr\[24\]\[15\] RF.reg_arr\[25\]\[15\] RF.reg_arr\[26\]\[15\] RF.reg_arr\[27\]\[15\]
+ _1847_ _1850_ VGND VGND VPWR VPWR _2146_ sky130_fd_sc_hd__mux4_1
X_8076_ _4010_ VGND VGND VPWR VPWR _0557_ sky130_fd_sc_hd__clkbuf_1
X_4308_ RF.reg_arr\[28\]\[0\] RF.reg_arr\[29\]\[0\] RF.reg_arr\[30\]\[0\] RF.reg_arr\[31\]\[0\]
+ _1093_ _1094_ VGND VGND VPWR VPWR _1097_ sky130_fd_sc_hd__mux4_2
X_5288_ _2075_ _2076_ _1854_ VGND VGND VPWR VPWR _2077_ sky130_fd_sc_hd__mux2_1
X_7027_ net244 _3395_ _3449_ VGND VGND VPWR VPWR _3453_ sky130_fd_sc_hd__mux2_1
X_4239_ A2[1] VGND VGND VPWR VPWR _1028_ sky130_fd_sc_hd__buf_4
XFILLER_0_4_93 VGND VGND VPWR VPWR sky130_fd_sc_hd__fill_1
XFILLER_0_97_559 VGND VGND VPWR VPWR sky130_fd_sc_hd__fill_1
X_8978_ clknet_leaf_18_CLK _0211_ VGND VGND VPWR VPWR RF.reg_arr\[31\]\[20\] sky130_fd_sc_hd__dfxtp_1
XTAP_TAPCELL_ROW_87_1298 VGND VPWR sky130_fd_sc_hd__tapvpwrvgnd_1
X_7929_ _3932_ VGND VGND VPWR VPWR _0488_ sky130_fd_sc_hd__clkbuf_1
XFILLER_0_38_615 VGND VGND VPWR VPWR sky130_fd_sc_hd__decap_3
XTAP_TAPCELL_ROW_13_407 VGND VPWR sky130_fd_sc_hd__tapvpwrvgnd_1
XTAP_TAPCELL_ROW_41_738 VGND VPWR sky130_fd_sc_hd__tapvpwrvgnd_1
XTAP_TAPCELL_ROW_41_749 VGND VPWR sky130_fd_sc_hd__tapvpwrvgnd_1
XFILLER_0_65_478 VGND VGND VPWR VPWR sky130_fd_sc_hd__fill_1
XFILLER_0_37_169 VGND VGND VPWR VPWR sky130_fd_sc_hd__fill_1
XFILLER_0_61_651 VGND VGND VPWR VPWR sky130_fd_sc_hd__fill_2
XFILLER_0_0_409 VGND VGND VPWR VPWR sky130_fd_sc_hd__fill_2
XTAP_TAPCELL_ROW_49_838 VGND VPWR sky130_fd_sc_hd__tapvpwrvgnd_1
XFILLER_0_88_504 VGND VGND VPWR VPWR sky130_fd_sc_hd__decap_8
XFILLER_0_88_548 VGND VGND VPWR VPWR sky130_fd_sc_hd__decap_8
XFILLER_0_0_29 VPWR VGND VPWR VGND sky130_ef_sc_hd__decap_12
XTAP_TAPCELL_ROW_29_595 VGND VPWR sky130_fd_sc_hd__tapvpwrvgnd_1
XFILLER_0_83_220 VGND VGND VPWR VPWR sky130_fd_sc_hd__decap_4
XPHY_EDGE_ROW_104_Right_104 VGND VGND VPWR VPWR sky130_fd_sc_hd__decap_3
XFILLER_0_83_297 VGND VGND VPWR VPWR sky130_fd_sc_hd__decap_4
X_4590_ RF.reg_arr\[4\]\[22\] RF.reg_arr\[5\]\[22\] RF.reg_arr\[6\]\[22\] RF.reg_arr\[7\]\[22\]
+ _1342_ _1343_ VGND VGND VPWR VPWR _1379_ sky130_fd_sc_hd__mux4_1
XFILLER_0_114_539 VPWR VGND VPWR VGND sky130_ef_sc_hd__decap_12
XFILLER_0_114_528 VGND VGND VPWR VPWR sky130_fd_sc_hd__decap_4
XFILLER_0_3_236 VGND VGND VPWR VPWR sky130_fd_sc_hd__decap_4
XFILLER_0_24_342 VGND VGND VPWR VPWR sky130_fd_sc_hd__fill_1
Xhold917 RF.reg_arr\[27\]\[28\] VGND VGND VPWR VPWR net999 sky130_fd_sc_hd__dlygate4sd3_1
Xhold928 RF.reg_arr\[22\]\[18\] VGND VGND VPWR VPWR net1010 sky130_fd_sc_hd__dlygate4sd3_1
Xhold906 RF.reg_arr\[31\]\[10\] VGND VGND VPWR VPWR net988 sky130_fd_sc_hd__dlygate4sd3_1
XFILLER_0_101_98 VGND VGND VPWR VPWR sky130_fd_sc_hd__decap_3
X_6260_ _3005_ VGND VGND VPWR VPWR _0770_ sky130_fd_sc_hd__clkbuf_1
Xhold939 RF.reg_arr\[31\]\[16\] VGND VGND VPWR VPWR net1021 sky130_fd_sc_hd__dlygate4sd3_1
X_5211_ _1737_ VGND VGND VPWR VPWR _2000_ sky130_fd_sc_hd__clkbuf_4
X_6191_ _2276_ _1665_ _1698_ _2949_ VGND VGND VPWR VPWR _2950_ sky130_fd_sc_hd__a31o_1
XFILLER_0_86_89 VGND VGND VPWR VPWR sky130_fd_sc_hd__decap_8
X_5142_ RF.reg_arr\[20\]\[18\] RF.reg_arr\[21\]\[18\] RF.reg_arr\[22\]\[18\] RF.reg_arr\[23\]\[18\]
+ _1884_ _1886_ VGND VGND VPWR VPWR _1931_ sky130_fd_sc_hd__mux4_1
XFILLER_0_20_581 VGND VGND VPWR VPWR sky130_fd_sc_hd__decap_3
XTAP_TAPCELL_ROW_71_1099 VGND VPWR sky130_fd_sc_hd__tapvpwrvgnd_1
X_5073_ RF.reg_arr\[0\]\[22\] RF.reg_arr\[1\]\[22\] RF.reg_arr\[2\]\[22\] RF.reg_arr\[3\]\[22\]
+ _1857_ _1860_ VGND VGND VPWR VPWR _1862_ sky130_fd_sc_hd__mux4_1
XFILLER_0_79_526 VPWR VGND VPWR VGND sky130_ef_sc_hd__decap_12
X_8901_ clknet_leaf_93_CLK _0134_ VGND VGND VPWR VPWR RF.reg_arr\[7\]\[7\] sky130_fd_sc_hd__dfxtp_1
X_8832_ clknet_leaf_55_CLK _0065_ VGND VGND VPWR VPWR RF.reg_arr\[19\]\[2\] sky130_fd_sc_hd__dfxtp_1
X_8763_ clknet_leaf_26_CLK _1020_ VGND VGND VPWR VPWR RF.reg_arr\[6\]\[29\] sky130_fd_sc_hd__dfxtp_1
X_5975_ _2395_ _2373_ VGND VGND VPWR VPWR _2747_ sky130_fd_sc_hd__nand2_1
XFILLER_0_47_423 VGND VGND VPWR VPWR sky130_fd_sc_hd__fill_2
X_8694_ clknet_leaf_51_CLK _0951_ VGND VGND VPWR VPWR RF.reg_arr\[15\]\[24\] sky130_fd_sc_hd__dfxtp_1
X_4926_ _1637_ _1714_ _1644_ VGND VGND VPWR VPWR _1715_ sky130_fd_sc_hd__o21ai_1
X_7714_ _3818_ VGND VGND VPWR VPWR _0387_ sky130_fd_sc_hd__clkbuf_1
X_4857_ _1587_ _1620_ _1633_ _1645_ VGND VGND VPWR VPWR _1646_ sky130_fd_sc_hd__o2bb2a_2
XFILLER_0_74_253 VGND VGND VPWR VPWR sky130_fd_sc_hd__decap_4
X_7645_ _3067_ net1095 _3777_ VGND VGND VPWR VPWR _3782_ sky130_fd_sc_hd__mux2_1
XFILLER_0_19_169 VGND VGND VPWR VPWR sky130_fd_sc_hd__fill_1
XFILLER_0_105_517 VGND VGND VPWR VPWR sky130_fd_sc_hd__decap_4
XFILLER_0_74_297 VGND VGND VPWR VPWR sky130_fd_sc_hd__decap_6
X_7576_ _3745_ VGND VGND VPWR VPWR _0322_ sky130_fd_sc_hd__clkbuf_1
X_4788_ RF.reg_arr\[0\]\[24\] RF.reg_arr\[1\]\[24\] RF.reg_arr\[2\]\[24\] RF.reg_arr\[3\]\[24\]
+ _1316_ _1304_ VGND VGND VPWR VPWR _1577_ sky130_fd_sc_hd__mux4_1
X_6527_ _3170_ VGND VGND VPWR VPWR _0872_ sky130_fd_sc_hd__clkbuf_1
X_9315_ clknet_leaf_79_CLK _0548_ VGND VGND VPWR VPWR RF.reg_arr\[20\]\[5\] sky130_fd_sc_hd__dfxtp_1
XFILLER_0_42_150 VGND VGND VPWR VPWR sky130_fd_sc_hd__decap_4
XFILLER_0_113_561 VPWR VGND VPWR VGND sky130_ef_sc_hd__decap_12
X_9246_ clknet_leaf_75_CLK _0479_ VGND VGND VPWR VPWR RF.reg_arr\[21\]\[0\] sky130_fd_sc_hd__dfxtp_1
X_6458_ net128 VGND VGND VPWR VPWR _3134_ sky130_fd_sc_hd__clkbuf_1
Xclkload90 clknet_leaf_53_CLK VGND VGND VPWR VPWR clkload90/Y sky130_fd_sc_hd__inv_8
X_9177_ clknet_leaf_37_CLK _0410_ VGND VGND VPWR VPWR RF.reg_arr\[9\]\[27\] sky130_fd_sc_hd__dfxtp_1
X_5409_ _2197_ VGND VGND VPWR VPWR _2198_ sky130_fd_sc_hd__buf_2
X_6389_ _3090_ net429 _3080_ VGND VGND VPWR VPWR _3091_ sky130_fd_sc_hd__mux2_1
X_8128_ net292 _3403_ _4030_ VGND VGND VPWR VPWR _4038_ sky130_fd_sc_hd__mux2_1
XTAP_TAPCELL_ROW_89_1316 VGND VPWR sky130_fd_sc_hd__tapvpwrvgnd_1
X_8059_ _4001_ VGND VGND VPWR VPWR _0549_ sky130_fd_sc_hd__clkbuf_1
XTAP_TAPCELL_ROW_46_808 VGND VPWR sky130_fd_sc_hd__tapvpwrvgnd_1
XFILLER_0_65_220 VGND VGND VPWR VPWR sky130_fd_sc_hd__decap_4
XTAP_TAPCELL_ROW_26_565 VGND VPWR sky130_fd_sc_hd__tapvpwrvgnd_1
XTAP_TAPCELL_ROW_54_896 VGND VPWR sky130_fd_sc_hd__tapvpwrvgnd_1
XFILLER_0_108_377 VPWR VGND VPWR VGND sky130_ef_sc_hd__decap_12
XFILLER_0_93_595 VGND VGND VPWR VPWR sky130_fd_sc_hd__decap_4
XFILLER_0_104_583 VGND VGND VPWR VPWR sky130_fd_sc_hd__decap_4
XTAP_TAPCELL_ROW_109_1563 VGND VPWR sky130_fd_sc_hd__tapvpwrvgnd_1
XFILLER_0_88_356 VGND VGND VPWR VPWR sky130_fd_sc_hd__decap_4
XFILLER_0_48_209 VGND VGND VPWR VPWR sky130_fd_sc_hd__decap_4
X_5760_ _2234_ _2516_ VGND VGND VPWR VPWR _2543_ sky130_fd_sc_hd__nand2_1
X_5691_ _2475_ _2476_ _2197_ VGND VGND VPWR VPWR _2477_ sky130_fd_sc_hd__mux2_1
X_4711_ RF.reg_arr\[28\]\[13\] RF.reg_arr\[29\]\[13\] RF.reg_arr\[30\]\[13\] RF.reg_arr\[31\]\[13\]
+ _1044_ _1046_ VGND VGND VPWR VPWR _1500_ sky130_fd_sc_hd__mux4_1
X_4642_ _1282_ _1430_ _1163_ VGND VGND VPWR VPWR _1431_ sky130_fd_sc_hd__o21ai_1
XFILLER_0_16_139 VGND VGND VPWR VPWR sky130_fd_sc_hd__fill_1
X_7430_ _3666_ VGND VGND VPWR VPWR _3667_ sky130_fd_sc_hd__buf_6
XFILLER_0_56_286 VGND VGND VPWR VPWR sky130_fd_sc_hd__fill_1
XFILLER_0_97_11 VGND VGND VPWR VPWR sky130_fd_sc_hd__fill_1
X_4573_ _1126_ _1361_ VGND VGND VPWR VPWR _1362_ sky130_fd_sc_hd__nand2_1
X_7361_ _3629_ VGND VGND VPWR VPWR _3630_ sky130_fd_sc_hd__clkbuf_8
Xhold703 RF.reg_arr\[27\]\[18\] VGND VGND VPWR VPWR net785 sky130_fd_sc_hd__dlygate4sd3_1
XFILLER_0_21_84 VGND VGND VPWR VPWR sky130_fd_sc_hd__decap_4
X_6312_ net177 _3039_ _3040_ VGND VGND VPWR VPWR _3041_ sky130_fd_sc_hd__mux2_1
X_7292_ _3057_ _3556_ VGND VGND VPWR VPWR _3593_ sky130_fd_sc_hd__nand2_2
Xhold714 RF.reg_arr\[14\]\[12\] VGND VGND VPWR VPWR net796 sky130_fd_sc_hd__dlygate4sd3_1
Xhold736 RF.reg_arr\[8\]\[17\] VGND VGND VPWR VPWR net818 sky130_fd_sc_hd__dlygate4sd3_1
X_9100_ clknet_leaf_95_CLK _0333_ VGND VGND VPWR VPWR RF.reg_arr\[2\]\[14\] sky130_fd_sc_hd__dfxtp_1
Xhold725 RF.reg_arr\[29\]\[0\] VGND VGND VPWR VPWR net807 sky130_fd_sc_hd__dlygate4sd3_1
XFILLER_0_40_654 VGND VGND VPWR VPWR sky130_fd_sc_hd__decap_3
Xhold747 RF.reg_arr\[12\]\[28\] VGND VGND VPWR VPWR net829 sky130_fd_sc_hd__dlygate4sd3_1
XFILLER_0_110_531 VGND VGND VPWR VPWR sky130_fd_sc_hd__fill_1
X_6243_ net325 _2992_ _2978_ VGND VGND VPWR VPWR _2993_ sky130_fd_sc_hd__mux2_1
XTAP_TAPCELL_ROW_73_1128 VGND VPWR sky130_fd_sc_hd__tapvpwrvgnd_1
X_9031_ clknet_leaf_78_CLK _0264_ VGND VGND VPWR VPWR RF.reg_arr\[26\]\[9\] sky130_fd_sc_hd__dfxtp_1
Xhold758 RF.reg_arr\[29\]\[2\] VGND VGND VPWR VPWR net840 sky130_fd_sc_hd__dlygate4sd3_1
Xhold769 RF.reg_arr\[30\]\[11\] VGND VGND VPWR VPWR net851 sky130_fd_sc_hd__dlygate4sd3_1
XFILLER_0_110_575 VGND VGND VPWR VPWR sky130_fd_sc_hd__fill_2
X_6174_ _2446_ _2927_ _2934_ VGND VGND VPWR VPWR net69 sky130_fd_sc_hd__o21a_1
X_5125_ RF.reg_arr\[16\]\[21\] RF.reg_arr\[17\]\[21\] RF.reg_arr\[18\]\[21\] RF.reg_arr\[19\]\[21\]
+ _1625_ _1598_ VGND VGND VPWR VPWR _1914_ sky130_fd_sc_hd__mux4_1
XFILLER_0_34_3 VGND VGND VPWR VPWR sky130_fd_sc_hd__decap_3
X_5056_ _1844_ VGND VGND VPWR VPWR _1845_ sky130_fd_sc_hd__clkbuf_8
XFILLER_0_94_304 VGND VGND VPWR VPWR sky130_fd_sc_hd__decap_4
XTAP_TAPCELL_ROW_84_1257 VGND VPWR sky130_fd_sc_hd__tapvpwrvgnd_1
X_8815_ clknet_leaf_1_CLK _0048_ VGND VGND VPWR VPWR RF.reg_arr\[4\]\[17\] sky130_fd_sc_hd__dfxtp_1
X_5958_ _2578_ VGND VGND VPWR VPWR _2731_ sky130_fd_sc_hd__inv_2
X_8746_ clknet_leaf_96_CLK _1003_ VGND VGND VPWR VPWR RF.reg_arr\[6\]\[12\] sky130_fd_sc_hd__dfxtp_1
X_4909_ _1667_ _1697_ VGND VGND VPWR VPWR _1698_ sky130_fd_sc_hd__or2_1
XFILLER_0_75_573 VGND VGND VPWR VPWR sky130_fd_sc_hd__decap_8
XTAP_TAPCELL_ROW_23_524 VGND VPWR sky130_fd_sc_hd__tapvpwrvgnd_1
X_5889_ _2340_ _2654_ _2665_ VGND VGND VPWR VPWR net52 sky130_fd_sc_hd__a21oi_1
X_8677_ clknet_leaf_97_CLK _0934_ VGND VGND VPWR VPWR RF.reg_arr\[15\]\[7\] sky130_fd_sc_hd__dfxtp_1
XTAP_TAPCELL_ROW_51_866 VGND VPWR sky130_fd_sc_hd__tapvpwrvgnd_1
X_7628_ _3772_ VGND VGND VPWR VPWR _0347_ sky130_fd_sc_hd__clkbuf_1
XFILLER_0_16_662 VGND VGND VPWR VPWR sky130_fd_sc_hd__decap_3
XFILLER_0_50_407 VGND VGND VPWR VPWR sky130_fd_sc_hd__fill_1
X_7559_ net342 _3379_ _3727_ VGND VGND VPWR VPWR _3736_ sky130_fd_sc_hd__mux2_1
XFILLER_0_90_587 VGND VGND VPWR VPWR sky130_fd_sc_hd__fill_1
XFILLER_0_15_150 VGND VGND VPWR VPWR sky130_fd_sc_hd__fill_2
XTAP_TAPCELL_ROW_95_1397 VGND VPWR sky130_fd_sc_hd__tapvpwrvgnd_1
XTAP_TAPCELL_ROW_95_1386 VGND VPWR sky130_fd_sc_hd__tapvpwrvgnd_1
X_9229_ clknet_leaf_105_CLK _0462_ VGND VGND VPWR VPWR RF.reg_arr\[22\]\[15\] sky130_fd_sc_hd__dfxtp_1
XFILLER_0_101_553 VGND VGND VPWR VPWR sky130_fd_sc_hd__decap_6
Xhold41 RF.reg_arr\[0\]\[5\] VGND VGND VPWR VPWR net123 sky130_fd_sc_hd__dlygate4sd3_1
Xhold30 RF.reg_arr\[0\]\[0\] VGND VGND VPWR VPWR net112 sky130_fd_sc_hd__dlygate4sd3_1
Xhold52 RF.reg_arr\[9\]\[31\] VGND VGND VPWR VPWR net134 sky130_fd_sc_hd__dlygate4sd3_1
XTAP_TAPCELL_ROW_59_955 VGND VPWR sky130_fd_sc_hd__tapvpwrvgnd_1
Xhold74 RF.reg_arr\[6\]\[6\] VGND VGND VPWR VPWR net156 sky130_fd_sc_hd__dlygate4sd3_1
Xhold63 RF.reg_arr\[16\]\[13\] VGND VGND VPWR VPWR net145 sky130_fd_sc_hd__dlygate4sd3_1
Xhold85 RF.reg_arr\[9\]\[25\] VGND VGND VPWR VPWR net167 sky130_fd_sc_hd__dlygate4sd3_1
Xhold96 RF.reg_arr\[10\]\[0\] VGND VGND VPWR VPWR net178 sky130_fd_sc_hd__dlygate4sd3_1
XFILLER_0_98_665 VPWR VGND VPWR VGND sky130_ef_sc_hd__decap_12
XFILLER_0_98_654 VGND VGND VPWR VPWR sky130_fd_sc_hd__decap_6
XTAP_TAPCELL_ROW_3_293 VGND VPWR sky130_fd_sc_hd__tapvpwrvgnd_1
XTAP_TAPCELL_ROW_3_282 VGND VPWR sky130_fd_sc_hd__tapvpwrvgnd_1
XFILLER_0_98_687 VGND VGND VPWR VPWR sky130_fd_sc_hd__decap_4
XFILLER_0_97_186 VGND VGND VPWR VPWR sky130_fd_sc_hd__decap_3
XFILLER_0_38_242 VGND VGND VPWR VPWR sky130_fd_sc_hd__fill_1
XFILLER_0_38_253 VGND VGND VPWR VPWR sky130_fd_sc_hd__fill_2
XFILLER_0_109_664 VGND VGND VPWR VPWR sky130_fd_sc_hd__decap_4
XFILLER_0_108_141 VGND VGND VPWR VPWR sky130_fd_sc_hd__decap_8
XFILLER_0_66_584 VGND VGND VPWR VPWR sky130_fd_sc_hd__decap_4
XFILLER_0_41_418 VGND VGND VPWR VPWR sky130_fd_sc_hd__decap_4
XANTENNA_5 WD3[20] VGND VGND VPWR VPWR sky130_fd_sc_hd__diode_2
XFILLER_0_67_69 VGND VGND VPWR VPWR sky130_fd_sc_hd__fill_1
XFILLER_0_83_57 VGND VGND VPWR VPWR sky130_fd_sc_hd__decap_6
XFILLER_0_16_40 VGND VGND VPWR VPWR sky130_fd_sc_hd__decap_4
X_6930_ _3390_ VGND VGND VPWR VPWR _0031_ sky130_fd_sc_hd__clkbuf_1
XFILLER_0_76_304 VGND VGND VPWR VPWR sky130_fd_sc_hd__decap_4
X_6861_ _3349_ VGND VGND VPWR VPWR _0003_ sky130_fd_sc_hd__clkbuf_1
X_8600_ clknet_leaf_53_CLK _0857_ VGND VGND VPWR VPWR RF.reg_arr\[0\]\[26\] sky130_fd_sc_hd__dfxtp_1
X_5812_ _1792_ _2272_ _2236_ VGND VGND VPWR VPWR _2593_ sky130_fd_sc_hd__o21ba_1
X_6792_ _3312_ VGND VGND VPWR VPWR _0995_ sky130_fd_sc_hd__clkbuf_1
X_5743_ _2485_ _2521_ _2525_ _2443_ VGND VGND VPWR VPWR _2526_ sky130_fd_sc_hd__o31ai_1
X_8531_ clknet_leaf_47_CLK _0788_ VGND VGND VPWR VPWR RF.reg_arr\[1\]\[21\] sky130_fd_sc_hd__dfxtp_1
XFILLER_0_57_573 VGND VGND VPWR VPWR sky130_fd_sc_hd__decap_8
XFILLER_0_8_125 VGND VGND VPWR VPWR sky130_fd_sc_hd__fill_1
XFILLER_0_17_404 VGND VGND VPWR VPWR sky130_fd_sc_hd__fill_1
XFILLER_0_17_437 VGND VGND VPWR VPWR sky130_fd_sc_hd__decap_4
XFILLER_0_32_83 VGND VGND VPWR VPWR sky130_fd_sc_hd__fill_1
X_5674_ _2457_ _2459_ VGND VGND VPWR VPWR _2460_ sky130_fd_sc_hd__xnor2_1
X_8462_ _4214_ VGND VGND VPWR VPWR _0739_ sky130_fd_sc_hd__clkbuf_1
X_7413_ _3657_ VGND VGND VPWR VPWR _0247_ sky130_fd_sc_hd__clkbuf_1
X_4625_ _1110_ _1413_ _1141_ VGND VGND VPWR VPWR _1414_ sky130_fd_sc_hd__a21oi_1
X_8393_ _4178_ VGND VGND VPWR VPWR _0706_ sky130_fd_sc_hd__clkbuf_1
X_7344_ _3109_ net883 _3616_ VGND VGND VPWR VPWR _3621_ sky130_fd_sc_hd__mux2_1
Xhold511 RF.reg_arr\[28\]\[23\] VGND VGND VPWR VPWR net593 sky130_fd_sc_hd__dlygate4sd3_1
X_4556_ _1121_ _1344_ VGND VGND VPWR VPWR _1345_ sky130_fd_sc_hd__or2_1
Xhold500 RF.reg_arr\[12\]\[3\] VGND VGND VPWR VPWR net582 sky130_fd_sc_hd__dlygate4sd3_1
Xhold544 RF.reg_arr\[16\]\[29\] VGND VGND VPWR VPWR net626 sky130_fd_sc_hd__dlygate4sd3_1
Xhold533 RF.reg_arr\[15\]\[22\] VGND VGND VPWR VPWR net615 sky130_fd_sc_hd__dlygate4sd3_1
XFILLER_0_4_397 VGND VGND VPWR VPWR sky130_fd_sc_hd__fill_2
Xhold522 RF.reg_arr\[5\]\[17\] VGND VGND VPWR VPWR net604 sky130_fd_sc_hd__dlygate4sd3_1
X_4487_ _1275_ VGND VGND VPWR VPWR _1276_ sky130_fd_sc_hd__clkbuf_4
X_7275_ _3584_ VGND VGND VPWR VPWR _0182_ sky130_fd_sc_hd__clkbuf_1
Xhold577 RF.reg_arr\[28\]\[4\] VGND VGND VPWR VPWR net659 sky130_fd_sc_hd__dlygate4sd3_1
Xhold555 RF.reg_arr\[14\]\[9\] VGND VGND VPWR VPWR net637 sky130_fd_sc_hd__dlygate4sd3_1
Xhold566 RF.reg_arr\[25\]\[3\] VGND VGND VPWR VPWR net648 sky130_fd_sc_hd__dlygate4sd3_1
Xhold588 RF.reg_arr\[30\]\[2\] VGND VGND VPWR VPWR net670 sky130_fd_sc_hd__dlygate4sd3_1
X_9014_ clknet_leaf_51_CLK _0247_ VGND VGND VPWR VPWR RF.reg_arr\[27\]\[24\] sky130_fd_sc_hd__dfxtp_1
XFILLER_0_110_372 VPWR VGND VPWR VGND sky130_ef_sc_hd__decap_12
XFILLER_0_110_361 VGND VGND VPWR VPWR sky130_fd_sc_hd__decap_3
X_6226_ _2981_ VGND VGND VPWR VPWR _0760_ sky130_fd_sc_hd__clkbuf_1
Xhold599 RF.reg_arr\[6\]\[13\] VGND VGND VPWR VPWR net681 sky130_fd_sc_hd__dlygate4sd3_1
X_6157_ _2916_ _2917_ VGND VGND VPWR VPWR _2918_ sky130_fd_sc_hd__or2_1
XFILLER_0_99_407 VGND VGND VPWR VPWR sky130_fd_sc_hd__decap_3
X_5108_ RF.reg_arr\[16\]\[20\] RF.reg_arr\[17\]\[20\] RF.reg_arr\[18\]\[20\] RF.reg_arr\[19\]\[20\]
+ _1848_ _1851_ VGND VGND VPWR VPWR _1897_ sky130_fd_sc_hd__mux4_1
X_6088_ _2730_ _2732_ _2735_ _2852_ VGND VGND VPWR VPWR _2853_ sky130_fd_sc_hd__a31o_4
X_5039_ _1039_ _1827_ net8 VGND VGND VPWR VPWR _1828_ sky130_fd_sc_hd__a21oi_2
XTAP_TAPCELL_ROW_56_925 VGND VPWR sky130_fd_sc_hd__tapvpwrvgnd_1
XFILLER_0_95_624 VPWR VGND VPWR VGND sky130_ef_sc_hd__decap_12
XTAP_TAPCELL_ROW_0_241 VGND VPWR sky130_fd_sc_hd__tapvpwrvgnd_1
XTAP_TAPCELL_ROW_0_252 VGND VPWR sky130_fd_sc_hd__tapvpwrvgnd_1
XFILLER_0_94_156 VGND VGND VPWR VPWR sky130_fd_sc_hd__fill_1
XTAP_TAPCELL_ROW_36_682 VGND VPWR sky130_fd_sc_hd__tapvpwrvgnd_1
X_8729_ clknet_leaf_37_CLK _0986_ VGND VGND VPWR VPWR RF.reg_arr\[14\]\[27\] sky130_fd_sc_hd__dfxtp_1
XFILLER_0_48_595 VGND VGND VPWR VPWR sky130_fd_sc_hd__fill_2
XTAP_TAPCELL_ROW_97_1415 VGND VPWR sky130_fd_sc_hd__tapvpwrvgnd_1
XFILLER_0_106_645 VGND VGND VPWR VPWR sky130_fd_sc_hd__fill_1
XFILLER_0_50_248 VGND VGND VPWR VPWR sky130_fd_sc_hd__fill_1
XFILLER_0_31_484 VGND VGND VPWR VPWR sky130_fd_sc_hd__fill_2
Xoutput64 net64 VGND VGND VPWR VPWR result[23] sky130_fd_sc_hd__clkbuf_4
Xoutput75 net75 VGND VGND VPWR VPWR result[4] sky130_fd_sc_hd__clkbuf_4
Xoutput53 net53 VGND VGND VPWR VPWR result[13] sky130_fd_sc_hd__clkbuf_4
XTAP_TAPCELL_ROW_8_352 VGND VPWR sky130_fd_sc_hd__tapvpwrvgnd_1
XTAP_TAPCELL_ROW_106_1522 VGND VPWR sky130_fd_sc_hd__tapvpwrvgnd_1
XFILLER_0_85_178 VGND VGND VPWR VPWR sky130_fd_sc_hd__decap_4
XFILLER_0_85_156 VGND VGND VPWR VPWR sky130_fd_sc_hd__fill_1
XFILLER_0_94_690 VGND VGND VPWR VPWR sky130_fd_sc_hd__fill_2
XFILLER_0_81_384 VGND VGND VPWR VPWR sky130_fd_sc_hd__decap_8
XFILLER_0_41_204 VGND VGND VPWR VPWR sky130_fd_sc_hd__decap_8
XFILLER_0_112_604 VGND VGND VPWR VPWR sky130_fd_sc_hd__fill_2
X_4410_ RF.reg_arr\[0\]\[18\] RF.reg_arr\[1\]\[18\] RF.reg_arr\[2\]\[18\] RF.reg_arr\[3\]\[18\]
+ _1164_ _1165_ VGND VGND VPWR VPWR _1199_ sky130_fd_sc_hd__mux4_1
XFILLER_0_111_136 VGND VGND VPWR VPWR sky130_fd_sc_hd__decap_3
XFILLER_0_78_57 VGND VGND VPWR VPWR sky130_fd_sc_hd__decap_6
XFILLER_0_1_334 VGND VGND VPWR VPWR sky130_fd_sc_hd__fill_2
X_5390_ _2177_ _2178_ net3 VGND VGND VPWR VPWR _2179_ sky130_fd_sc_hd__mux2_1
XFILLER_0_111_169 VGND VGND VPWR VPWR sky130_fd_sc_hd__decap_6
XFILLER_0_22_473 VGND VGND VPWR VPWR sky130_fd_sc_hd__decap_3
X_4341_ _1046_ VGND VGND VPWR VPWR _1130_ sky130_fd_sc_hd__buf_4
X_7060_ net972 _3428_ _3460_ VGND VGND VPWR VPWR _3470_ sky130_fd_sc_hd__mux2_1
X_4272_ net7 VGND VGND VPWR VPWR _1061_ sky130_fd_sc_hd__buf_4
X_6011_ _2568_ _2775_ _2780_ VGND VGND VPWR VPWR net59 sky130_fd_sc_hd__o21ai_1
XFILLER_0_27_50 VGND VGND VPWR VPWR sky130_fd_sc_hd__decap_6
X_7962_ _2980_ net516 _3944_ VGND VGND VPWR VPWR _3950_ sky130_fd_sc_hd__mux2_1
X_6913_ _3378_ VGND VGND VPWR VPWR _0026_ sky130_fd_sc_hd__clkbuf_1
XFILLER_0_76_101 VGND VGND VPWR VPWR sky130_fd_sc_hd__decap_3
XFILLER_0_49_315 VGND VGND VPWR VPWR sky130_fd_sc_hd__decap_3
X_7893_ _3913_ VGND VGND VPWR VPWR _0471_ sky130_fd_sc_hd__clkbuf_1
X_6844_ _3339_ VGND VGND VPWR VPWR _1020_ sky130_fd_sc_hd__clkbuf_1
XTAP_TAPCELL_ROW_81_1227 VGND VPWR sky130_fd_sc_hd__tapvpwrvgnd_1
XFILLER_0_77_668 VGND VGND VPWR VPWR sky130_fd_sc_hd__decap_4
X_6775_ _3302_ VGND VGND VPWR VPWR _0988_ sky130_fd_sc_hd__clkbuf_1
XFILLER_0_92_627 VGND VGND VPWR VPWR sky130_fd_sc_hd__decap_8
XTAP_TAPCELL_ROW_33_652 VGND VPWR sky130_fd_sc_hd__tapvpwrvgnd_1
X_9494_ clknet_leaf_36_CLK _0727_ VGND VGND VPWR VPWR RF.reg_arr\[11\]\[24\] sky130_fd_sc_hd__dfxtp_1
X_5726_ _2386_ _2509_ _1830_ VGND VGND VPWR VPWR _2510_ sky130_fd_sc_hd__mux2_1
XTAP_TAPCELL_ROW_61_983 VGND VPWR sky130_fd_sc_hd__tapvpwrvgnd_1
X_8514_ clknet_leaf_66_CLK _0771_ VGND VGND VPWR VPWR RF.reg_arr\[1\]\[4\] sky130_fd_sc_hd__dfxtp_1
XFILLER_0_45_554 VGND VGND VPWR VPWR sky130_fd_sc_hd__decap_6
X_8445_ _4205_ VGND VGND VPWR VPWR _0731_ sky130_fd_sc_hd__clkbuf_1
XFILLER_0_17_289 VGND VGND VPWR VPWR sky130_fd_sc_hd__fill_1
X_5657_ _1092_ _2440_ _2442_ _2382_ _2443_ VGND VGND VPWR VPWR _2444_ sky130_fd_sc_hd__o221a_1
XFILLER_0_5_673 VPWR VGND VPWR VGND sky130_ef_sc_hd__decap_12
X_8376_ _2986_ net829 _4160_ VGND VGND VPWR VPWR _4169_ sky130_fd_sc_hd__mux2_1
XFILLER_0_103_626 VGND VGND VPWR VPWR sky130_fd_sc_hd__decap_6
X_5588_ _2372_ _2375_ _2366_ VGND VGND VPWR VPWR _2376_ sky130_fd_sc_hd__mux2_1
XFILLER_0_60_568 VGND VGND VPWR VPWR sky130_fd_sc_hd__fill_1
X_4608_ RF.reg_arr\[4\]\[6\] RF.reg_arr\[5\]\[6\] RF.reg_arr\[6\]\[6\] RF.reg_arr\[7\]\[6\]
+ _1044_ _1046_ VGND VGND VPWR VPWR _1397_ sky130_fd_sc_hd__mux4_1
XFILLER_0_102_169 VGND VGND VPWR VPWR sky130_fd_sc_hd__fill_1
Xhold341 RF.reg_arr\[6\]\[14\] VGND VGND VPWR VPWR net423 sky130_fd_sc_hd__dlygate4sd3_1
Xhold330 RF.reg_arr\[19\]\[18\] VGND VGND VPWR VPWR net412 sky130_fd_sc_hd__dlygate4sd3_1
Xhold352 RF.reg_arr\[28\]\[19\] VGND VGND VPWR VPWR net434 sky130_fd_sc_hd__dlygate4sd3_1
X_7327_ _3092_ net1021 _3605_ VGND VGND VPWR VPWR _3612_ sky130_fd_sc_hd__mux2_1
X_4539_ _1165_ VGND VGND VPWR VPWR _1328_ sky130_fd_sc_hd__buf_4
Xhold385 RF.reg_arr\[19\]\[25\] VGND VGND VPWR VPWR net467 sky130_fd_sc_hd__dlygate4sd3_1
XTAP_TAPCELL_ROW_92_1356 VGND VPWR sky130_fd_sc_hd__tapvpwrvgnd_1
Xhold374 RF.reg_arr\[9\]\[29\] VGND VGND VPWR VPWR net456 sky130_fd_sc_hd__dlygate4sd3_1
Xhold363 RF.reg_arr\[6\]\[25\] VGND VGND VPWR VPWR net445 sky130_fd_sc_hd__dlygate4sd3_1
X_7258_ _3575_ VGND VGND VPWR VPWR _0174_ sky130_fd_sc_hd__clkbuf_1
Xhold396 RF.reg_arr\[9\]\[5\] VGND VGND VPWR VPWR net478 sky130_fd_sc_hd__dlygate4sd3_1
X_6209_ _2430_ _2908_ _2966_ _2025_ VGND VGND VPWR VPWR _2967_ sky130_fd_sc_hd__a211o_1
XTAP_TAPCELL_ROW_5_311 VGND VPWR sky130_fd_sc_hd__tapvpwrvgnd_1
X_7189_ _3538_ VGND VGND VPWR VPWR _0142_ sky130_fd_sc_hd__clkbuf_1
Xhold1030 RF.reg_arr\[20\]\[26\] VGND VGND VPWR VPWR net1112 sky130_fd_sc_hd__dlygate4sd3_1
XTAP_TAPCELL_ROW_101_1463 VGND VPWR sky130_fd_sc_hd__tapvpwrvgnd_1
XFILLER_0_63_362 VGND VGND VPWR VPWR sky130_fd_sc_hd__fill_1
XFILLER_0_36_587 VGND VGND VPWR VPWR sky130_fd_sc_hd__fill_1
XFILLER_0_106_475 VGND VGND VPWR VPWR sky130_fd_sc_hd__fill_1
Xrebuffer8 net89 VGND VGND VPWR VPWR net90 sky130_fd_sc_hd__dlymetal6s2s_1
XTAP_TAPCELL_ROW_11_379 VGND VPWR sky130_fd_sc_hd__tapvpwrvgnd_1
XFILLER_0_2_109 VGND VGND VPWR VPWR sky130_fd_sc_hd__decap_8
XFILLER_0_31_281 VGND VGND VPWR VPWR sky130_fd_sc_hd__decap_3
XTAP_TAPCELL_ROW_112_1592 VGND VPWR sky130_fd_sc_hd__tapvpwrvgnd_1
XFILLER_0_86_421 VGND VGND VPWR VPWR sky130_fd_sc_hd__decap_4
XTAP_TAPCELL_ROW_67_1060 VGND VPWR sky130_fd_sc_hd__tapvpwrvgnd_1
XTAP_TAPCELL_ROW_19_479 VGND VPWR sky130_fd_sc_hd__tapvpwrvgnd_1
X_4890_ net2 VGND VGND VPWR VPWR _1679_ sky130_fd_sc_hd__clkbuf_4
XFILLER_0_86_487 VGND VGND VPWR VPWR sky130_fd_sc_hd__decap_3
XFILLER_0_73_104 VGND VGND VPWR VPWR sky130_fd_sc_hd__decap_4
XFILLER_0_27_521 VGND VGND VPWR VPWR sky130_fd_sc_hd__decap_3
XFILLER_0_104_65 VPWR VGND VPWR VGND sky130_ef_sc_hd__decap_12
X_6560_ net339 _2980_ _3182_ VGND VGND VPWR VPWR _3188_ sky130_fd_sc_hd__mux2_1
XTAP_TAPCELL_ROW_30_611 VGND VPWR sky130_fd_sc_hd__tapvpwrvgnd_1
XFILLER_0_104_98 VGND VGND VPWR VPWR sky130_fd_sc_hd__fill_2
X_5511_ _2296_ _2299_ _1634_ VGND VGND VPWR VPWR _2300_ sky130_fd_sc_hd__mux2_1
XFILLER_0_42_513 VGND VGND VPWR VPWR sky130_fd_sc_hd__decap_4
X_6491_ _3150_ VGND VGND VPWR VPWR _0856_ sky130_fd_sc_hd__clkbuf_1
X_8230_ _3046_ net552 _4088_ VGND VGND VPWR VPWR _4092_ sky130_fd_sc_hd__mux2_1
X_5442_ RF.reg_arr\[0\]\[5\] RF.reg_arr\[1\]\[5\] RF.reg_arr\[2\]\[5\] RF.reg_arr\[3\]\[5\]
+ _2087_ _1859_ VGND VGND VPWR VPWR _2231_ sky130_fd_sc_hd__mux4_1
XFILLER_0_112_445 VGND VGND VPWR VPWR sky130_fd_sc_hd__fill_2
X_8161_ _4055_ VGND VGND VPWR VPWR _0597_ sky130_fd_sc_hd__clkbuf_1
X_5373_ _2160_ _2161_ _1863_ VGND VGND VPWR VPWR _2162_ sky130_fd_sc_hd__mux2_1
XFILLER_0_2_643 VGND VGND VPWR VPWR sky130_fd_sc_hd__fill_1
X_4324_ _1112_ VGND VGND VPWR VPWR _1113_ sky130_fd_sc_hd__clkbuf_4
X_8092_ _3044_ net852 _4016_ VGND VGND VPWR VPWR _4019_ sky130_fd_sc_hd__mux2_1
XFILLER_0_10_421 VGND VGND VPWR VPWR sky130_fd_sc_hd__decap_4
XFILLER_0_1_164 VGND VGND VPWR VPWR sky130_fd_sc_hd__decap_4
X_7112_ net600 _3412_ _3496_ VGND VGND VPWR VPWR _3498_ sky130_fd_sc_hd__mux2_1
XFILLER_0_1_186 VGND VGND VPWR VPWR sky130_fd_sc_hd__decap_3
X_7043_ _3461_ VGND VGND VPWR VPWR _0073_ sky130_fd_sc_hd__clkbuf_1
XFILLER_0_10_498 VGND VGND VPWR VPWR sky130_fd_sc_hd__fill_1
X_4255_ _1043_ VGND VGND VPWR VPWR _1044_ sky130_fd_sc_hd__buf_4
XTAP_TAPCELL_ROW_38_711 VGND VPWR sky130_fd_sc_hd__tapvpwrvgnd_1
X_8994_ clknet_leaf_76_CLK _0227_ VGND VGND VPWR VPWR RF.reg_arr\[27\]\[4\] sky130_fd_sc_hd__dfxtp_1
XFILLER_0_89_281 VGND VGND VPWR VPWR sky130_fd_sc_hd__decap_4
XFILLER_0_77_410 VGND VGND VPWR VPWR sky130_fd_sc_hd__decap_4
X_7945_ _3033_ net1018 _3933_ VGND VGND VPWR VPWR _3941_ sky130_fd_sc_hd__mux2_1
XFILLER_0_65_605 VGND VGND VPWR VPWR sky130_fd_sc_hd__decap_3
X_7876_ _3904_ VGND VGND VPWR VPWR _0463_ sky130_fd_sc_hd__clkbuf_1
X_6827_ net601 _3042_ _3329_ VGND VGND VPWR VPWR _3331_ sky130_fd_sc_hd__mux2_1
X_6758_ _3103_ net502 _3292_ VGND VGND VPWR VPWR _3294_ sky130_fd_sc_hd__mux2_1
XFILLER_0_18_565 VGND VGND VPWR VPWR sky130_fd_sc_hd__decap_3
X_5709_ _2198_ _2493_ VGND VGND VPWR VPWR _2494_ sky130_fd_sc_hd__nor2_1
X_6689_ _3256_ VGND VGND VPWR VPWR _0948_ sky130_fd_sc_hd__clkbuf_1
X_9477_ clknet_leaf_97_CLK _0710_ VGND VGND VPWR VPWR RF.reg_arr\[11\]\[7\] sky130_fd_sc_hd__dfxtp_1
XFILLER_0_33_524 VGND VGND VPWR VPWR sky130_fd_sc_hd__decap_3
XFILLER_0_115_261 VGND VGND VPWR VPWR sky130_fd_sc_hd__fill_2
X_8428_ net261 _3430_ _4196_ VGND VGND VPWR VPWR _4197_ sky130_fd_sc_hd__mux2_1
XFILLER_0_5_492 VGND VGND VPWR VPWR sky130_fd_sc_hd__decap_3
X_8359_ _4137_ VGND VGND VPWR VPWR _4160_ sky130_fd_sc_hd__clkbuf_8
XFILLER_0_103_478 VPWR VGND VPWR VGND sky130_ef_sc_hd__decap_12
Xhold171 RF.reg_arr\[1\]\[18\] VGND VGND VPWR VPWR net253 sky130_fd_sc_hd__dlygate4sd3_1
Xhold160 RF.reg_arr\[3\]\[18\] VGND VGND VPWR VPWR net242 sky130_fd_sc_hd__dlygate4sd3_1
Xhold182 RF.reg_arr\[11\]\[15\] VGND VGND VPWR VPWR net264 sky130_fd_sc_hd__dlygate4sd3_1
Xhold193 RF.reg_arr\[6\]\[9\] VGND VGND VPWR VPWR net275 sky130_fd_sc_hd__dlygate4sd3_1
XFILLER_0_68_421 VGND VGND VPWR VPWR sky130_fd_sc_hd__decap_4
XTAP_TAPCELL_ROW_16_438 VGND VPWR sky130_fd_sc_hd__tapvpwrvgnd_1
XTAP_TAPCELL_ROW_16_449 VGND VPWR sky130_fd_sc_hd__tapvpwrvgnd_1
XFILLER_0_28_307 VGND VGND VPWR VPWR sky130_fd_sc_hd__fill_1
XFILLER_0_71_608 VGND VGND VPWR VPWR sky130_fd_sc_hd__decap_8
XFILLER_0_36_373 VGND VGND VPWR VPWR sky130_fd_sc_hd__fill_1
XFILLER_0_106_261 VGND VGND VPWR VPWR sky130_fd_sc_hd__decap_6
XTAP_TAPCELL_ROW_114_1621 VGND VPWR sky130_fd_sc_hd__tapvpwrvgnd_1
X_5991_ net82 _2761_ VGND VGND VPWR VPWR _2762_ sky130_fd_sc_hd__xnor2_2
X_4942_ _1077_ _1730_ VGND VGND VPWR VPWR _1731_ sky130_fd_sc_hd__nand2_1
X_7730_ net174 _3414_ _3824_ VGND VGND VPWR VPWR _3827_ sky130_fd_sc_hd__mux2_1
X_7661_ _3790_ VGND VGND VPWR VPWR _0362_ sky130_fd_sc_hd__clkbuf_1
X_9400_ clknet_leaf_36_CLK _0633_ VGND VGND VPWR VPWR RF.reg_arr\[13\]\[26\] sky130_fd_sc_hd__dfxtp_1
X_4873_ _1637_ _1661_ _1644_ VGND VGND VPWR VPWR _1662_ sky130_fd_sc_hd__o21ai_1
X_6612_ _3215_ VGND VGND VPWR VPWR _0912_ sky130_fd_sc_hd__clkbuf_1
XFILLER_0_55_671 VGND VGND VPWR VPWR sky130_fd_sc_hd__fill_1
X_7592_ net476 _3412_ _3752_ VGND VGND VPWR VPWR _3754_ sky130_fd_sc_hd__mux2_1
X_9331_ clknet_leaf_48_CLK _0564_ VGND VGND VPWR VPWR RF.reg_arr\[20\]\[21\] sky130_fd_sc_hd__dfxtp_1
XFILLER_0_70_630 VGND VGND VPWR VPWR sky130_fd_sc_hd__decap_8
X_6543_ net880 _3033_ _3171_ VGND VGND VPWR VPWR _3179_ sky130_fd_sc_hd__mux2_1
XFILLER_0_15_568 VGND VGND VPWR VPWR sky130_fd_sc_hd__fill_1
X_6474_ net122 VGND VGND VPWR VPWR _3142_ sky130_fd_sc_hd__clkbuf_1
XFILLER_0_42_365 VGND VGND VPWR VPWR sky130_fd_sc_hd__fill_2
X_9262_ clknet_leaf_6_CLK _0495_ VGND VGND VPWR VPWR RF.reg_arr\[21\]\[16\] sky130_fd_sc_hd__dfxtp_1
X_8213_ _3029_ net529 _4077_ VGND VGND VPWR VPWR _4083_ sky130_fd_sc_hd__mux2_1
XPHY_EDGE_ROW_12_Right_12 VGND VGND VPWR VPWR sky130_fd_sc_hd__decap_3
X_5425_ _2212_ _2213_ _1610_ VGND VGND VPWR VPWR _2214_ sky130_fd_sc_hd__mux2_1
XFILLER_0_112_253 VGND VGND VPWR VPWR sky130_fd_sc_hd__decap_3
XTAP_TAPCELL_ROW_76_1159 VGND VPWR sky130_fd_sc_hd__tapvpwrvgnd_1
X_9193_ clknet_leaf_91_CLK _0426_ VGND VGND VPWR VPWR RF.reg_arr\[24\]\[11\] sky130_fd_sc_hd__dfxtp_1
X_8144_ _4046_ VGND VGND VPWR VPWR _0589_ sky130_fd_sc_hd__clkbuf_1
X_5356_ RF.reg_arr\[28\]\[15\] RF.reg_arr\[29\]\[15\] RF.reg_arr\[30\]\[15\] RF.reg_arr\[31\]\[15\]
+ _1847_ _1850_ VGND VGND VPWR VPWR _2145_ sky130_fd_sc_hd__mux4_1
X_8075_ _3027_ net1002 _4005_ VGND VGND VPWR VPWR _4010_ sky130_fd_sc_hd__mux2_1
X_4307_ RF.reg_arr\[16\]\[0\] RF.reg_arr\[17\]\[0\] RF.reg_arr\[18\]\[0\] RF.reg_arr\[19\]\[0\]
+ _1093_ _1094_ VGND VGND VPWR VPWR _1096_ sky130_fd_sc_hd__mux4_2
X_5287_ RF.reg_arr\[12\]\[11\] RF.reg_arr\[13\]\[11\] RF.reg_arr\[14\]\[11\] RF.reg_arr\[15\]\[11\]
+ _1591_ _1878_ VGND VGND VPWR VPWR _2076_ sky130_fd_sc_hd__mux4_1
X_7026_ _3452_ VGND VGND VPWR VPWR _0065_ sky130_fd_sc_hd__clkbuf_1
X_4238_ net88 VGND VGND VPWR VPWR _1027_ sky130_fd_sc_hd__clkbuf_8
XFILLER_0_97_505 VGND VGND VPWR VPWR sky130_fd_sc_hd__decap_3
XPHY_EDGE_ROW_21_Right_21 VGND VGND VPWR VPWR sky130_fd_sc_hd__decap_3
X_8977_ clknet_leaf_4_CLK _0210_ VGND VGND VPWR VPWR RF.reg_arr\[31\]\[19\] sky130_fd_sc_hd__dfxtp_1
XTAP_TAPCELL_ROW_87_1299 VGND VPWR sky130_fd_sc_hd__tapvpwrvgnd_1
X_7928_ _3016_ net846 _3922_ VGND VGND VPWR VPWR _3932_ sky130_fd_sc_hd__mux2_1
XFILLER_0_38_605 VGND VGND VPWR VPWR sky130_fd_sc_hd__fill_1
XTAP_TAPCELL_ROW_13_408 VGND VPWR sky130_fd_sc_hd__tapvpwrvgnd_1
X_7859_ _3895_ VGND VGND VPWR VPWR _0455_ sky130_fd_sc_hd__clkbuf_1
XTAP_TAPCELL_ROW_41_739 VGND VPWR sky130_fd_sc_hd__tapvpwrvgnd_1
XFILLER_0_21_505 VGND VGND VPWR VPWR sky130_fd_sc_hd__fill_2
XPHY_EDGE_ROW_30_Right_30 VGND VGND VPWR VPWR sky130_fd_sc_hd__decap_3
XFILLER_0_103_220 VGND VGND VPWR VPWR sky130_fd_sc_hd__decap_4
XFILLER_0_21_527 VGND VGND VPWR VPWR sky130_fd_sc_hd__decap_4
XFILLER_0_103_264 VGND VGND VPWR VPWR sky130_fd_sc_hd__decap_8
XFILLER_0_103_297 VGND VGND VPWR VPWR sky130_fd_sc_hd__decap_8
XFILLER_0_45_28 VGND VGND VPWR VPWR sky130_fd_sc_hd__fill_2
XTAP_TAPCELL_ROW_49_839 VGND VPWR sky130_fd_sc_hd__tapvpwrvgnd_1
XTAP_TAPCELL_ROW_29_596 VGND VPWR sky130_fd_sc_hd__tapvpwrvgnd_1
XFILLER_0_68_262 VGND VGND VPWR VPWR sky130_fd_sc_hd__decap_4
XFILLER_0_28_159 VGND VGND VPWR VPWR sky130_fd_sc_hd__decap_4
XFILLER_0_37_671 VGND VGND VPWR VPWR sky130_fd_sc_hd__fill_1
XFILLER_0_71_438 VGND VGND VPWR VPWR sky130_fd_sc_hd__decap_8
XFILLER_0_101_55 VGND VGND VPWR VPWR sky130_fd_sc_hd__fill_1
Xhold907 RF.reg_arr\[31\]\[12\] VGND VGND VPWR VPWR net989 sky130_fd_sc_hd__dlygate4sd3_1
Xhold918 RF.reg_arr\[14\]\[6\] VGND VGND VPWR VPWR net1000 sky130_fd_sc_hd__dlygate4sd3_1
X_5210_ _1981_ _1998_ VGND VGND VPWR VPWR _1999_ sky130_fd_sc_hd__nand2_1
Xhold929 RF.reg_arr\[27\]\[17\] VGND VGND VPWR VPWR net1011 sky130_fd_sc_hd__dlygate4sd3_1
X_6190_ _2029_ _1718_ _1774_ _2027_ VGND VGND VPWR VPWR _2949_ sky130_fd_sc_hd__a31o_1
X_5141_ _1894_ _1929_ _1738_ VGND VGND VPWR VPWR _1930_ sky130_fd_sc_hd__mux2_1
X_5072_ RF.reg_arr\[4\]\[22\] RF.reg_arr\[5\]\[22\] RF.reg_arr\[6\]\[22\] RF.reg_arr\[7\]\[22\]
+ _1857_ _1860_ VGND VGND VPWR VPWR _1861_ sky130_fd_sc_hd__mux4_1
X_8900_ clknet_leaf_89_CLK _0133_ VGND VGND VPWR VPWR RF.reg_arr\[7\]\[6\] sky130_fd_sc_hd__dfxtp_1
XFILLER_0_79_505 VPWR VGND VPWR VGND sky130_ef_sc_hd__decap_12
XFILLER_0_79_538 VGND VGND VPWR VPWR sky130_fd_sc_hd__decap_6
X_8831_ clknet_leaf_55_CLK _0064_ VGND VGND VPWR VPWR RF.reg_arr\[19\]\[1\] sky130_fd_sc_hd__dfxtp_1
X_8762_ clknet_leaf_29_CLK _1019_ VGND VGND VPWR VPWR RF.reg_arr\[6\]\[28\] sky130_fd_sc_hd__dfxtp_1
XFILLER_0_35_72 VGND VGND VPWR VPWR sky130_fd_sc_hd__decap_3
X_5974_ _2198_ _2715_ VGND VGND VPWR VPWR _2746_ sky130_fd_sc_hd__or2_1
X_7713_ net218 _3397_ _3813_ VGND VGND VPWR VPWR _3818_ sky130_fd_sc_hd__mux2_1
X_4925_ _1712_ _1713_ _1614_ VGND VGND VPWR VPWR _1714_ sky130_fd_sc_hd__mux2_1
X_8693_ clknet_leaf_40_CLK _0950_ VGND VGND VPWR VPWR RF.reg_arr\[15\]\[23\] sky130_fd_sc_hd__dfxtp_1
X_4856_ _1637_ _1640_ _1644_ VGND VGND VPWR VPWR _1645_ sky130_fd_sc_hd__o21ai_1
XFILLER_0_7_521 VGND VGND VPWR VPWR sky130_fd_sc_hd__decap_4
X_7644_ _3781_ VGND VGND VPWR VPWR _0354_ sky130_fd_sc_hd__clkbuf_1
X_7575_ net179 _3395_ _3741_ VGND VGND VPWR VPWR _3745_ sky130_fd_sc_hd__mux2_1
XFILLER_0_15_321 VPWR VGND VPWR VGND sky130_ef_sc_hd__decap_12
X_4787_ _1308_ _1575_ VGND VGND VPWR VPWR _1576_ sky130_fd_sc_hd__and2_1
X_6526_ net563 _3016_ _3160_ VGND VGND VPWR VPWR _3170_ sky130_fd_sc_hd__mux2_1
X_9314_ clknet_leaf_75_CLK _0547_ VGND VGND VPWR VPWR RF.reg_arr\[20\]\[4\] sky130_fd_sc_hd__dfxtp_1
XFILLER_0_113_573 VPWR VGND VPWR VGND sky130_ef_sc_hd__decap_12
X_9245_ clknet_leaf_18_CLK _0478_ VGND VGND VPWR VPWR RF.reg_arr\[22\]\[31\] sky130_fd_sc_hd__dfxtp_1
Xclkload80 clknet_leaf_82_CLK VGND VGND VPWR VPWR clkload80/Y sky130_fd_sc_hd__clkinv_4
X_6457_ _3133_ VGND VGND VPWR VPWR _0839_ sky130_fd_sc_hd__clkbuf_1
X_9176_ clknet_leaf_36_CLK _0409_ VGND VGND VPWR VPWR RF.reg_arr\[9\]\[26\] sky130_fd_sc_hd__dfxtp_1
Xclkload91 clknet_leaf_54_CLK VGND VGND VPWR VPWR clkload91/Y sky130_fd_sc_hd__inv_8
XFILLER_0_100_223 VGND VGND VPWR VPWR sky130_fd_sc_hd__fill_1
X_5408_ _1063_ _1816_ _1820_ _1824_ _1828_ VGND VGND VPWR VPWR _2197_ sky130_fd_sc_hd__a32oi_4
X_6388_ net20 VGND VGND VPWR VPWR _3090_ sky130_fd_sc_hd__clkbuf_2
XFILLER_0_100_245 VGND VGND VPWR VPWR sky130_fd_sc_hd__fill_1
X_8127_ _4037_ VGND VGND VPWR VPWR _0581_ sky130_fd_sc_hd__clkbuf_1
X_5339_ RF.reg_arr\[28\]\[14\] RF.reg_arr\[29\]\[14\] RF.reg_arr\[30\]\[14\] RF.reg_arr\[31\]\[14\]
+ _2087_ _1859_ VGND VGND VPWR VPWR _2128_ sky130_fd_sc_hd__mux4_1
XTAP_TAPCELL_ROW_89_1317 VGND VPWR sky130_fd_sc_hd__tapvpwrvgnd_1
X_8058_ _3010_ net1007 _3994_ VGND VGND VPWR VPWR _4001_ sky130_fd_sc_hd__mux2_1
X_7009_ _3442_ VGND VGND VPWR VPWR _0058_ sky130_fd_sc_hd__clkbuf_1
XFILLER_0_97_335 VGND VGND VPWR VPWR sky130_fd_sc_hd__fill_1
XTAP_TAPCELL_ROW_46_809 VGND VPWR sky130_fd_sc_hd__tapvpwrvgnd_1
XFILLER_0_97_368 VGND VGND VPWR VPWR sky130_fd_sc_hd__fill_1
XFILLER_0_78_560 VGND VGND VPWR VPWR sky130_fd_sc_hd__decap_6
XFILLER_0_93_530 VPWR VGND VPWR VGND sky130_ef_sc_hd__decap_12
XTAP_TAPCELL_ROW_26_566 VGND VPWR sky130_fd_sc_hd__tapvpwrvgnd_1
XFILLER_0_38_424 VGND VGND VPWR VPWR sky130_fd_sc_hd__fill_2
XFILLER_0_38_435 VGND VGND VPWR VPWR sky130_fd_sc_hd__fill_1
XTAP_TAPCELL_ROW_54_897 VGND VPWR sky130_fd_sc_hd__tapvpwrvgnd_1
XFILLER_0_53_416 VGND VGND VPWR VPWR sky130_fd_sc_hd__decap_3
XFILLER_0_108_345 VGND VGND VPWR VPWR sky130_fd_sc_hd__decap_8
XFILLER_0_108_389 VGND VGND VPWR VPWR sky130_fd_sc_hd__fill_2
XFILLER_0_34_685 VGND VGND VPWR VPWR sky130_fd_sc_hd__decap_6
XFILLER_0_104_573 VGND VGND VPWR VPWR sky130_fd_sc_hd__fill_1
XFILLER_0_21_324 VGND VGND VPWR VPWR sky130_fd_sc_hd__decap_3
XTAP_TAPCELL_ROW_109_1564 VGND VPWR sky130_fd_sc_hd__tapvpwrvgnd_1
XFILLER_0_76_519 VPWR VGND VPWR VGND sky130_ef_sc_hd__decap_12
XFILLER_0_96_390 VGND VGND VPWR VPWR sky130_fd_sc_hd__fill_2
XFILLER_0_29_424 VPWR VGND VPWR VGND sky130_ef_sc_hd__decap_12
X_5690_ _2396_ _2375_ _2028_ VGND VGND VPWR VPWR _2476_ sky130_fd_sc_hd__mux2_1
XFILLER_0_84_552 VPWR VGND VPWR VGND sky130_ef_sc_hd__decap_12
XFILLER_0_29_457 VGND VGND VPWR VPWR sky130_fd_sc_hd__decap_6
X_4710_ _1116_ _1490_ _1498_ VGND VGND VPWR VPWR _1499_ sky130_fd_sc_hd__o21ai_4
X_4641_ _1428_ _1429_ _1296_ VGND VGND VPWR VPWR _1430_ sky130_fd_sc_hd__mux2_1
XFILLER_0_114_359 VGND VGND VPWR VPWR sky130_fd_sc_hd__fill_2
X_4572_ _1359_ _1360_ _1049_ VGND VGND VPWR VPWR _1361_ sky130_fd_sc_hd__mux2_1
X_7360_ _2973_ _3057_ _2972_ _2975_ VGND VGND VPWR VPWR _3629_ sky130_fd_sc_hd__nand4b_4
Xhold737 RF.reg_arr\[26\]\[21\] VGND VGND VPWR VPWR net819 sky130_fd_sc_hd__dlygate4sd3_1
Xhold726 RF.reg_arr\[15\]\[20\] VGND VGND VPWR VPWR net808 sky130_fd_sc_hd__dlygate4sd3_1
Xhold704 RF.reg_arr\[26\]\[30\] VGND VGND VPWR VPWR net786 sky130_fd_sc_hd__dlygate4sd3_1
X_6311_ _2997_ VGND VGND VPWR VPWR _3040_ sky130_fd_sc_hd__clkbuf_8
X_7291_ _3592_ VGND VGND VPWR VPWR _0190_ sky130_fd_sc_hd__clkbuf_1
XFILLER_0_24_195 VGND VGND VPWR VPWR sky130_fd_sc_hd__fill_1
Xhold715 RF.reg_arr\[10\]\[18\] VGND VGND VPWR VPWR net797 sky130_fd_sc_hd__dlygate4sd3_1
Xhold759 RF.reg_arr\[8\]\[25\] VGND VGND VPWR VPWR net841 sky130_fd_sc_hd__dlygate4sd3_1
X_6242_ net38 VGND VGND VPWR VPWR _2992_ sky130_fd_sc_hd__buf_2
XTAP_TAPCELL_ROW_73_1129 VGND VPWR sky130_fd_sc_hd__tapvpwrvgnd_1
Xhold748 RF.reg_arr\[16\]\[14\] VGND VGND VPWR VPWR net830 sky130_fd_sc_hd__dlygate4sd3_1
X_9030_ clknet_leaf_82_CLK _0263_ VGND VGND VPWR VPWR RF.reg_arr\[26\]\[8\] sky130_fd_sc_hd__dfxtp_1
XFILLER_0_40_688 VGND VGND VPWR VPWR sky130_fd_sc_hd__fill_1
XFILLER_0_110_587 VGND VGND VPWR VPWR sky130_fd_sc_hd__fill_1
X_6173_ _2661_ _2714_ _2933_ VGND VGND VPWR VPWR _2934_ sky130_fd_sc_hd__o21ai_1
X_5124_ RF.reg_arr\[20\]\[21\] RF.reg_arr\[21\]\[21\] RF.reg_arr\[22\]\[21\] RF.reg_arr\[23\]\[21\]
+ _1677_ _1683_ VGND VGND VPWR VPWR _1913_ sky130_fd_sc_hd__mux4_1
X_5055_ _1634_ VGND VGND VPWR VPWR _1844_ sky130_fd_sc_hd__buf_4
XFILLER_0_27_3 VGND VGND VPWR VPWR sky130_fd_sc_hd__decap_6
X_8814_ clknet_leaf_9_CLK _0047_ VGND VGND VPWR VPWR RF.reg_arr\[4\]\[16\] sky130_fd_sc_hd__dfxtp_1
XTAP_TAPCELL_ROW_84_1258 VGND VPWR sky130_fd_sc_hd__tapvpwrvgnd_1
XFILLER_0_79_379 VGND VGND VPWR VPWR sky130_fd_sc_hd__decap_3
XFILLER_0_1_51 VGND VGND VPWR VPWR sky130_fd_sc_hd__decap_4
X_5957_ _2729_ _2652_ VGND VGND VPWR VPWR _2730_ sky130_fd_sc_hd__or2b_1
XFILLER_0_75_541 VGND VGND VPWR VPWR sky130_fd_sc_hd__fill_1
X_8745_ clknet_leaf_13_CLK _1002_ VGND VGND VPWR VPWR RF.reg_arr\[6\]\[11\] sky130_fd_sc_hd__dfxtp_1
X_4908_ _1649_ _1696_ VGND VGND VPWR VPWR _1697_ sky130_fd_sc_hd__nor2_1
X_8676_ clknet_leaf_84_CLK _0933_ VGND VGND VPWR VPWR RF.reg_arr\[15\]\[6\] sky130_fd_sc_hd__dfxtp_1
XTAP_TAPCELL_ROW_23_525 VGND VPWR sky130_fd_sc_hd__tapvpwrvgnd_1
X_7627_ net425 _3379_ _3763_ VGND VGND VPWR VPWR _3772_ sky130_fd_sc_hd__mux2_1
X_5888_ _2521_ _2661_ _2664_ VGND VGND VPWR VPWR _2665_ sky130_fd_sc_hd__o21a_1
XTAP_TAPCELL_ROW_51_867 VGND VPWR sky130_fd_sc_hd__tapvpwrvgnd_1
X_4839_ _1598_ VGND VGND VPWR VPWR _1628_ sky130_fd_sc_hd__buf_4
X_7558_ _3735_ VGND VGND VPWR VPWR _0314_ sky130_fd_sc_hd__clkbuf_1
XFILLER_0_15_140 VGND VGND VPWR VPWR sky130_fd_sc_hd__fill_1
X_7489_ _3117_ net802 _3689_ VGND VGND VPWR VPWR _3698_ sky130_fd_sc_hd__mux2_1
X_6509_ _3161_ VGND VGND VPWR VPWR _0863_ sky130_fd_sc_hd__clkbuf_1
XFILLER_0_43_482 VGND VGND VPWR VPWR sky130_fd_sc_hd__decap_6
XTAP_TAPCELL_ROW_95_1387 VGND VPWR sky130_fd_sc_hd__tapvpwrvgnd_1
X_9228_ clknet_leaf_101_CLK _0461_ VGND VGND VPWR VPWR RF.reg_arr\[22\]\[14\] sky130_fd_sc_hd__dfxtp_1
XFILLER_0_30_187 VGND VGND VPWR VPWR sky130_fd_sc_hd__decap_8
XFILLER_0_101_587 VPWR VGND VPWR VGND sky130_ef_sc_hd__decap_12
X_9159_ clknet_leaf_63_CLK _0392_ VGND VGND VPWR VPWR RF.reg_arr\[9\]\[9\] sky130_fd_sc_hd__dfxtp_1
Xhold20 RF.reg_arr\[0\]\[27\] VGND VGND VPWR VPWR net102 sky130_fd_sc_hd__dlygate4sd3_1
Xhold31 RF.reg_arr\[0\]\[2\] VGND VGND VPWR VPWR net113 sky130_fd_sc_hd__dlygate4sd3_1
Xhold64 RF.reg_arr\[7\]\[22\] VGND VGND VPWR VPWR net146 sky130_fd_sc_hd__dlygate4sd3_1
XTAP_TAPCELL_ROW_59_956 VGND VPWR sky130_fd_sc_hd__tapvpwrvgnd_1
XFILLER_0_26_19 VGND VGND VPWR VPWR sky130_fd_sc_hd__fill_1
Xhold53 RF.reg_arr\[6\]\[15\] VGND VGND VPWR VPWR net135 sky130_fd_sc_hd__dlygate4sd3_1
Xhold42 RF.reg_arr\[0\]\[4\] VGND VGND VPWR VPWR net124 sky130_fd_sc_hd__dlygate4sd3_1
Xhold75 RF.reg_arr\[3\]\[20\] VGND VGND VPWR VPWR net157 sky130_fd_sc_hd__dlygate4sd3_1
Xhold86 RF.reg_arr\[9\]\[20\] VGND VGND VPWR VPWR net168 sky130_fd_sc_hd__dlygate4sd3_1
Xhold97 RF.reg_arr\[2\]\[3\] VGND VGND VPWR VPWR net179 sky130_fd_sc_hd__dlygate4sd3_1
XTAP_TAPCELL_ROW_3_283 VGND VPWR sky130_fd_sc_hd__tapvpwrvgnd_1
XFILLER_0_98_677 VGND VGND VPWR VPWR sky130_fd_sc_hd__fill_1
XFILLER_0_97_165 VGND VGND VPWR VPWR sky130_fd_sc_hd__decap_3
XFILLER_0_109_610 VGND VGND VPWR VPWR sky130_fd_sc_hd__fill_1
XTAP_TAPCELL_ROW_104_1494 VGND VPWR sky130_fd_sc_hd__tapvpwrvgnd_1
XFILLER_0_109_654 VGND VGND VPWR VPWR sky130_fd_sc_hd__decap_6
XFILLER_0_81_544 VPWR VGND VPWR VGND sky130_ef_sc_hd__decap_12
XANTENNA_6 WD3[23] VGND VGND VPWR VPWR sky130_fd_sc_hd__diode_2
XFILLER_0_61_290 VGND VGND VPWR VPWR sky130_fd_sc_hd__decap_8
XFILLER_0_6_29 VGND VGND VPWR VPWR sky130_fd_sc_hd__decap_4
XFILLER_0_22_688 VGND VGND VPWR VPWR sky130_fd_sc_hd__decap_4
Xrebuffer18 _2832_ VGND VGND VPWR VPWR net1127 sky130_fd_sc_hd__dlygate4sd1_1
X_6860_ net606 _3006_ _3344_ VGND VGND VPWR VPWR _3349_ sky130_fd_sc_hd__mux2_1
X_5811_ _2441_ _2492_ _1738_ VGND VGND VPWR VPWR _2592_ sky130_fd_sc_hd__mux2_1
X_6791_ net709 _3006_ _3307_ VGND VGND VPWR VPWR _3312_ sky130_fd_sc_hd__mux2_1
X_5742_ _2522_ _2524_ _2361_ VGND VGND VPWR VPWR _2525_ sky130_fd_sc_hd__mux2_1
X_8530_ clknet_leaf_14_CLK _0787_ VGND VGND VPWR VPWR RF.reg_arr\[1\]\[20\] sky130_fd_sc_hd__dfxtp_1
XFILLER_0_29_287 VGND VGND VPWR VPWR sky130_fd_sc_hd__decap_4
X_5673_ _2450_ _2452_ _2458_ VGND VGND VPWR VPWR _2459_ sky130_fd_sc_hd__o21ai_1
XFILLER_0_17_449 VGND VGND VPWR VPWR sky130_fd_sc_hd__fill_2
X_8461_ net636 net40 _4211_ VGND VGND VPWR VPWR _4214_ sky130_fd_sc_hd__mux2_1
X_7412_ _3109_ net758 _3652_ VGND VGND VPWR VPWR _3657_ sky130_fd_sc_hd__mux2_1
XPHY_EDGE_ROW_6_Right_6 VGND VGND VPWR VPWR sky130_fd_sc_hd__decap_3
X_4624_ _1411_ _1412_ _1034_ VGND VGND VPWR VPWR _1413_ sky130_fd_sc_hd__mux2_1
X_8392_ net486 _3395_ _4174_ VGND VGND VPWR VPWR _4178_ sky130_fd_sc_hd__mux2_1
Xhold501 RF.reg_arr\[3\]\[28\] VGND VGND VPWR VPWR net583 sky130_fd_sc_hd__dlygate4sd3_1
X_7343_ _3620_ VGND VGND VPWR VPWR _0214_ sky130_fd_sc_hd__clkbuf_1
X_4555_ RF.reg_arr\[4\]\[20\] RF.reg_arr\[5\]\[20\] RF.reg_arr\[6\]\[20\] RF.reg_arr\[7\]\[20\]
+ _1342_ _1343_ VGND VGND VPWR VPWR _1344_ sky130_fd_sc_hd__mux4_1
Xhold534 RF.reg_arr\[31\]\[26\] VGND VGND VPWR VPWR net616 sky130_fd_sc_hd__dlygate4sd3_1
Xhold545 RF.reg_arr\[10\]\[6\] VGND VGND VPWR VPWR net627 sky130_fd_sc_hd__dlygate4sd3_1
Xhold523 RF.reg_arr\[3\]\[16\] VGND VGND VPWR VPWR net605 sky130_fd_sc_hd__dlygate4sd3_1
Xhold512 RF.reg_arr\[20\]\[11\] VGND VGND VPWR VPWR net594 sky130_fd_sc_hd__dlygate4sd3_1
X_4486_ _1176_ VGND VGND VPWR VPWR _1275_ sky130_fd_sc_hd__clkbuf_4
X_9013_ clknet_leaf_25_CLK _0246_ VGND VGND VPWR VPWR RF.reg_arr\[27\]\[23\] sky130_fd_sc_hd__dfxtp_1
X_7274_ _3107_ net549 _3580_ VGND VGND VPWR VPWR _3584_ sky130_fd_sc_hd__mux2_1
XFILLER_0_12_165 VGND VGND VPWR VPWR sky130_fd_sc_hd__decap_3
Xhold567 RF.reg_arr\[7\]\[5\] VGND VGND VPWR VPWR net649 sky130_fd_sc_hd__dlygate4sd3_1
Xhold556 RF.reg_arr\[12\]\[4\] VGND VGND VPWR VPWR net638 sky130_fd_sc_hd__dlygate4sd3_1
Xhold578 RF.reg_arr\[2\]\[4\] VGND VGND VPWR VPWR net660 sky130_fd_sc_hd__dlygate4sd3_1
XFILLER_0_110_384 VGND VGND VPWR VPWR sky130_fd_sc_hd__decap_8
X_6225_ net152 _2980_ _2978_ VGND VGND VPWR VPWR _2981_ sky130_fd_sc_hd__mux2_1
Xhold589 RF.reg_arr\[8\]\[21\] VGND VGND VPWR VPWR net671 sky130_fd_sc_hd__dlygate4sd3_1
X_6156_ _1716_ _2915_ VGND VGND VPWR VPWR _2917_ sky130_fd_sc_hd__and2_1
XFILLER_0_99_419 VGND VGND VPWR VPWR sky130_fd_sc_hd__decap_4
X_5107_ RF.reg_arr\[20\]\[20\] RF.reg_arr\[21\]\[20\] RF.reg_arr\[22\]\[20\] RF.reg_arr\[23\]\[20\]
+ _1848_ _1851_ VGND VGND VPWR VPWR _1896_ sky130_fd_sc_hd__mux4_1
XFILLER_0_57_92 VGND VGND VPWR VPWR sky130_fd_sc_hd__fill_2
X_6087_ _2793_ _2850_ _2851_ VGND VGND VPWR VPWR _2852_ sky130_fd_sc_hd__or3_4
XTAP_TAPCELL_ROW_56_926 VGND VPWR sky130_fd_sc_hd__tapvpwrvgnd_1
X_5038_ _1825_ _1826_ net6 VGND VGND VPWR VPWR _1827_ sky130_fd_sc_hd__mux2_1
XTAP_TAPCELL_ROW_0_242 VGND VPWR sky130_fd_sc_hd__tapvpwrvgnd_1
XTAP_TAPCELL_ROW_0_253 VGND VPWR sky130_fd_sc_hd__tapvpwrvgnd_1
XFILLER_0_95_658 VPWR VGND VPWR VGND sky130_ef_sc_hd__decap_12
XFILLER_0_95_636 VGND VGND VPWR VPWR sky130_fd_sc_hd__decap_4
X_8728_ clknet_leaf_35_CLK _0985_ VGND VGND VPWR VPWR RF.reg_arr\[14\]\[26\] sky130_fd_sc_hd__dfxtp_1
X_6989_ net26 VGND VGND VPWR VPWR _3430_ sky130_fd_sc_hd__buf_2
XTAP_TAPCELL_ROW_36_683 VGND VPWR sky130_fd_sc_hd__tapvpwrvgnd_1
X_8659_ clknet_leaf_45_CLK _0916_ VGND VGND VPWR VPWR RF.reg_arr\[8\]\[21\] sky130_fd_sc_hd__dfxtp_1
XFILLER_0_75_393 VGND VGND VPWR VPWR sky130_fd_sc_hd__fill_1
XTAP_TAPCELL_ROW_97_1416 VGND VPWR sky130_fd_sc_hd__tapvpwrvgnd_1
XFILLER_0_31_452 VGND VGND VPWR VPWR sky130_fd_sc_hd__decap_8
XFILLER_0_43_290 VGND VGND VPWR VPWR sky130_fd_sc_hd__decap_4
Xoutput65 net65 VGND VGND VPWR VPWR result[24] sky130_fd_sc_hd__clkbuf_4
Xoutput54 net54 VGND VGND VPWR VPWR result[14] sky130_fd_sc_hd__clkbuf_4
Xoutput76 net76 VGND VGND VPWR VPWR result[5] sky130_fd_sc_hd__clkbuf_4
XTAP_TAPCELL_ROW_8_353 VGND VPWR sky130_fd_sc_hd__tapvpwrvgnd_1
XTAP_TAPCELL_ROW_8_342 VGND VPWR sky130_fd_sc_hd__tapvpwrvgnd_1
Xclkbuf_leaf_103_CLK clknet_3_1__leaf_CLK VGND VGND VPWR VPWR clknet_leaf_103_CLK
+ sky130_fd_sc_hd__clkbuf_8
XTAP_TAPCELL_ROW_106_1523 VGND VPWR sky130_fd_sc_hd__tapvpwrvgnd_1
XFILLER_0_85_113 VGND VGND VPWR VPWR sky130_fd_sc_hd__fill_1
XPHY_EDGE_ROW_59_Right_59 VGND VGND VPWR VPWR sky130_fd_sc_hd__decap_3
XFILLER_0_54_533 VGND VGND VPWR VPWR sky130_fd_sc_hd__decap_6
XFILLER_0_81_374 VGND VGND VPWR VPWR sky130_fd_sc_hd__decap_6
XFILLER_0_54_566 VGND VGND VPWR VPWR sky130_fd_sc_hd__decap_6
XFILLER_0_111_126 VGND VGND VPWR VPWR sky130_fd_sc_hd__fill_1
XFILLER_0_105_690 VGND VGND VPWR VPWR sky130_fd_sc_hd__fill_2
X_4340_ _1044_ VGND VGND VPWR VPWR _1129_ sky130_fd_sc_hd__clkbuf_8
X_4271_ _1057_ _1058_ _1059_ VGND VGND VPWR VPWR _1060_ sky130_fd_sc_hd__mux2_1
X_6010_ _2418_ _2471_ _2633_ _2718_ _2779_ VGND VGND VPWR VPWR _2780_ sky130_fd_sc_hd__o221a_1
XPHY_EDGE_ROW_68_Right_68 VGND VGND VPWR VPWR sky130_fd_sc_hd__decap_3
X_7961_ _3949_ VGND VGND VPWR VPWR _0503_ sky130_fd_sc_hd__clkbuf_1
XFILLER_0_89_441 VGND VGND VPWR VPWR sky130_fd_sc_hd__fill_1
X_7892_ _3109_ net539 _3908_ VGND VGND VPWR VPWR _3913_ sky130_fd_sc_hd__mux2_1
X_6912_ net367 _3377_ _3366_ VGND VGND VPWR VPWR _3378_ sky130_fd_sc_hd__mux2_1
X_6843_ net204 _2988_ _3329_ VGND VGND VPWR VPWR _3339_ sky130_fd_sc_hd__mux2_1
XFILLER_0_89_496 VGND VGND VPWR VPWR sky130_fd_sc_hd__decap_4
XTAP_TAPCELL_ROW_81_1228 VGND VPWR sky130_fd_sc_hd__tapvpwrvgnd_1
X_6774_ _3119_ net1020 _3292_ VGND VGND VPWR VPWR _3302_ sky130_fd_sc_hd__mux2_1
XFILLER_0_91_105 VGND VGND VPWR VPWR sky130_fd_sc_hd__fill_1
XPHY_EDGE_ROW_77_Right_77 VGND VGND VPWR VPWR sky130_fd_sc_hd__decap_3
XTAP_TAPCELL_ROW_33_642 VGND VPWR sky130_fd_sc_hd__tapvpwrvgnd_1
XTAP_TAPCELL_ROW_33_653 VGND VPWR sky130_fd_sc_hd__tapvpwrvgnd_1
X_5725_ _2472_ _2508_ _2000_ VGND VGND VPWR VPWR _2509_ sky130_fd_sc_hd__mux2_1
X_9493_ clknet_leaf_40_CLK _0726_ VGND VGND VPWR VPWR RF.reg_arr\[11\]\[23\] sky130_fd_sc_hd__dfxtp_1
XTAP_TAPCELL_ROW_61_984 VGND VPWR sky130_fd_sc_hd__tapvpwrvgnd_1
X_8513_ clknet_leaf_65_CLK _0770_ VGND VGND VPWR VPWR RF.reg_arr\[1\]\[3\] sky130_fd_sc_hd__dfxtp_1
X_8444_ net524 net34 _4196_ VGND VGND VPWR VPWR _4205_ sky130_fd_sc_hd__mux2_1
XFILLER_0_94_3 VPWR VGND VPWR VGND sky130_ef_sc_hd__decap_12
X_5656_ _1024_ VGND VGND VPWR VPWR _2443_ sky130_fd_sc_hd__buf_2
XFILLER_0_60_514 VGND VGND VPWR VPWR sky130_fd_sc_hd__fill_1
X_4607_ _1062_ _1395_ VGND VGND VPWR VPWR _1396_ sky130_fd_sc_hd__nand2_1
X_8375_ _4168_ VGND VGND VPWR VPWR _0698_ sky130_fd_sc_hd__clkbuf_1
X_5587_ _2373_ _2374_ VGND VGND VPWR VPWR _2375_ sky130_fd_sc_hd__nand2_1
XFILLER_0_5_685 VGND VGND VPWR VPWR sky130_fd_sc_hd__decap_6
Xhold320 RF.reg_arr\[11\]\[0\] VGND VGND VPWR VPWR net402 sky130_fd_sc_hd__dlygate4sd3_1
Xhold342 RF.reg_arr\[17\]\[1\] VGND VGND VPWR VPWR net424 sky130_fd_sc_hd__dlygate4sd3_1
X_4538_ _1164_ VGND VGND VPWR VPWR _1327_ sky130_fd_sc_hd__buf_6
X_7326_ _3611_ VGND VGND VPWR VPWR _0206_ sky130_fd_sc_hd__clkbuf_1
Xhold353 RF.reg_arr\[28\]\[18\] VGND VGND VPWR VPWR net435 sky130_fd_sc_hd__dlygate4sd3_1
Xhold331 RF.reg_arr\[17\]\[19\] VGND VGND VPWR VPWR net413 sky130_fd_sc_hd__dlygate4sd3_1
XTAP_TAPCELL_ROW_92_1357 VGND VPWR sky130_fd_sc_hd__tapvpwrvgnd_1
Xhold386 RF.reg_arr\[7\]\[30\] VGND VGND VPWR VPWR net468 sky130_fd_sc_hd__dlygate4sd3_1
Xhold364 RF.reg_arr\[17\]\[17\] VGND VGND VPWR VPWR net446 sky130_fd_sc_hd__dlygate4sd3_1
X_7257_ _3090_ net843 _3569_ VGND VGND VPWR VPWR _3575_ sky130_fd_sc_hd__mux2_1
Xhold375 RF.reg_arr\[4\]\[16\] VGND VGND VPWR VPWR net457 sky130_fd_sc_hd__dlygate4sd3_1
X_4469_ RF.reg_arr\[28\]\[11\] RF.reg_arr\[29\]\[11\] RF.reg_arr\[30\]\[11\] RF.reg_arr\[31\]\[11\]
+ net98 _1106_ VGND VGND VPWR VPWR _1258_ sky130_fd_sc_hd__mux4_2
X_6208_ _2276_ _2942_ _2965_ _2420_ VGND VGND VPWR VPWR _2966_ sky130_fd_sc_hd__o211a_1
XPHY_EDGE_ROW_86_Right_86 VGND VGND VPWR VPWR sky130_fd_sc_hd__decap_3
XTAP_TAPCELL_ROW_5_312 VGND VPWR sky130_fd_sc_hd__tapvpwrvgnd_1
Xhold397 RF.reg_arr\[13\]\[19\] VGND VGND VPWR VPWR net479 sky130_fd_sc_hd__dlygate4sd3_1
X_7188_ net159 _3420_ _3532_ VGND VGND VPWR VPWR _3538_ sky130_fd_sc_hd__mux2_1
X_6139_ _1772_ _2899_ VGND VGND VPWR VPWR _2901_ sky130_fd_sc_hd__nor2_1
Xhold1031 RF.reg_arr\[22\]\[17\] VGND VGND VPWR VPWR net1113 sky130_fd_sc_hd__dlygate4sd3_1
Xhold1020 RF.reg_arr\[30\]\[19\] VGND VGND VPWR VPWR net1102 sky130_fd_sc_hd__dlygate4sd3_1
XPHY_EDGE_ROW_95_Right_95 VGND VGND VPWR VPWR sky130_fd_sc_hd__decap_3
XTAP_TAPCELL_ROW_101_1464 VGND VPWR sky130_fd_sc_hd__tapvpwrvgnd_1
XFILLER_0_82_138 VGND VGND VPWR VPWR sky130_fd_sc_hd__fill_2
XFILLER_0_23_205 VGND VGND VPWR VPWR sky130_fd_sc_hd__decap_4
Xrebuffer9 _2700_ VGND VGND VPWR VPWR net91 sky130_fd_sc_hd__dlygate4sd1_1
XFILLER_0_51_536 VGND VGND VPWR VPWR sky130_fd_sc_hd__decap_4
XPHY_EDGE_ROW_39_Left_156 VGND VGND VPWR VPWR sky130_fd_sc_hd__decap_3
XTAP_TAPCELL_ROW_112_1593 VGND VPWR sky130_fd_sc_hd__tapvpwrvgnd_1
XPHY_EDGE_ROW_48_Left_165 VGND VGND VPWR VPWR sky130_fd_sc_hd__decap_3
XTAP_TAPCELL_ROW_67_1061 VGND VPWR sky130_fd_sc_hd__tapvpwrvgnd_1
XTAP_TAPCELL_ROW_67_1050 VGND VPWR sky130_fd_sc_hd__tapvpwrvgnd_1
XFILLER_0_104_77 VGND VGND VPWR VPWR sky130_fd_sc_hd__decap_6
XFILLER_0_67_691 VGND VGND VPWR VPWR sky130_fd_sc_hd__fill_1
XFILLER_0_13_75 VGND VGND VPWR VPWR sky130_fd_sc_hd__decap_6
XTAP_TAPCELL_ROW_30_612 VGND VPWR sky130_fd_sc_hd__tapvpwrvgnd_1
XFILLER_0_39_393 VGND VGND VPWR VPWR sky130_fd_sc_hd__fill_2
X_5510_ _2297_ _2298_ _1609_ VGND VGND VPWR VPWR _2299_ sky130_fd_sc_hd__mux2_1
X_6490_ net116 VGND VGND VPWR VPWR _3150_ sky130_fd_sc_hd__clkbuf_1
XFILLER_0_14_249 VGND VGND VPWR VPWR sky130_fd_sc_hd__decap_3
X_5441_ _1603_ _2229_ VGND VGND VPWR VPWR _2230_ sky130_fd_sc_hd__and2_1
XPHY_EDGE_ROW_57_Left_174 VGND VGND VPWR VPWR sky130_fd_sc_hd__decap_3
XTAP_TAPCELL_ROW_78_1190 VGND VPWR sky130_fd_sc_hd__tapvpwrvgnd_1
X_8160_ net344 _3435_ _4052_ VGND VGND VPWR VPWR _4055_ sky130_fd_sc_hd__mux2_1
X_5372_ RF.reg_arr\[16\]\[12\] RF.reg_arr\[17\]\[12\] RF.reg_arr\[18\]\[12\] RF.reg_arr\[19\]\[12\]
+ _1622_ _1595_ VGND VGND VPWR VPWR _2161_ sky130_fd_sc_hd__mux4_1
X_8091_ _4018_ VGND VGND VPWR VPWR _0564_ sky130_fd_sc_hd__clkbuf_1
X_4323_ _1100_ _1111_ VGND VGND VPWR VPWR _1112_ sky130_fd_sc_hd__or2_1
X_7111_ _3497_ VGND VGND VPWR VPWR _0105_ sky130_fd_sc_hd__clkbuf_1
XFILLER_0_10_477 VGND VGND VPWR VPWR sky130_fd_sc_hd__fill_1
X_7042_ net795 _3409_ _3460_ VGND VGND VPWR VPWR _3461_ sky130_fd_sc_hd__mux2_1
X_4254_ A2[0] VGND VGND VPWR VPWR _1043_ sky130_fd_sc_hd__buf_4
XPHY_EDGE_ROW_66_Left_183 VGND VGND VPWR VPWR sky130_fd_sc_hd__decap_3
XTAP_TAPCELL_ROW_38_712 VGND VPWR sky130_fd_sc_hd__tapvpwrvgnd_1
X_8993_ clknet_leaf_69_CLK _0226_ VGND VGND VPWR VPWR RF.reg_arr\[27\]\[3\] sky130_fd_sc_hd__dfxtp_1
XFILLER_0_96_219 VGND VGND VPWR VPWR sky130_fd_sc_hd__fill_1
X_7944_ _3940_ VGND VGND VPWR VPWR _0495_ sky130_fd_sc_hd__clkbuf_1
X_7875_ _3092_ net1031 _3897_ VGND VGND VPWR VPWR _3904_ sky130_fd_sc_hd__mux2_1
XFILLER_0_92_403 VGND VGND VPWR VPWR sky130_fd_sc_hd__decap_4
X_6826_ _3330_ VGND VGND VPWR VPWR _1011_ sky130_fd_sc_hd__clkbuf_1
XFILLER_0_65_639 VGND VGND VPWR VPWR sky130_fd_sc_hd__decap_6
XFILLER_0_65_617 VGND VGND VPWR VPWR sky130_fd_sc_hd__decap_3
XFILLER_0_80_609 VGND VGND VPWR VPWR sky130_fd_sc_hd__fill_2
X_6757_ _3293_ VGND VGND VPWR VPWR _0979_ sky130_fd_sc_hd__clkbuf_1
XFILLER_0_18_522 VGND VGND VPWR VPWR sky130_fd_sc_hd__fill_2
XFILLER_0_18_533 VGND VGND VPWR VPWR sky130_fd_sc_hd__fill_2
X_5708_ _2441_ _2492_ _1738_ VGND VGND VPWR VPWR _2493_ sky130_fd_sc_hd__mux2_1
X_6688_ _3103_ net951 _3254_ VGND VGND VPWR VPWR _3256_ sky130_fd_sc_hd__mux2_1
XPHY_EDGE_ROW_75_Left_192 VGND VGND VPWR VPWR sky130_fd_sc_hd__decap_3
X_9476_ clknet_leaf_85_CLK _0709_ VGND VGND VPWR VPWR RF.reg_arr\[11\]\[6\] sky130_fd_sc_hd__dfxtp_1
X_5639_ _1648_ _2104_ VGND VGND VPWR VPWR _2426_ sky130_fd_sc_hd__nand2_1
X_8427_ _4173_ VGND VGND VPWR VPWR _4196_ sky130_fd_sc_hd__clkbuf_8
XFILLER_0_103_457 VGND VGND VPWR VPWR sky130_fd_sc_hd__fill_2
X_8358_ _4159_ VGND VGND VPWR VPWR _0690_ sky130_fd_sc_hd__clkbuf_1
Xhold150 RF.reg_arr\[19\]\[7\] VGND VGND VPWR VPWR net232 sky130_fd_sc_hd__dlygate4sd3_1
X_7309_ _3602_ VGND VGND VPWR VPWR _0198_ sky130_fd_sc_hd__clkbuf_1
Xhold161 RF.reg_arr\[7\]\[6\] VGND VGND VPWR VPWR net243 sky130_fd_sc_hd__dlygate4sd3_1
Xhold194 RF.reg_arr\[2\]\[22\] VGND VGND VPWR VPWR net276 sky130_fd_sc_hd__dlygate4sd3_1
Xhold183 RF.reg_arr\[18\]\[12\] VGND VGND VPWR VPWR net265 sky130_fd_sc_hd__dlygate4sd3_1
Xhold172 RF.reg_arr\[5\]\[18\] VGND VGND VPWR VPWR net254 sky130_fd_sc_hd__dlygate4sd3_1
X_8289_ net413 _3428_ _4113_ VGND VGND VPWR VPWR _4123_ sky130_fd_sc_hd__mux2_1
XTAP_TAPCELL_ROW_16_439 VGND VPWR sky130_fd_sc_hd__tapvpwrvgnd_1
XFILLER_0_28_319 VGND VGND VPWR VPWR sky130_fd_sc_hd__decap_4
XFILLER_0_83_447 VGND VGND VPWR VPWR sky130_fd_sc_hd__fill_1
XTAP_TAPCELL_ROW_114_1622 VGND VPWR sky130_fd_sc_hd__tapvpwrvgnd_1
XFILLER_0_91_14 VGND VGND VPWR VPWR sky130_fd_sc_hd__fill_1
XFILLER_0_91_47 VGND VGND VPWR VPWR sky130_fd_sc_hd__decap_8
X_5990_ _2760_ _1205_ VGND VGND VPWR VPWR _2761_ sky130_fd_sc_hd__xor2_2
X_4941_ _1728_ _1729_ _1041_ VGND VGND VPWR VPWR _1730_ sky130_fd_sc_hd__mux2_1
X_4872_ _1659_ _1660_ _1614_ VGND VGND VPWR VPWR _1661_ sky130_fd_sc_hd__mux2_1
XFILLER_0_24_52 VGND VGND VPWR VPWR sky130_fd_sc_hd__decap_3
X_7660_ _3082_ net851 _3788_ VGND VGND VPWR VPWR _3790_ sky130_fd_sc_hd__mux2_1
X_6611_ net818 _3033_ _3207_ VGND VGND VPWR VPWR _3215_ sky130_fd_sc_hd__mux2_1
XTAP_TAPCELL_ROW_43_770 VGND VPWR sky130_fd_sc_hd__tapvpwrvgnd_1
X_9330_ clknet_leaf_15_CLK _0563_ VGND VGND VPWR VPWR RF.reg_arr\[20\]\[20\] sky130_fd_sc_hd__dfxtp_1
X_7591_ _3753_ VGND VGND VPWR VPWR _0329_ sky130_fd_sc_hd__clkbuf_1
X_6542_ _3178_ VGND VGND VPWR VPWR _0879_ sky130_fd_sc_hd__clkbuf_1
Xclkbuf_leaf_92_CLK clknet_3_4__leaf_CLK VGND VGND VPWR VPWR clknet_leaf_92_CLK sky130_fd_sc_hd__clkbuf_8
X_9261_ clknet_leaf_104_CLK _0494_ VGND VGND VPWR VPWR RF.reg_arr\[21\]\[15\] sky130_fd_sc_hd__dfxtp_1
X_6473_ _3141_ VGND VGND VPWR VPWR _0847_ sky130_fd_sc_hd__clkbuf_1
X_8212_ _4082_ VGND VGND VPWR VPWR _0621_ sky130_fd_sc_hd__clkbuf_1
X_5424_ RF.reg_arr\[0\]\[4\] RF.reg_arr\[1\]\[4\] RF.reg_arr\[2\]\[4\] RF.reg_arr\[3\]\[4\]
+ _1674_ _1680_ VGND VGND VPWR VPWR _2213_ sky130_fd_sc_hd__mux4_1
X_9192_ clknet_leaf_10_CLK _0425_ VGND VGND VPWR VPWR RF.reg_arr\[24\]\[10\] sky130_fd_sc_hd__dfxtp_1
XFILLER_0_112_265 VGND VGND VPWR VPWR sky130_fd_sc_hd__fill_1
X_8143_ net893 _3418_ _4041_ VGND VGND VPWR VPWR _4046_ sky130_fd_sc_hd__mux2_1
X_5355_ _2142_ _2143_ _1864_ VGND VGND VPWR VPWR _2144_ sky130_fd_sc_hd__mux2_1
XFILLER_0_10_296 VGND VGND VPWR VPWR sky130_fd_sc_hd__decap_3
X_4306_ RF.reg_arr\[20\]\[0\] RF.reg_arr\[21\]\[0\] RF.reg_arr\[22\]\[0\] RF.reg_arr\[23\]\[0\]
+ _1093_ _1094_ VGND VGND VPWR VPWR _1095_ sky130_fd_sc_hd__mux4_2
X_8074_ _4009_ VGND VGND VPWR VPWR _0556_ sky130_fd_sc_hd__clkbuf_1
X_5286_ RF.reg_arr\[8\]\[11\] RF.reg_arr\[9\]\[11\] RF.reg_arr\[10\]\[11\] RF.reg_arr\[11\]\[11\]
+ _1591_ _1878_ VGND VGND VPWR VPWR _2075_ sky130_fd_sc_hd__mux4_1
X_7025_ net599 _3393_ _3449_ VGND VGND VPWR VPWR _3452_ sky130_fd_sc_hd__mux2_1
X_4237_ A2[0] VGND VGND VPWR VPWR _1026_ sky130_fd_sc_hd__buf_12
X_8976_ clknet_leaf_0_CLK _0209_ VGND VGND VPWR VPWR RF.reg_arr\[31\]\[18\] sky130_fd_sc_hd__dfxtp_1
X_7927_ _3931_ VGND VGND VPWR VPWR _0487_ sky130_fd_sc_hd__clkbuf_1
X_7858_ _3075_ net977 _3886_ VGND VGND VPWR VPWR _3895_ sky130_fd_sc_hd__mux2_1
XFILLER_0_38_639 VGND VGND VPWR VPWR sky130_fd_sc_hd__decap_4
XFILLER_0_108_505 VPWR VGND VPWR VGND sky130_ef_sc_hd__decap_12
XFILLER_0_92_222 VGND VGND VPWR VPWR sky130_fd_sc_hd__decap_6
XFILLER_0_92_211 VGND VGND VPWR VPWR sky130_fd_sc_hd__fill_1
XPHY_EDGE_ROW_83_Left_200 VGND VGND VPWR VPWR sky130_fd_sc_hd__decap_3
XFILLER_0_65_447 VGND VGND VPWR VPWR sky130_fd_sc_hd__fill_1
XTAP_TAPCELL_ROW_13_409 VGND VPWR sky130_fd_sc_hd__tapvpwrvgnd_1
X_6809_ _3321_ VGND VGND VPWR VPWR _1003_ sky130_fd_sc_hd__clkbuf_1
XFILLER_0_80_417 VGND VGND VPWR VPWR sky130_fd_sc_hd__decap_3
X_7789_ _3075_ net1063 _3849_ VGND VGND VPWR VPWR _3858_ sky130_fd_sc_hd__mux2_1
Xclkbuf_leaf_83_CLK clknet_3_4__leaf_CLK VGND VGND VPWR VPWR clknet_leaf_83_CLK sky130_fd_sc_hd__clkbuf_8
XFILLER_0_18_363 VGND VGND VPWR VPWR sky130_fd_sc_hd__fill_1
X_9459_ clknet_leaf_46_CLK _0692_ VGND VGND VPWR VPWR RF.reg_arr\[12\]\[21\] sky130_fd_sc_hd__dfxtp_1
XFILLER_0_45_18 VGND VGND VPWR VPWR sky130_fd_sc_hd__fill_1
XTAP_TAPCELL_ROW_29_597 VGND VPWR sky130_fd_sc_hd__tapvpwrvgnd_1
XTAP_TAPCELL_ROW_64_1020 VGND VPWR sky130_fd_sc_hd__tapvpwrvgnd_1
XFILLER_0_56_447 VGND VGND VPWR VPWR sky130_fd_sc_hd__decap_8
XFILLER_0_83_255 VGND VGND VPWR VPWR sky130_fd_sc_hd__fill_1
XFILLER_0_83_277 VGND VGND VPWR VPWR sky130_fd_sc_hd__decap_3
XFILLER_0_71_428 VGND VGND VPWR VPWR sky130_fd_sc_hd__fill_1
Xclkbuf_leaf_74_CLK clknet_3_5__leaf_CLK VGND VGND VPWR VPWR clknet_leaf_74_CLK sky130_fd_sc_hd__clkbuf_8
XFILLER_0_24_322 VGND VGND VPWR VPWR sky130_fd_sc_hd__fill_1
XFILLER_0_107_593 VGND VGND VPWR VPWR sky130_fd_sc_hd__decap_8
Xhold908 RF.reg_arr\[11\]\[27\] VGND VGND VPWR VPWR net990 sky130_fd_sc_hd__dlygate4sd3_1
Xhold919 RF.reg_arr\[30\]\[14\] VGND VGND VPWR VPWR net1001 sky130_fd_sc_hd__dlygate4sd3_1
XFILLER_0_3_249 VGND VGND VPWR VPWR sky130_fd_sc_hd__fill_2
XFILLER_0_20_561 VGND VGND VPWR VPWR sky130_fd_sc_hd__fill_1
X_5140_ _1912_ _1928_ VGND VGND VPWR VPWR _1929_ sky130_fd_sc_hd__nand2_1
X_5071_ _1859_ VGND VGND VPWR VPWR _1860_ sky130_fd_sc_hd__buf_4
XFILLER_0_79_517 VGND VGND VPWR VPWR sky130_fd_sc_hd__decap_4
X_8830_ clknet_leaf_71_CLK _0063_ VGND VGND VPWR VPWR RF.reg_arr\[19\]\[0\] sky130_fd_sc_hd__dfxtp_1
X_8761_ clknet_leaf_49_CLK _1018_ VGND VGND VPWR VPWR RF.reg_arr\[6\]\[27\] sky130_fd_sc_hd__dfxtp_1
X_5973_ _2741_ _2744_ VGND VGND VPWR VPWR _2745_ sky130_fd_sc_hd__xnor2_1
X_4924_ RF.reg_arr\[0\]\[28\] RF.reg_arr\[1\]\[28\] RF.reg_arr\[2\]\[28\] RF.reg_arr\[3\]\[28\]
+ _1678_ _1684_ VGND VGND VPWR VPWR _1713_ sky130_fd_sc_hd__mux4_1
X_7712_ _3817_ VGND VGND VPWR VPWR _0386_ sky130_fd_sc_hd__clkbuf_1
XFILLER_0_47_403 VGND VGND VPWR VPWR sky130_fd_sc_hd__fill_1
XFILLER_0_74_222 VGND VGND VPWR VPWR sky130_fd_sc_hd__fill_2
X_8692_ clknet_leaf_42_CLK _0949_ VGND VGND VPWR VPWR RF.reg_arr\[15\]\[22\] sky130_fd_sc_hd__dfxtp_1
X_4855_ _1643_ VGND VGND VPWR VPWR _1644_ sky130_fd_sc_hd__buf_4
X_7643_ _3065_ net1032 _3777_ VGND VGND VPWR VPWR _3781_ sky130_fd_sc_hd__mux2_1
X_4786_ RF.reg_arr\[4\]\[24\] RF.reg_arr\[5\]\[24\] RF.reg_arr\[6\]\[24\] RF.reg_arr\[7\]\[24\]
+ _1316_ _1304_ VGND VGND VPWR VPWR _1575_ sky130_fd_sc_hd__mux4_1
X_7574_ _3744_ VGND VGND VPWR VPWR _0321_ sky130_fd_sc_hd__clkbuf_1
XFILLER_0_27_160 VGND VGND VPWR VPWR sky130_fd_sc_hd__decap_8
Xclkbuf_leaf_65_CLK clknet_3_7__leaf_CLK VGND VGND VPWR VPWR clknet_leaf_65_CLK sky130_fd_sc_hd__clkbuf_8
X_6525_ _3169_ VGND VGND VPWR VPWR _0871_ sky130_fd_sc_hd__clkbuf_1
XFILLER_0_15_333 VGND VGND VPWR VPWR sky130_fd_sc_hd__decap_3
X_9313_ clknet_leaf_70_CLK _0546_ VGND VGND VPWR VPWR RF.reg_arr\[20\]\[3\] sky130_fd_sc_hd__dfxtp_1
X_9244_ clknet_leaf_22_CLK _0477_ VGND VGND VPWR VPWR RF.reg_arr\[22\]\[30\] sky130_fd_sc_hd__dfxtp_1
Xclkload70 clknet_leaf_72_CLK VGND VGND VPWR VPWR clkload70/Y sky130_fd_sc_hd__inv_8
X_6456_ net130 VGND VGND VPWR VPWR _3133_ sky130_fd_sc_hd__clkbuf_1
XFILLER_0_113_585 VPWR VGND VPWR VGND sky130_ef_sc_hd__decap_12
X_9175_ clknet_leaf_38_CLK _0408_ VGND VGND VPWR VPWR RF.reg_arr\[9\]\[25\] sky130_fd_sc_hd__dfxtp_1
X_5407_ _2159_ _2195_ _2001_ VGND VGND VPWR VPWR _2196_ sky130_fd_sc_hd__mux2_1
Xclkload92 clknet_leaf_62_CLK VGND VGND VPWR VPWR clkload92/Y sky130_fd_sc_hd__clkinv_4
X_6387_ _3089_ VGND VGND VPWR VPWR _0813_ sky130_fd_sc_hd__clkbuf_1
XFILLER_0_30_358 VGND VGND VPWR VPWR sky130_fd_sc_hd__decap_6
Xclkload81 clknet_leaf_87_CLK VGND VGND VPWR VPWR clkload81/Y sky130_fd_sc_hd__inv_8
X_8126_ net699 _3401_ _4030_ VGND VGND VPWR VPWR _4037_ sky130_fd_sc_hd__mux2_1
XFILLER_0_11_583 VGND VGND VPWR VPWR sky130_fd_sc_hd__decap_6
X_5338_ _2125_ _2126_ _1864_ VGND VGND VPWR VPWR _2127_ sky130_fd_sc_hd__mux2_1
X_8057_ _4000_ VGND VGND VPWR VPWR _0548_ sky130_fd_sc_hd__clkbuf_1
X_7008_ net586 _3377_ _3431_ VGND VGND VPWR VPWR _3442_ sky130_fd_sc_hd__mux2_1
XTAP_TAPCELL_ROW_89_1318 VGND VPWR sky130_fd_sc_hd__tapvpwrvgnd_1
X_5269_ _2054_ _2057_ _1635_ VGND VGND VPWR VPWR _2058_ sky130_fd_sc_hd__mux2_1
X_8959_ clknet_leaf_57_CLK _0192_ VGND VGND VPWR VPWR RF.reg_arr\[31\]\[1\] sky130_fd_sc_hd__dfxtp_1
XFILLER_0_93_542 VGND VGND VPWR VPWR sky130_fd_sc_hd__decap_8
XFILLER_0_78_594 VGND VGND VPWR VPWR sky130_fd_sc_hd__decap_4
XTAP_TAPCELL_ROW_26_567 VGND VPWR sky130_fd_sc_hd__tapvpwrvgnd_1
XFILLER_0_38_447 VGND VGND VPWR VPWR sky130_fd_sc_hd__decap_4
XTAP_TAPCELL_ROW_54_898 VGND VPWR sky130_fd_sc_hd__tapvpwrvgnd_1
XFILLER_0_19_650 VGND VGND VPWR VPWR sky130_fd_sc_hd__decap_4
Xclkbuf_leaf_56_CLK clknet_3_7__leaf_CLK VGND VGND VPWR VPWR clknet_leaf_56_CLK sky130_fd_sc_hd__clkbuf_8
XFILLER_0_25_108 VGND VGND VPWR VPWR sky130_fd_sc_hd__decap_4
XTAP_TAPCELL_ROW_70_1090 VGND VPWR sky130_fd_sc_hd__tapvpwrvgnd_1
XTAP_TAPCELL_ROW_109_1554 VGND VPWR sky130_fd_sc_hd__tapvpwrvgnd_1
XFILLER_0_88_303 VGND VGND VPWR VPWR sky130_fd_sc_hd__decap_4
XTAP_TAPCELL_ROW_109_1565 VGND VPWR sky130_fd_sc_hd__tapvpwrvgnd_1
XFILLER_0_72_27 VGND VGND VPWR VPWR sky130_fd_sc_hd__fill_1
XFILLER_0_84_531 VGND VGND VPWR VPWR sky130_fd_sc_hd__fill_1
XFILLER_0_29_436 VPWR VGND VPWR VGND sky130_ef_sc_hd__decap_12
XFILLER_0_84_575 VPWR VGND VPWR VGND sky130_ef_sc_hd__decap_12
XFILLER_0_84_564 VGND VGND VPWR VPWR sky130_fd_sc_hd__fill_1
XFILLER_0_84_542 VGND VGND VPWR VPWR sky130_fd_sc_hd__decap_6
X_4640_ RF.reg_arr\[0\]\[27\] RF.reg_arr\[1\]\[27\] RF.reg_arr\[2\]\[27\] RF.reg_arr\[3\]\[27\]
+ _1302_ _1322_ VGND VGND VPWR VPWR _1429_ sky130_fd_sc_hd__mux4_1
Xclkbuf_leaf_47_CLK clknet_3_6__leaf_CLK VGND VGND VPWR VPWR clknet_leaf_47_CLK sky130_fd_sc_hd__clkbuf_8
XFILLER_0_71_225 VGND VGND VPWR VPWR sky130_fd_sc_hd__decap_4
XFILLER_0_115_3 VPWR VGND VPWR VGND sky130_ef_sc_hd__decap_12
XFILLER_0_112_77 VGND VGND VPWR VPWR sky130_fd_sc_hd__fill_2
XFILLER_0_21_53 VGND VGND VPWR VPWR sky130_fd_sc_hd__decap_3
XFILLER_0_114_338 VGND VGND VPWR VPWR sky130_fd_sc_hd__decap_4
X_4571_ RF.reg_arr\[12\]\[21\] RF.reg_arr\[13\]\[21\] RF.reg_arr\[14\]\[21\] RF.reg_arr\[15\]\[21\]
+ _1357_ _1358_ VGND VGND VPWR VPWR _1360_ sky130_fd_sc_hd__mux4_1
X_6310_ net26 VGND VGND VPWR VPWR _3039_ sky130_fd_sc_hd__buf_2
Xhold705 RF.reg_arr\[29\]\[30\] VGND VGND VPWR VPWR net787 sky130_fd_sc_hd__dlygate4sd3_1
X_7290_ _3123_ net1030 _3557_ VGND VGND VPWR VPWR _3592_ sky130_fd_sc_hd__mux2_1
Xhold716 RF.reg_arr\[31\]\[9\] VGND VGND VPWR VPWR net798 sky130_fd_sc_hd__dlygate4sd3_1
Xhold727 RF.reg_arr\[1\]\[9\] VGND VGND VPWR VPWR net809 sky130_fd_sc_hd__dlygate4sd3_1
XFILLER_0_110_533 VGND VGND VPWR VPWR sky130_fd_sc_hd__decap_6
X_6241_ _2991_ VGND VGND VPWR VPWR _0765_ sky130_fd_sc_hd__clkbuf_1
Xhold738 RF.reg_arr\[13\]\[12\] VGND VGND VPWR VPWR net820 sky130_fd_sc_hd__dlygate4sd3_1
XFILLER_0_12_358 VGND VGND VPWR VPWR sky130_fd_sc_hd__decap_6
Xhold749 RF.reg_arr\[12\]\[8\] VGND VGND VPWR VPWR net831 sky130_fd_sc_hd__dlygate4sd3_1
XFILLER_0_40_678 VGND VGND VPWR VPWR sky130_fd_sc_hd__fill_1
X_6172_ _1739_ _2928_ _2932_ _2445_ VGND VGND VPWR VPWR _2933_ sky130_fd_sc_hd__o211a_1
X_5123_ _1895_ _1911_ _1667_ VGND VGND VPWR VPWR _1912_ sky130_fd_sc_hd__o21ai_1
X_5054_ _1838_ _1841_ _1842_ VGND VGND VPWR VPWR _1843_ sky130_fd_sc_hd__mux2_1
XFILLER_0_46_72 VGND VGND VPWR VPWR sky130_fd_sc_hd__decap_8
X_8813_ clknet_leaf_103_CLK _0046_ VGND VGND VPWR VPWR RF.reg_arr\[4\]\[15\] sky130_fd_sc_hd__dfxtp_1
XTAP_TAPCELL_ROW_84_1259 VGND VPWR sky130_fd_sc_hd__tapvpwrvgnd_1
XFILLER_0_87_391 VGND VGND VPWR VPWR sky130_fd_sc_hd__fill_1
X_5956_ _2728_ _2674_ _2693_ _2700_ VGND VGND VPWR VPWR _2729_ sky130_fd_sc_hd__or4_4
X_8744_ clknet_leaf_63_CLK _1001_ VGND VGND VPWR VPWR RF.reg_arr\[6\]\[10\] sky130_fd_sc_hd__dfxtp_1
X_5887_ _2490_ _2586_ _2588_ _2486_ _2663_ VGND VGND VPWR VPWR _2664_ sky130_fd_sc_hd__o221a_1
X_4907_ _1587_ _1687_ _1691_ _1695_ VGND VGND VPWR VPWR _1696_ sky130_fd_sc_hd__o2bb2a_2
X_8675_ clknet_leaf_79_CLK _0932_ VGND VGND VPWR VPWR RF.reg_arr\[15\]\[5\] sky130_fd_sc_hd__dfxtp_1
XTAP_TAPCELL_ROW_23_526 VGND VPWR sky130_fd_sc_hd__tapvpwrvgnd_1
XFILLER_0_47_244 VGND VGND VPWR VPWR sky130_fd_sc_hd__fill_1
X_7626_ _3771_ VGND VGND VPWR VPWR _0346_ sky130_fd_sc_hd__clkbuf_1
Xclkbuf_leaf_38_CLK clknet_3_3__leaf_CLK VGND VGND VPWR VPWR clknet_leaf_38_CLK sky130_fd_sc_hd__clkbuf_8
X_4838_ _1626_ VGND VGND VPWR VPWR _1627_ sky130_fd_sc_hd__buf_4
XTAP_TAPCELL_ROW_51_868 VGND VPWR sky130_fd_sc_hd__tapvpwrvgnd_1
XFILLER_0_16_642 VGND VGND VPWR VPWR sky130_fd_sc_hd__fill_2
X_7557_ net757 _3377_ _3727_ VGND VGND VPWR VPWR _3735_ sky130_fd_sc_hd__mux2_1
X_4769_ _1556_ _1557_ _1308_ VGND VGND VPWR VPWR _1558_ sky130_fd_sc_hd__mux2_1
XFILLER_0_90_589 VGND VGND VPWR VPWR sky130_fd_sc_hd__decap_6
XFILLER_0_7_385 VGND VGND VPWR VPWR sky130_fd_sc_hd__decap_6
X_7488_ _3697_ VGND VGND VPWR VPWR _0282_ sky130_fd_sc_hd__clkbuf_1
X_6508_ net876 _2994_ _3160_ VGND VGND VPWR VPWR _3161_ sky130_fd_sc_hd__mux2_1
XFILLER_0_31_623 VGND VGND VPWR VPWR sky130_fd_sc_hd__fill_2
XTAP_TAPCELL_ROW_95_1388 VGND VPWR sky130_fd_sc_hd__tapvpwrvgnd_1
X_6439_ _3124_ VGND VGND VPWR VPWR _0830_ sky130_fd_sc_hd__clkbuf_1
X_9227_ clknet_leaf_94_CLK _0460_ VGND VGND VPWR VPWR RF.reg_arr\[22\]\[13\] sky130_fd_sc_hd__dfxtp_1
X_9158_ clknet_leaf_86_CLK _0391_ VGND VGND VPWR VPWR RF.reg_arr\[9\]\[8\] sky130_fd_sc_hd__dfxtp_1
XFILLER_0_101_599 VGND VGND VPWR VPWR sky130_fd_sc_hd__decap_8
X_8109_ _4027_ VGND VGND VPWR VPWR _0573_ sky130_fd_sc_hd__clkbuf_1
Xhold21 RF.reg_arr\[0\]\[26\] VGND VGND VPWR VPWR net103 sky130_fd_sc_hd__dlygate4sd3_1
Xhold32 RF.reg_arr\[0\]\[28\] VGND VGND VPWR VPWR net114 sky130_fd_sc_hd__dlygate4sd3_1
X_9089_ clknet_leaf_61_CLK _0322_ VGND VGND VPWR VPWR RF.reg_arr\[2\]\[3\] sky130_fd_sc_hd__dfxtp_1
Xhold54 RF.reg_arr\[5\]\[31\] VGND VGND VPWR VPWR net136 sky130_fd_sc_hd__dlygate4sd3_1
Xhold65 RF.reg_arr\[5\]\[7\] VGND VGND VPWR VPWR net147 sky130_fd_sc_hd__dlygate4sd3_1
Xhold43 RF.reg_arr\[0\]\[18\] VGND VGND VPWR VPWR net125 sky130_fd_sc_hd__dlygate4sd3_1
XFILLER_0_98_623 VGND VGND VPWR VPWR sky130_fd_sc_hd__decap_8
Xhold87 RF.reg_arr\[17\]\[28\] VGND VGND VPWR VPWR net169 sky130_fd_sc_hd__dlygate4sd3_1
Xhold76 RF.reg_arr\[19\]\[21\] VGND VGND VPWR VPWR net158 sky130_fd_sc_hd__dlygate4sd3_1
Xhold98 RF.reg_arr\[19\]\[22\] VGND VGND VPWR VPWR net180 sky130_fd_sc_hd__dlygate4sd3_1
XTAP_TAPCELL_ROW_59_957 VGND VPWR sky130_fd_sc_hd__tapvpwrvgnd_1
XFILLER_0_97_111 VGND VGND VPWR VPWR sky130_fd_sc_hd__fill_1
XPHY_EDGE_ROW_11_Left_128 VGND VGND VPWR VPWR sky130_fd_sc_hd__decap_3
XTAP_TAPCELL_ROW_3_284 VGND VPWR sky130_fd_sc_hd__tapvpwrvgnd_1
XFILLER_0_66_531 VGND VGND VPWR VPWR sky130_fd_sc_hd__fill_1
XFILLER_0_66_542 VGND VGND VPWR VPWR sky130_fd_sc_hd__fill_1
XFILLER_0_108_121 VGND VGND VPWR VPWR sky130_fd_sc_hd__decap_8
XTAP_TAPCELL_ROW_104_1495 VGND VPWR sky130_fd_sc_hd__tapvpwrvgnd_1
XFILLER_0_66_597 VGND VGND VPWR VPWR sky130_fd_sc_hd__fill_1
Xclkbuf_leaf_29_CLK clknet_3_2__leaf_CLK VGND VGND VPWR VPWR clknet_leaf_29_CLK sky130_fd_sc_hd__clkbuf_8
XFILLER_0_109_677 VGND VGND VPWR VPWR sky130_fd_sc_hd__fill_2
XFILLER_0_81_556 VGND VGND VPWR VPWR sky130_fd_sc_hd__decap_4
XPHY_EDGE_ROW_20_Left_137 VGND VGND VPWR VPWR sky130_fd_sc_hd__decap_3
XFILLER_0_21_111 VGND VGND VPWR VPWR sky130_fd_sc_hd__fill_1
XANTENNA_7 _1062_ VGND VGND VPWR VPWR sky130_fd_sc_hd__diode_2
XFILLER_0_104_382 VGND VGND VPWR VPWR sky130_fd_sc_hd__fill_1
XFILLER_0_107_55 VGND VGND VPWR VPWR sky130_fd_sc_hd__fill_1
Xrebuffer19 _2761_ VGND VGND VPWR VPWR net1128 sky130_fd_sc_hd__dlygate4sd1_1
XFILLER_0_88_155 VGND VGND VPWR VPWR sky130_fd_sc_hd__decap_3
X_5810_ _2489_ VGND VGND VPWR VPWR _2591_ sky130_fd_sc_hd__inv_2
X_6790_ _3311_ VGND VGND VPWR VPWR _0994_ sky130_fd_sc_hd__clkbuf_1
X_5741_ _2492_ _2523_ _2434_ VGND VGND VPWR VPWR _2524_ sky130_fd_sc_hd__mux2_1
X_8460_ _4213_ VGND VGND VPWR VPWR _0738_ sky130_fd_sc_hd__clkbuf_1
X_7411_ _3656_ VGND VGND VPWR VPWR _0246_ sky130_fd_sc_hd__clkbuf_1
X_5672_ _2309_ _2449_ VGND VGND VPWR VPWR _2458_ sky130_fd_sc_hd__or2_1
XFILLER_0_32_85 VGND VGND VPWR VPWR sky130_fd_sc_hd__decap_4
XFILLER_0_72_589 VGND VGND VPWR VPWR sky130_fd_sc_hd__fill_2
X_4623_ RF.reg_arr\[0\]\[7\] RF.reg_arr\[1\]\[7\] RF.reg_arr\[2\]\[7\] RF.reg_arr\[3\]\[7\]
+ _1082_ _1084_ VGND VGND VPWR VPWR _1412_ sky130_fd_sc_hd__mux4_1
X_8391_ _4177_ VGND VGND VPWR VPWR _0705_ sky130_fd_sc_hd__clkbuf_1
X_7342_ _3107_ net369 _3616_ VGND VGND VPWR VPWR _3620_ sky130_fd_sc_hd__mux2_1
XFILLER_0_4_355 VGND VGND VPWR VPWR sky130_fd_sc_hd__decap_8
X_4554_ _1106_ VGND VGND VPWR VPWR _1343_ sky130_fd_sc_hd__buf_4
Xhold502 RF.reg_arr\[1\]\[7\] VGND VGND VPWR VPWR net584 sky130_fd_sc_hd__dlygate4sd3_1
Xhold535 RF.reg_arr\[29\]\[28\] VGND VGND VPWR VPWR net617 sky130_fd_sc_hd__dlygate4sd3_1
Xhold513 RF.reg_arr\[27\]\[27\] VGND VGND VPWR VPWR net595 sky130_fd_sc_hd__dlygate4sd3_1
X_7273_ _3583_ VGND VGND VPWR VPWR _0181_ sky130_fd_sc_hd__clkbuf_1
XFILLER_0_13_667 VGND VGND VPWR VPWR sky130_fd_sc_hd__decap_4
Xhold524 RF.reg_arr\[5\]\[4\] VGND VGND VPWR VPWR net606 sky130_fd_sc_hd__dlygate4sd3_1
Xhold557 RF.reg_arr\[28\]\[24\] VGND VGND VPWR VPWR net639 sky130_fd_sc_hd__dlygate4sd3_1
X_4485_ _1273_ VGND VGND VPWR VPWR _1274_ sky130_fd_sc_hd__buf_6
X_6224_ net31 VGND VGND VPWR VPWR _2980_ sky130_fd_sc_hd__buf_2
Xhold568 RF.reg_arr\[25\]\[20\] VGND VGND VPWR VPWR net650 sky130_fd_sc_hd__dlygate4sd3_1
X_9012_ clknet_leaf_44_CLK _0245_ VGND VGND VPWR VPWR RF.reg_arr\[27\]\[22\] sky130_fd_sc_hd__dfxtp_1
XFILLER_0_12_177 VGND VGND VPWR VPWR sky130_fd_sc_hd__decap_8
Xhold546 RF.reg_arr\[21\]\[4\] VGND VGND VPWR VPWR net628 sky130_fd_sc_hd__dlygate4sd3_1
Xhold579 RF.reg_arr\[27\]\[14\] VGND VGND VPWR VPWR net661 sky130_fd_sc_hd__dlygate4sd3_1
XFILLER_0_40_497 VGND VGND VPWR VPWR sky130_fd_sc_hd__fill_1
XFILLER_0_0_561 VGND VGND VPWR VPWR sky130_fd_sc_hd__fill_2
XFILLER_0_0_572 VGND VGND VPWR VPWR sky130_fd_sc_hd__decap_4
X_6155_ _1716_ _2915_ VGND VGND VPWR VPWR _2916_ sky130_fd_sc_hd__nor2_1
X_5106_ _1833_ VGND VGND VPWR VPWR _1895_ sky130_fd_sc_hd__buf_2
X_6086_ _2789_ _2802_ VGND VGND VPWR VPWR _2851_ sky130_fd_sc_hd__or2b_1
X_5037_ RF.reg_arr\[12\]\[2\] RF.reg_arr\[13\]\[2\] RF.reg_arr\[14\]\[2\] RF.reg_arr\[15\]\[2\]
+ _1043_ _1083_ VGND VGND VPWR VPWR _1826_ sky130_fd_sc_hd__mux4_1
XTAP_TAPCELL_ROW_56_927 VGND VPWR sky130_fd_sc_hd__tapvpwrvgnd_1
XTAP_TAPCELL_ROW_0_243 VGND VPWR sky130_fd_sc_hd__tapvpwrvgnd_1
XTAP_TAPCELL_ROW_0_254 VGND VPWR sky130_fd_sc_hd__tapvpwrvgnd_1
XFILLER_0_79_177 VGND VGND VPWR VPWR sky130_fd_sc_hd__decap_6
XFILLER_0_48_520 VGND VGND VPWR VPWR sky130_fd_sc_hd__decap_3
X_8727_ clknet_leaf_39_CLK _0984_ VGND VGND VPWR VPWR RF.reg_arr\[14\]\[25\] sky130_fd_sc_hd__dfxtp_1
XFILLER_0_82_309 VGND VGND VPWR VPWR sky130_fd_sc_hd__decap_3
XTAP_TAPCELL_ROW_36_684 VGND VPWR sky130_fd_sc_hd__tapvpwrvgnd_1
X_6988_ _3429_ VGND VGND VPWR VPWR _0050_ sky130_fd_sc_hd__clkbuf_1
X_5939_ _2340_ _2704_ _2712_ VGND VGND VPWR VPWR net55 sky130_fd_sc_hd__a21oi_1
X_8658_ clknet_leaf_13_CLK _0915_ VGND VGND VPWR VPWR RF.reg_arr\[8\]\[20\] sky130_fd_sc_hd__dfxtp_1
XFILLER_0_35_225 VGND VGND VPWR VPWR sky130_fd_sc_hd__fill_2
XTAP_TAPCELL_ROW_97_1417 VGND VPWR sky130_fd_sc_hd__tapvpwrvgnd_1
X_8589_ clknet_leaf_94_CLK _0846_ VGND VGND VPWR VPWR RF.reg_arr\[0\]\[15\] sky130_fd_sc_hd__dfxtp_1
X_7609_ _3762_ VGND VGND VPWR VPWR _0338_ sky130_fd_sc_hd__clkbuf_1
XFILLER_0_105_146 VGND VGND VPWR VPWR sky130_fd_sc_hd__fill_2
XFILLER_0_101_330 VGND VGND VPWR VPWR sky130_fd_sc_hd__decap_6
Xoutput66 net66 VGND VGND VPWR VPWR result[25] sky130_fd_sc_hd__clkbuf_4
Xoutput55 net55 VGND VGND VPWR VPWR result[15] sky130_fd_sc_hd__clkbuf_4
XFILLER_0_9_3 VPWR VGND VPWR VGND sky130_ef_sc_hd__decap_12
XTAP_TAPCELL_ROW_8_343 VGND VPWR sky130_fd_sc_hd__tapvpwrvgnd_1
Xoutput77 net77 VGND VGND VPWR VPWR result[6] sky130_fd_sc_hd__clkbuf_4
XTAP_TAPCELL_ROW_106_1524 VGND VPWR sky130_fd_sc_hd__tapvpwrvgnd_1
XFILLER_0_58_306 VGND VGND VPWR VPWR sky130_fd_sc_hd__fill_2
XFILLER_0_98_486 VGND VGND VPWR VPWR sky130_fd_sc_hd__decap_8
XFILLER_0_86_637 VGND VGND VPWR VPWR sky130_fd_sc_hd__fill_2
XFILLER_0_109_452 VGND VGND VPWR VPWR sky130_fd_sc_hd__fill_2
XFILLER_0_5_108 VGND VGND VPWR VPWR sky130_fd_sc_hd__decap_4
XFILLER_0_10_604 VGND VGND VPWR VPWR sky130_fd_sc_hd__fill_2
XFILLER_0_22_486 VGND VGND VPWR VPWR sky130_fd_sc_hd__decap_8
X_4270_ net6 VGND VGND VPWR VPWR _1059_ sky130_fd_sc_hd__clkbuf_8
Xclkbuf_leaf_9_CLK clknet_3_0__leaf_CLK VGND VGND VPWR VPWR clknet_leaf_9_CLK sky130_fd_sc_hd__clkbuf_8
X_7960_ _2970_ net870 _3944_ VGND VGND VPWR VPWR _3949_ sky130_fd_sc_hd__mux2_1
X_6911_ net33 VGND VGND VPWR VPWR _3377_ sky130_fd_sc_hd__buf_2
X_7891_ _3912_ VGND VGND VPWR VPWR _0470_ sky130_fd_sc_hd__clkbuf_1
XFILLER_0_77_615 VGND VGND VPWR VPWR sky130_fd_sc_hd__fill_1
X_6842_ _3338_ VGND VGND VPWR VPWR _1019_ sky130_fd_sc_hd__clkbuf_1
XFILLER_0_77_648 VGND VGND VPWR VPWR sky130_fd_sc_hd__fill_2
XFILLER_0_76_125 VGND VGND VPWR VPWR sky130_fd_sc_hd__decap_6
XTAP_TAPCELL_ROW_81_1229 VGND VPWR sky130_fd_sc_hd__tapvpwrvgnd_1
XTAP_TAPCELL_ROW_81_1218 VGND VPWR sky130_fd_sc_hd__tapvpwrvgnd_1
XFILLER_0_43_73 VGND VGND VPWR VPWR sky130_fd_sc_hd__decap_3
X_6773_ _3301_ VGND VGND VPWR VPWR _0987_ sky130_fd_sc_hd__clkbuf_1
XFILLER_0_64_309 VGND VGND VPWR VPWR sky130_fd_sc_hd__fill_2
XFILLER_0_9_447 VGND VGND VPWR VPWR sky130_fd_sc_hd__fill_1
XTAP_TAPCELL_ROW_33_643 VGND VPWR sky130_fd_sc_hd__tapvpwrvgnd_1
X_5724_ _2410_ _2406_ VGND VGND VPWR VPWR _2508_ sky130_fd_sc_hd__nand2_1
X_8512_ clknet_leaf_60_CLK _0769_ VGND VGND VPWR VPWR RF.reg_arr\[1\]\[2\] sky130_fd_sc_hd__dfxtp_1
X_9492_ clknet_leaf_43_CLK _0725_ VGND VGND VPWR VPWR RF.reg_arr\[11\]\[22\] sky130_fd_sc_hd__dfxtp_1
XTAP_TAPCELL_ROW_61_985 VGND VPWR sky130_fd_sc_hd__tapvpwrvgnd_1
X_8443_ _4204_ VGND VGND VPWR VPWR _0730_ sky130_fd_sc_hd__clkbuf_1
X_5655_ _2046_ _2441_ _2276_ VGND VGND VPWR VPWR _2442_ sky130_fd_sc_hd__mux2_1
XFILLER_0_45_578 VGND VGND VPWR VPWR sky130_fd_sc_hd__fill_1
X_8374_ _2984_ net994 _4160_ VGND VGND VPWR VPWR _4168_ sky130_fd_sc_hd__mux2_1
XFILLER_0_87_3 VGND VGND VPWR VPWR sky130_fd_sc_hd__decap_3
XFILLER_0_60_526 VGND VGND VPWR VPWR sky130_fd_sc_hd__fill_1
XFILLER_0_4_141 VGND VGND VPWR VPWR sky130_fd_sc_hd__decap_6
X_4606_ _1393_ _1394_ _1059_ VGND VGND VPWR VPWR _1395_ sky130_fd_sc_hd__mux2_1
X_5586_ _1833_ net82 _1700_ VGND VGND VPWR VPWR _2374_ sky130_fd_sc_hd__o21ai_1
X_7325_ _3090_ net444 _3605_ VGND VGND VPWR VPWR _3611_ sky130_fd_sc_hd__mux2_1
Xhold310 RF.reg_arr\[4\]\[6\] VGND VGND VPWR VPWR net392 sky130_fd_sc_hd__dlygate4sd3_1
Xhold343 RF.reg_arr\[2\]\[28\] VGND VGND VPWR VPWR net425 sky130_fd_sc_hd__dlygate4sd3_1
X_4537_ _1282_ _1325_ VGND VGND VPWR VPWR _1326_ sky130_fd_sc_hd__nand2_1
Xhold321 RF.reg_arr\[11\]\[1\] VGND VGND VPWR VPWR net403 sky130_fd_sc_hd__dlygate4sd3_1
Xhold332 RF.reg_arr\[3\]\[13\] VGND VGND VPWR VPWR net414 sky130_fd_sc_hd__dlygate4sd3_1
Xhold376 RF.reg_arr\[20\]\[28\] VGND VGND VPWR VPWR net458 sky130_fd_sc_hd__dlygate4sd3_1
XTAP_TAPCELL_ROW_92_1358 VGND VPWR sky130_fd_sc_hd__tapvpwrvgnd_1
Xhold354 RF.reg_arr\[3\]\[22\] VGND VGND VPWR VPWR net436 sky130_fd_sc_hd__dlygate4sd3_1
Xhold365 RF.reg_arr\[28\]\[1\] VGND VGND VPWR VPWR net447 sky130_fd_sc_hd__dlygate4sd3_1
X_7256_ _3574_ VGND VGND VPWR VPWR _0173_ sky130_fd_sc_hd__clkbuf_1
Xhold387 RF.reg_arr\[21\]\[14\] VGND VGND VPWR VPWR net469 sky130_fd_sc_hd__dlygate4sd3_1
X_4468_ RF.reg_arr\[16\]\[11\] RF.reg_arr\[17\]\[11\] RF.reg_arr\[18\]\[11\] RF.reg_arr\[19\]\[11\]
+ net98 _1106_ VGND VGND VPWR VPWR _1257_ sky130_fd_sc_hd__mux4_2
X_6207_ _2348_ _2350_ _2001_ VGND VGND VPWR VPWR _2965_ sky130_fd_sc_hd__o21ai_1
XTAP_TAPCELL_ROW_5_313 VGND VPWR sky130_fd_sc_hd__tapvpwrvgnd_1
X_7187_ _3537_ VGND VGND VPWR VPWR _0141_ sky130_fd_sc_hd__clkbuf_1
Xhold398 RF.reg_arr\[5\]\[16\] VGND VGND VPWR VPWR net480 sky130_fd_sc_hd__dlygate4sd3_1
X_6138_ _1772_ _2899_ VGND VGND VPWR VPWR _2900_ sky130_fd_sc_hd__and2_1
X_4399_ _1052_ VGND VGND VPWR VPWR _1188_ sky130_fd_sc_hd__buf_4
Xhold1021 RF.reg_arr\[12\]\[5\] VGND VGND VPWR VPWR net1103 sky130_fd_sc_hd__dlygate4sd3_1
Xhold1032 RF.reg_arr\[23\]\[13\] VGND VGND VPWR VPWR net1114 sky130_fd_sc_hd__dlygate4sd3_1
Xhold1010 RF.reg_arr\[31\]\[2\] VGND VGND VPWR VPWR net1092 sky130_fd_sc_hd__dlygate4sd3_1
X_6069_ _2814_ _2818_ _2834_ VGND VGND VPWR VPWR _2835_ sky130_fd_sc_hd__a21oi_1
XFILLER_0_99_228 VPWR VGND VPWR VGND sky130_ef_sc_hd__decap_12
XFILLER_0_95_423 VGND VGND VPWR VPWR sky130_fd_sc_hd__fill_2
XTAP_TAPCELL_ROW_101_1465 VGND VPWR sky130_fd_sc_hd__tapvpwrvgnd_1
XFILLER_0_63_320 VGND VGND VPWR VPWR sky130_fd_sc_hd__fill_1
XFILLER_0_91_673 VGND VGND VPWR VPWR sky130_fd_sc_hd__fill_2
XFILLER_0_106_488 VGND VGND VPWR VPWR sky130_fd_sc_hd__decap_4
XFILLER_0_16_291 VGND VGND VPWR VPWR sky130_fd_sc_hd__fill_1
Xclkbuf_3_4__f_CLK clknet_0_CLK VGND VGND VPWR VPWR clknet_3_4__leaf_CLK sky130_fd_sc_hd__clkbuf_16
XFILLER_0_102_683 VGND VGND VPWR VPWR sky130_fd_sc_hd__decap_8
XTAP_TAPCELL_ROW_112_1594 VGND VPWR sky130_fd_sc_hd__tapvpwrvgnd_1
XPHY_EDGE_ROW_103_Left_220 VGND VGND VPWR VPWR sky130_fd_sc_hd__decap_3
XFILLER_0_98_283 VGND VGND VPWR VPWR sky130_fd_sc_hd__fill_2
XTAP_TAPCELL_ROW_67_1051 VGND VPWR sky130_fd_sc_hd__tapvpwrvgnd_1
XFILLER_0_98_294 VGND VGND VPWR VPWR sky130_fd_sc_hd__fill_1
XFILLER_0_86_467 VGND VGND VPWR VPWR sky130_fd_sc_hd__fill_2
XFILLER_0_13_54 VGND VGND VPWR VPWR sky130_fd_sc_hd__fill_2
XTAP_TAPCELL_ROW_30_613 VGND VPWR sky130_fd_sc_hd__tapvpwrvgnd_1
XFILLER_0_27_556 VGND VGND VPWR VPWR sky130_fd_sc_hd__decap_4
XFILLER_0_54_353 VGND VGND VPWR VPWR sky130_fd_sc_hd__decap_8
X_5440_ RF.reg_arr\[4\]\[5\] RF.reg_arr\[5\]\[5\] RF.reg_arr\[6\]\[5\] RF.reg_arr\[7\]\[5\]
+ _1623_ _1596_ VGND VGND VPWR VPWR _2229_ sky130_fd_sc_hd__mux4_1
XFILLER_0_42_526 VGND VGND VPWR VPWR sky130_fd_sc_hd__decap_3
XTAP_TAPCELL_ROW_10_370 VGND VPWR sky130_fd_sc_hd__tapvpwrvgnd_1
XFILLER_0_2_601 VPWR VGND VPWR VGND sky130_ef_sc_hd__decap_12
X_5371_ RF.reg_arr\[20\]\[12\] RF.reg_arr\[21\]\[12\] RF.reg_arr\[22\]\[12\] RF.reg_arr\[23\]\[12\]
+ _1622_ _1595_ VGND VGND VPWR VPWR _2160_ sky130_fd_sc_hd__mux4_1
XFILLER_0_2_645 VPWR VGND VPWR VGND sky130_ef_sc_hd__decap_12
X_8090_ _3042_ net929 _4016_ VGND VGND VPWR VPWR _4018_ sky130_fd_sc_hd__mux2_1
XTAP_TAPCELL_ROW_78_1191 VGND VPWR sky130_fd_sc_hd__tapvpwrvgnd_1
XFILLER_0_2_689 VGND VGND VPWR VPWR sky130_fd_sc_hd__decap_3
X_4322_ _1104_ _1102_ _1110_ _1109_ _1063_ VGND VGND VPWR VPWR _1111_ sky130_fd_sc_hd__a221oi_4
X_7110_ net389 _3409_ _3496_ VGND VGND VPWR VPWR _3497_ sky130_fd_sc_hd__mux2_1
XFILLER_0_50_592 VGND VGND VPWR VPWR sky130_fd_sc_hd__decap_4
X_7041_ _3448_ VGND VGND VPWR VPWR _3460_ sky130_fd_sc_hd__clkbuf_8
X_4253_ _1041_ VGND VGND VPWR VPWR _1042_ sky130_fd_sc_hd__buf_4
XTAP_TAPCELL_ROW_38_702 VGND VPWR sky130_fd_sc_hd__tapvpwrvgnd_1
XTAP_TAPCELL_ROW_38_713 VGND VPWR sky130_fd_sc_hd__tapvpwrvgnd_1
X_8992_ clknet_leaf_69_CLK _0225_ VGND VGND VPWR VPWR RF.reg_arr\[27\]\[2\] sky130_fd_sc_hd__dfxtp_1
X_7943_ _3031_ net856 _3933_ VGND VGND VPWR VPWR _3940_ sky130_fd_sc_hd__mux2_1
XFILLER_0_54_83 VGND VGND VPWR VPWR sky130_fd_sc_hd__fill_1
X_7874_ _3903_ VGND VGND VPWR VPWR _0462_ sky130_fd_sc_hd__clkbuf_1
XTAP_TAPCELL_ROW_18_470 VGND VPWR sky130_fd_sc_hd__tapvpwrvgnd_1
X_6825_ net311 _3039_ _3329_ VGND VGND VPWR VPWR _3330_ sky130_fd_sc_hd__mux2_1
XFILLER_0_92_437 VGND VGND VPWR VPWR sky130_fd_sc_hd__fill_2
X_6756_ _3100_ net461 _3292_ VGND VGND VPWR VPWR _3293_ sky130_fd_sc_hd__mux2_1
XFILLER_0_107_219 VGND VGND VPWR VPWR sky130_fd_sc_hd__fill_2
X_5707_ _1648_ _2293_ _2218_ VGND VGND VPWR VPWR _2492_ sky130_fd_sc_hd__o21ba_1
XFILLER_0_73_673 VGND VGND VPWR VPWR sky130_fd_sc_hd__decap_3
XFILLER_0_115_241 VGND VGND VPWR VPWR sky130_fd_sc_hd__decap_4
XFILLER_0_72_161 VGND VGND VPWR VPWR sky130_fd_sc_hd__fill_1
X_6687_ _3255_ VGND VGND VPWR VPWR _0947_ sky130_fd_sc_hd__clkbuf_1
X_9475_ clknet_leaf_80_CLK _0708_ VGND VGND VPWR VPWR RF.reg_arr\[11\]\[5\] sky130_fd_sc_hd__dfxtp_1
X_5638_ _2423_ _2424_ _2197_ VGND VGND VPWR VPWR _2425_ sky130_fd_sc_hd__mux2_1
XFILLER_0_33_559 VGND VGND VPWR VPWR sky130_fd_sc_hd__fill_1
X_8426_ _4195_ VGND VGND VPWR VPWR _0722_ sky130_fd_sc_hd__clkbuf_1
X_5569_ _1113_ _1754_ VGND VGND VPWR VPWR _2357_ sky130_fd_sc_hd__nor2_1
XFILLER_0_103_447 VGND VGND VPWR VPWR sky130_fd_sc_hd__fill_1
XFILLER_0_41_570 VGND VGND VPWR VPWR sky130_fd_sc_hd__decap_4
X_8357_ _3037_ net906 _4149_ VGND VGND VPWR VPWR _4159_ sky130_fd_sc_hd__mux2_1
Xhold151 RF.reg_arr\[5\]\[20\] VGND VGND VPWR VPWR net233 sky130_fd_sc_hd__dlygate4sd3_1
X_7308_ _3073_ net912 _3594_ VGND VGND VPWR VPWR _3602_ sky130_fd_sc_hd__mux2_1
Xhold162 RF.reg_arr\[19\]\[3\] VGND VGND VPWR VPWR net244 sky130_fd_sc_hd__dlygate4sd3_1
Xhold140 RF.reg_arr\[28\]\[10\] VGND VGND VPWR VPWR net222 sky130_fd_sc_hd__dlygate4sd3_1
Xhold184 RF.reg_arr\[11\]\[31\] VGND VGND VPWR VPWR net266 sky130_fd_sc_hd__dlygate4sd3_1
Xhold173 RF.reg_arr\[9\]\[23\] VGND VGND VPWR VPWR net255 sky130_fd_sc_hd__dlygate4sd3_1
Xhold195 RF.reg_arr\[3\]\[1\] VGND VGND VPWR VPWR net277 sky130_fd_sc_hd__dlygate4sd3_1
X_8288_ _4122_ VGND VGND VPWR VPWR _0657_ sky130_fd_sc_hd__clkbuf_1
X_7239_ _3565_ VGND VGND VPWR VPWR _0165_ sky130_fd_sc_hd__clkbuf_1
XFILLER_0_95_242 VGND VGND VPWR VPWR sky130_fd_sc_hd__fill_1
XFILLER_0_49_670 VGND VGND VPWR VPWR sky130_fd_sc_hd__fill_2
XFILLER_0_55_128 VGND VGND VPWR VPWR sky130_fd_sc_hd__fill_1
XFILLER_0_64_662 VGND VGND VPWR VPWR sky130_fd_sc_hd__fill_1
XTAP_TAPCELL_ROW_114_1623 VGND VPWR sky130_fd_sc_hd__tapvpwrvgnd_1
XFILLER_0_32_581 VGND VGND VPWR VPWR sky130_fd_sc_hd__decap_6
XFILLER_0_75_38 VGND VGND VPWR VPWR sky130_fd_sc_hd__decap_6
XFILLER_0_115_55 VGND VGND VPWR VPWR sky130_fd_sc_hd__fill_1
X_4940_ RF.reg_arr\[0\]\[1\] RF.reg_arr\[1\]\[1\] RF.reg_arr\[2\]\[1\] RF.reg_arr\[3\]\[1\]
+ _1050_ _1052_ VGND VGND VPWR VPWR _1729_ sky130_fd_sc_hd__mux4_1
X_4871_ RF.reg_arr\[0\]\[30\] RF.reg_arr\[1\]\[30\] RF.reg_arr\[2\]\[30\] RF.reg_arr\[3\]\[30\]
+ _1593_ _1600_ VGND VGND VPWR VPWR _1660_ sky130_fd_sc_hd__mux4_1
XFILLER_0_59_478 VGND VGND VPWR VPWR sky130_fd_sc_hd__fill_1
XFILLER_0_24_64 VGND VGND VPWR VPWR sky130_fd_sc_hd__decap_8
XFILLER_0_86_297 VGND VGND VPWR VPWR sky130_fd_sc_hd__decap_3
XFILLER_0_39_180 VGND VGND VPWR VPWR sky130_fd_sc_hd__fill_2
XTAP_TAPCELL_ROW_43_771 VGND VPWR sky130_fd_sc_hd__tapvpwrvgnd_1
X_6610_ _3214_ VGND VGND VPWR VPWR _0911_ sky130_fd_sc_hd__clkbuf_1
XFILLER_0_46_139 VGND VGND VPWR VPWR sky130_fd_sc_hd__fill_1
X_7590_ net751 _3409_ _3752_ VGND VGND VPWR VPWR _3753_ sky130_fd_sc_hd__mux2_1
XFILLER_0_39_191 VGND VGND VPWR VPWR sky130_fd_sc_hd__decap_4
X_6541_ net892 _3031_ _3171_ VGND VGND VPWR VPWR _3178_ sky130_fd_sc_hd__mux2_1
XFILLER_0_6_236 VGND VGND VPWR VPWR sky130_fd_sc_hd__decap_4
XFILLER_0_55_673 VGND VGND VPWR VPWR sky130_fd_sc_hd__decap_3
X_9260_ clknet_leaf_102_CLK _0493_ VGND VGND VPWR VPWR RF.reg_arr\[21\]\[14\] sky130_fd_sc_hd__dfxtp_1
X_6472_ net129 VGND VGND VPWR VPWR _3141_ sky130_fd_sc_hd__clkbuf_1
X_9191_ clknet_leaf_77_CLK _0424_ VGND VGND VPWR VPWR RF.reg_arr\[24\]\[9\] sky130_fd_sc_hd__dfxtp_1
X_8211_ _3027_ net741 _4077_ VGND VGND VPWR VPWR _4082_ sky130_fd_sc_hd__mux2_1
X_5423_ RF.reg_arr\[4\]\[4\] RF.reg_arr\[5\]\[4\] RF.reg_arr\[6\]\[4\] RF.reg_arr\[7\]\[4\]
+ _1674_ _1680_ VGND VGND VPWR VPWR _2212_ sky130_fd_sc_hd__mux4_1
X_5354_ RF.reg_arr\[16\]\[15\] RF.reg_arr\[17\]\[15\] RF.reg_arr\[18\]\[15\] RF.reg_arr\[19\]\[15\]
+ _1847_ _1850_ VGND VGND VPWR VPWR _2143_ sky130_fd_sc_hd__mux4_1
X_8142_ _4045_ VGND VGND VPWR VPWR _0588_ sky130_fd_sc_hd__clkbuf_1
X_4305_ _1028_ VGND VGND VPWR VPWR _1094_ sky130_fd_sc_hd__clkbuf_4
X_8073_ _3025_ net352 _4005_ VGND VGND VPWR VPWR _4009_ sky130_fd_sc_hd__mux2_1
X_5285_ _2070_ _2071_ _2072_ _2073_ _1612_ _1845_ VGND VGND VPWR VPWR _2074_ sky130_fd_sc_hd__mux4_1
X_7024_ _3451_ VGND VGND VPWR VPWR _0064_ sky130_fd_sc_hd__clkbuf_1
X_4236_ net8 VGND VGND VPWR VPWR _1025_ sky130_fd_sc_hd__inv_4
XFILLER_0_97_518 VGND VGND VPWR VPWR sky130_fd_sc_hd__fill_1
X_8975_ clknet_leaf_106_CLK _0208_ VGND VGND VPWR VPWR RF.reg_arr\[31\]\[17\] sky130_fd_sc_hd__dfxtp_1
X_7926_ _3014_ net863 _3922_ VGND VGND VPWR VPWR _3931_ sky130_fd_sc_hd__mux2_1
XFILLER_0_81_70 VGND VGND VPWR VPWR sky130_fd_sc_hd__fill_1
X_7857_ _3894_ VGND VGND VPWR VPWR _0454_ sky130_fd_sc_hd__clkbuf_1
X_6808_ net1088 _3023_ _3318_ VGND VGND VPWR VPWR _3321_ sky130_fd_sc_hd__mux2_1
X_7788_ _3857_ VGND VGND VPWR VPWR _0422_ sky130_fd_sc_hd__clkbuf_1
X_6739_ _3084_ net796 _3281_ VGND VGND VPWR VPWR _3284_ sky130_fd_sc_hd__mux2_1
X_9458_ clknet_leaf_41_CLK _0691_ VGND VGND VPWR VPWR RF.reg_arr\[12\]\[20\] sky130_fd_sc_hd__dfxtp_1
XTAP_TAPCELL_ROW_21_498 VGND VPWR sky130_fd_sc_hd__tapvpwrvgnd_1
X_8409_ net784 _3412_ _4185_ VGND VGND VPWR VPWR _4187_ sky130_fd_sc_hd__mux2_1
X_9389_ clknet_leaf_104_CLK _0622_ VGND VGND VPWR VPWR RF.reg_arr\[13\]\[15\] sky130_fd_sc_hd__dfxtp_1
XTAP_TAPCELL_ROW_64_1021 VGND VPWR sky130_fd_sc_hd__tapvpwrvgnd_1
XTAP_TAPCELL_ROW_29_598 VGND VPWR sky130_fd_sc_hd__tapvpwrvgnd_1
XFILLER_0_96_584 VGND VGND VPWR VPWR sky130_fd_sc_hd__decap_4
XFILLER_0_68_297 VGND VGND VPWR VPWR sky130_fd_sc_hd__fill_1
XFILLER_0_37_651 VGND VGND VPWR VPWR sky130_fd_sc_hd__decap_4
XTAP_TAPCELL_ROW_40_730 VGND VPWR sky130_fd_sc_hd__tapvpwrvgnd_1
XFILLER_0_52_643 VGND VGND VPWR VPWR sky130_fd_sc_hd__fill_1
XFILLER_0_52_654 VGND VGND VPWR VPWR sky130_fd_sc_hd__fill_1
XFILLER_0_101_57 VGND VGND VPWR VPWR sky130_fd_sc_hd__fill_1
Xhold909 RF.reg_arr\[17\]\[25\] VGND VGND VPWR VPWR net991 sky130_fd_sc_hd__dlygate4sd3_1
XTAP_TAPCELL_ROW_75_1150 VGND VPWR sky130_fd_sc_hd__tapvpwrvgnd_1
X_5070_ _1858_ VGND VGND VPWR VPWR _1859_ sky130_fd_sc_hd__clkbuf_4
XTAP_TAPCELL_ROW_48_830 VGND VPWR sky130_fd_sc_hd__tapvpwrvgnd_1
X_8760_ clknet_leaf_50_CLK _1017_ VGND VGND VPWR VPWR RF.reg_arr\[6\]\[26\] sky130_fd_sc_hd__dfxtp_1
X_5972_ _2742_ _2736_ _2743_ VGND VGND VPWR VPWR _2744_ sky130_fd_sc_hd__a21oi_1
XFILLER_0_87_540 VGND VGND VPWR VPWR sky130_fd_sc_hd__decap_8
X_4923_ RF.reg_arr\[4\]\[28\] RF.reg_arr\[5\]\[28\] RF.reg_arr\[6\]\[28\] RF.reg_arr\[7\]\[28\]
+ _1678_ _1684_ VGND VGND VPWR VPWR _1712_ sky130_fd_sc_hd__mux4_1
X_7711_ net221 _3395_ _3813_ VGND VGND VPWR VPWR _3817_ sky130_fd_sc_hd__mux2_1
X_8691_ clknet_leaf_42_CLK _0948_ VGND VGND VPWR VPWR RF.reg_arr\[15\]\[21\] sky130_fd_sc_hd__dfxtp_1
X_7642_ _3780_ VGND VGND VPWR VPWR _0353_ sky130_fd_sc_hd__clkbuf_1
XFILLER_0_7_501 VGND VGND VPWR VPWR sky130_fd_sc_hd__decap_3
X_4854_ _1642_ VGND VGND VPWR VPWR _1643_ sky130_fd_sc_hd__clkbuf_8
X_4785_ _1572_ _1573_ _1296_ VGND VGND VPWR VPWR _1574_ sky130_fd_sc_hd__mux2_1
XFILLER_0_105_509 VGND VGND VPWR VPWR sky130_fd_sc_hd__fill_1
X_7573_ net500 _3393_ _3741_ VGND VGND VPWR VPWR _3744_ sky130_fd_sc_hd__mux2_1
XFILLER_0_62_418 VGND VGND VPWR VPWR sky130_fd_sc_hd__fill_2
X_9312_ clknet_leaf_55_CLK _0545_ VGND VGND VPWR VPWR RF.reg_arr\[20\]\[2\] sky130_fd_sc_hd__dfxtp_1
X_6524_ net477 _3014_ _3160_ VGND VGND VPWR VPWR _3169_ sky130_fd_sc_hd__mux2_1
XFILLER_0_55_492 VGND VGND VPWR VPWR sky130_fd_sc_hd__fill_1
X_9243_ clknet_leaf_30_CLK _0476_ VGND VGND VPWR VPWR RF.reg_arr\[22\]\[29\] sky130_fd_sc_hd__dfxtp_1
Xclkload71 clknet_leaf_73_CLK VGND VGND VPWR VPWR clkload71/Y sky130_fd_sc_hd__inv_6
X_6455_ _3132_ VGND VGND VPWR VPWR _0838_ sky130_fd_sc_hd__clkbuf_1
Xclkload60 clknet_leaf_90_CLK VGND VGND VPWR VPWR clkload60/Y sky130_fd_sc_hd__inv_8
XFILLER_0_113_597 VPWR VGND VPWR VGND sky130_ef_sc_hd__decap_12
X_9174_ clknet_leaf_36_CLK _0407_ VGND VGND VPWR VPWR RF.reg_arr\[9\]\[24\] sky130_fd_sc_hd__dfxtp_1
X_5406_ _2176_ _2194_ VGND VGND VPWR VPWR _2195_ sky130_fd_sc_hd__nand2_1
Xclkload82 clknet_leaf_44_CLK VGND VGND VPWR VPWR clkload82/Y sky130_fd_sc_hd__inv_6
Xclkload93 clknet_leaf_63_CLK VGND VGND VPWR VPWR clkload93/Y sky130_fd_sc_hd__clkinvlp_2
X_6386_ _3088_ net734 _3080_ VGND VGND VPWR VPWR _3089_ sky130_fd_sc_hd__mux2_1
XFILLER_0_11_573 VGND VGND VPWR VPWR sky130_fd_sc_hd__fill_1
X_5337_ RF.reg_arr\[16\]\[14\] RF.reg_arr\[17\]\[14\] RF.reg_arr\[18\]\[14\] RF.reg_arr\[19\]\[14\]
+ _2087_ _1859_ VGND VGND VPWR VPWR _2126_ sky130_fd_sc_hd__mux4_1
X_8125_ _4036_ VGND VGND VPWR VPWR _0580_ sky130_fd_sc_hd__clkbuf_1
X_8056_ _3008_ net922 _3994_ VGND VGND VPWR VPWR _4000_ sky130_fd_sc_hd__mux2_1
X_5268_ _2055_ _2056_ _1942_ VGND VGND VPWR VPWR _2057_ sky130_fd_sc_hd__mux2_1
X_7007_ _3441_ VGND VGND VPWR VPWR _0057_ sky130_fd_sc_hd__clkbuf_1
XTAP_TAPCELL_ROW_89_1319 VGND VPWR sky130_fd_sc_hd__tapvpwrvgnd_1
X_5199_ _1984_ _1987_ _1842_ VGND VGND VPWR VPWR _1988_ sky130_fd_sc_hd__mux2_1
XFILLER_0_78_540 VGND VGND VPWR VPWR sky130_fd_sc_hd__decap_8
X_8958_ clknet_leaf_74_CLK _0191_ VGND VGND VPWR VPWR RF.reg_arr\[31\]\[0\] sky130_fd_sc_hd__dfxtp_1
X_7909_ _3921_ VGND VGND VPWR VPWR _3922_ sky130_fd_sc_hd__buf_6
X_8889_ clknet_leaf_48_CLK _0122_ VGND VGND VPWR VPWR RF.reg_arr\[3\]\[27\] sky130_fd_sc_hd__dfxtp_1
XTAP_TAPCELL_ROW_26_568 VGND VPWR sky130_fd_sc_hd__tapvpwrvgnd_1
XTAP_TAPCELL_ROW_54_899 VGND VPWR sky130_fd_sc_hd__tapvpwrvgnd_1
XFILLER_0_93_576 VGND VGND VPWR VPWR sky130_fd_sc_hd__decap_4
XFILLER_0_65_278 VGND VGND VPWR VPWR sky130_fd_sc_hd__fill_2
XFILLER_0_33_175 VGND VGND VPWR VPWR sky130_fd_sc_hd__fill_1
XTAP_TAPCELL_ROW_70_1091 VGND VPWR sky130_fd_sc_hd__tapvpwrvgnd_1
XTAP_TAPCELL_ROW_109_1555 VGND VPWR sky130_fd_sc_hd__tapvpwrvgnd_1
XFILLER_0_84_587 VGND VGND VPWR VPWR sky130_fd_sc_hd__fill_1
XFILLER_0_44_429 VGND VGND VPWR VPWR sky130_fd_sc_hd__fill_2
XFILLER_0_112_67 VGND VGND VPWR VPWR sky130_fd_sc_hd__fill_1
X_4570_ RF.reg_arr\[8\]\[21\] RF.reg_arr\[9\]\[21\] RF.reg_arr\[10\]\[21\] RF.reg_arr\[11\]\[21\]
+ _1357_ _1358_ VGND VGND VPWR VPWR _1359_ sky130_fd_sc_hd__mux4_1
XFILLER_0_107_391 VGND VGND VPWR VPWR sky130_fd_sc_hd__fill_1
Xhold717 RF.reg_arr\[25\]\[30\] VGND VGND VPWR VPWR net799 sky130_fd_sc_hd__dlygate4sd3_1
Xhold706 RF.reg_arr\[27\]\[9\] VGND VGND VPWR VPWR net788 sky130_fd_sc_hd__dlygate4sd3_1
Xhold728 RF.reg_arr\[27\]\[13\] VGND VGND VPWR VPWR net810 sky130_fd_sc_hd__dlygate4sd3_1
X_6240_ net475 _2990_ _2978_ VGND VGND VPWR VPWR _2991_ sky130_fd_sc_hd__mux2_1
Xhold739 RF.reg_arr\[8\]\[19\] VGND VGND VPWR VPWR net821 sky130_fd_sc_hd__dlygate4sd3_1
X_6171_ _2050_ _2785_ _2931_ _2026_ VGND VGND VPWR VPWR _2932_ sky130_fd_sc_hd__a211o_1
X_5122_ _1587_ _1902_ _1906_ _1910_ VGND VGND VPWR VPWR _1911_ sky130_fd_sc_hd__o2bb2a_2
X_5053_ _1616_ VGND VGND VPWR VPWR _1842_ sky130_fd_sc_hd__clkbuf_8
XFILLER_0_79_337 VGND VGND VPWR VPWR sky130_fd_sc_hd__decap_8
X_8812_ clknet_leaf_95_CLK _0045_ VGND VGND VPWR VPWR RF.reg_arr\[4\]\[14\] sky130_fd_sc_hd__dfxtp_1
XFILLER_0_87_381 VGND VGND VPWR VPWR sky130_fd_sc_hd__fill_1
X_5955_ _2646_ _2647_ VGND VGND VPWR VPWR _2728_ sky130_fd_sc_hd__or2_1
X_8743_ clknet_leaf_88_CLK _1000_ VGND VGND VPWR VPWR RF.reg_arr\[6\]\[9\] sky130_fd_sc_hd__dfxtp_1
XFILLER_0_47_201 VGND VGND VPWR VPWR sky130_fd_sc_hd__decap_6
X_5886_ _1739_ _2662_ _1024_ VGND VGND VPWR VPWR _2663_ sky130_fd_sc_hd__o21a_1
X_4906_ _1637_ _1694_ _1644_ VGND VGND VPWR VPWR _1695_ sky130_fd_sc_hd__o21ai_1
XTAP_TAPCELL_ROW_23_527 VGND VPWR sky130_fd_sc_hd__tapvpwrvgnd_1
X_8674_ clknet_leaf_74_CLK _0931_ VGND VGND VPWR VPWR RF.reg_arr\[15\]\[4\] sky130_fd_sc_hd__dfxtp_1
X_7625_ net368 _3377_ _3763_ VGND VGND VPWR VPWR _3771_ sky130_fd_sc_hd__mux2_1
X_4837_ _1625_ VGND VGND VPWR VPWR _1626_ sky130_fd_sc_hd__buf_4
XTAP_TAPCELL_ROW_51_858 VGND VPWR sky130_fd_sc_hd__tapvpwrvgnd_1
XTAP_TAPCELL_ROW_51_869 VGND VPWR sky130_fd_sc_hd__tapvpwrvgnd_1
XFILLER_0_7_353 VGND VGND VPWR VPWR sky130_fd_sc_hd__fill_2
X_7556_ _3734_ VGND VGND VPWR VPWR _0313_ sky130_fd_sc_hd__clkbuf_1
X_4768_ RF.reg_arr\[12\]\[25\] RF.reg_arr\[13\]\[25\] RF.reg_arr\[14\]\[25\] RF.reg_arr\[15\]\[25\]
+ _1327_ _1328_ VGND VGND VPWR VPWR _1557_ sky130_fd_sc_hd__mux4_1
X_7487_ _3115_ net618 _3689_ VGND VGND VPWR VPWR _3697_ sky130_fd_sc_hd__mux2_1
X_6507_ _3159_ VGND VGND VPWR VPWR _3160_ sky130_fd_sc_hd__clkbuf_8
X_4699_ RF.reg_arr\[24\]\[12\] RF.reg_arr\[25\]\[12\] RF.reg_arr\[26\]\[12\] RF.reg_arr\[27\]\[12\]
+ _1051_ _1053_ VGND VGND VPWR VPWR _1488_ sky130_fd_sc_hd__mux4_1
XFILLER_0_101_501 VGND VGND VPWR VPWR sky130_fd_sc_hd__decap_3
X_6438_ _3123_ net776 _3058_ VGND VGND VPWR VPWR _3124_ sky130_fd_sc_hd__mux2_1
X_9226_ clknet_leaf_100_CLK _0459_ VGND VGND VPWR VPWR RF.reg_arr\[22\]\[12\] sky130_fd_sc_hd__dfxtp_1
XFILLER_0_101_545 VGND VGND VPWR VPWR sky130_fd_sc_hd__decap_4
XTAP_TAPCELL_ROW_95_1389 VGND VPWR sky130_fd_sc_hd__tapvpwrvgnd_1
X_9157_ clknet_leaf_85_CLK _0390_ VGND VGND VPWR VPWR RF.reg_arr\[9\]\[7\] sky130_fd_sc_hd__dfxtp_1
XFILLER_0_30_178 VGND VGND VPWR VPWR sky130_fd_sc_hd__fill_1
X_8108_ _2990_ net947 _3993_ VGND VGND VPWR VPWR _4027_ sky130_fd_sc_hd__mux2_1
X_6369_ net45 VGND VGND VPWR VPWR _3077_ sky130_fd_sc_hd__buf_2
Xhold22 RF.reg_arr\[0\]\[24\] VGND VGND VPWR VPWR net104 sky130_fd_sc_hd__dlygate4sd3_1
X_9088_ clknet_leaf_60_CLK _0321_ VGND VGND VPWR VPWR RF.reg_arr\[2\]\[2\] sky130_fd_sc_hd__dfxtp_1
X_8039_ _3990_ VGND VGND VPWR VPWR _0540_ sky130_fd_sc_hd__clkbuf_1
Xhold55 RF.reg_arr\[1\]\[5\] VGND VGND VPWR VPWR net137 sky130_fd_sc_hd__dlygate4sd3_1
Xhold33 RF.reg_arr\[0\]\[6\] VGND VGND VPWR VPWR net115 sky130_fd_sc_hd__dlygate4sd3_1
Xhold44 RF.reg_arr\[0\]\[11\] VGND VGND VPWR VPWR net126 sky130_fd_sc_hd__dlygate4sd3_1
Xhold99 RF.reg_arr\[10\]\[24\] VGND VGND VPWR VPWR net181 sky130_fd_sc_hd__dlygate4sd3_1
XTAP_TAPCELL_ROW_59_958 VGND VPWR sky130_fd_sc_hd__tapvpwrvgnd_1
Xhold88 RF.reg_arr\[17\]\[16\] VGND VGND VPWR VPWR net170 sky130_fd_sc_hd__dlygate4sd3_1
Xhold77 RF.reg_arr\[7\]\[15\] VGND VGND VPWR VPWR net159 sky130_fd_sc_hd__dlygate4sd3_1
Xhold66 RF.reg_arr\[3\]\[9\] VGND VGND VPWR VPWR net148 sky130_fd_sc_hd__dlygate4sd3_1
XTAP_TAPCELL_ROW_3_285 VGND VPWR sky130_fd_sc_hd__tapvpwrvgnd_1
XTAP_TAPCELL_ROW_104_1496 VGND VPWR sky130_fd_sc_hd__tapvpwrvgnd_1
XFILLER_0_61_281 VGND VGND VPWR VPWR sky130_fd_sc_hd__decap_6
XANTENNA_8 _1106_ VGND VGND VPWR VPWR sky130_fd_sc_hd__diode_2
XFILLER_0_21_145 VGND VGND VPWR VPWR sky130_fd_sc_hd__decap_4
XTAP_TAPCELL_ROW_72_1120 VGND VPWR sky130_fd_sc_hd__tapvpwrvgnd_1
XFILLER_0_107_23 VGND VGND VPWR VPWR sky130_fd_sc_hd__fill_2
XFILLER_0_107_78 VGND VGND VPWR VPWR sky130_fd_sc_hd__decap_3
X_5740_ _1792_ _2235_ _2273_ VGND VGND VPWR VPWR _2523_ sky130_fd_sc_hd__a21bo_1
XFILLER_0_17_429 VGND VGND VPWR VPWR sky130_fd_sc_hd__decap_4
XFILLER_0_115_615 VGND VGND VPWR VPWR sky130_fd_sc_hd__fill_1
X_7410_ _3107_ net555 _3652_ VGND VGND VPWR VPWR _3656_ sky130_fd_sc_hd__mux2_1
X_5671_ _2456_ VGND VGND VPWR VPWR _2457_ sky130_fd_sc_hd__inv_2
XFILLER_0_72_557 VGND VGND VPWR VPWR sky130_fd_sc_hd__fill_1
XFILLER_0_4_334 VGND VGND VPWR VPWR sky130_fd_sc_hd__decap_4
X_4622_ RF.reg_arr\[4\]\[7\] RF.reg_arr\[5\]\[7\] RF.reg_arr\[6\]\[7\] RF.reg_arr\[7\]\[7\]
+ _1082_ _1084_ VGND VGND VPWR VPWR _1411_ sky130_fd_sc_hd__mux4_1
X_8390_ net324 _3393_ _4174_ VGND VGND VPWR VPWR _4177_ sky130_fd_sc_hd__mux2_1
XFILLER_0_114_147 VGND VGND VPWR VPWR sky130_fd_sc_hd__fill_1
X_7341_ _3619_ VGND VGND VPWR VPWR _0213_ sky130_fd_sc_hd__clkbuf_1
XFILLER_0_12_101 VGND VGND VPWR VPWR sky130_fd_sc_hd__fill_2
XFILLER_0_25_495 VGND VGND VPWR VPWR sky130_fd_sc_hd__fill_1
X_4553_ net93 VGND VGND VPWR VPWR _1342_ sky130_fd_sc_hd__buf_4
XFILLER_0_40_421 VGND VGND VPWR VPWR sky130_fd_sc_hd__fill_2
Xhold536 RF.reg_arr\[26\]\[27\] VGND VGND VPWR VPWR net618 sky130_fd_sc_hd__dlygate4sd3_1
X_4484_ _1175_ VGND VGND VPWR VPWR _1273_ sky130_fd_sc_hd__buf_6
X_7272_ _3105_ net307 _3580_ VGND VGND VPWR VPWR _3583_ sky130_fd_sc_hd__mux2_1
XFILLER_0_12_134 VGND VGND VPWR VPWR sky130_fd_sc_hd__decap_3
Xhold503 RF.reg_arr\[19\]\[4\] VGND VGND VPWR VPWR net585 sky130_fd_sc_hd__dlygate4sd3_1
Xhold514 RF.reg_arr\[2\]\[5\] VGND VGND VPWR VPWR net596 sky130_fd_sc_hd__dlygate4sd3_1
Xhold525 RF.reg_arr\[3\]\[4\] VGND VGND VPWR VPWR net607 sky130_fd_sc_hd__dlygate4sd3_1
X_6223_ _2979_ VGND VGND VPWR VPWR _0759_ sky130_fd_sc_hd__clkbuf_1
X_9011_ clknet_leaf_46_CLK _0244_ VGND VGND VPWR VPWR RF.reg_arr\[27\]\[21\] sky130_fd_sc_hd__dfxtp_1
Xhold569 RF.reg_arr\[8\]\[7\] VGND VGND VPWR VPWR net651 sky130_fd_sc_hd__dlygate4sd3_1
Xhold547 RF.reg_arr\[5\]\[9\] VGND VGND VPWR VPWR net629 sky130_fd_sc_hd__dlygate4sd3_1
Xhold558 RF.reg_arr\[13\]\[11\] VGND VGND VPWR VPWR net640 sky130_fd_sc_hd__dlygate4sd3_1
X_6154_ _1293_ _2914_ VGND VGND VPWR VPWR _2915_ sky130_fd_sc_hd__xnor2_1
X_5105_ _1870_ _1893_ VGND VGND VPWR VPWR _1894_ sky130_fd_sc_hd__nand2_1
X_6085_ _2831_ _2832_ _2814_ VGND VGND VPWR VPWR _2850_ sky130_fd_sc_hd__or3b_4
X_5036_ RF.reg_arr\[8\]\[2\] RF.reg_arr\[9\]\[2\] RF.reg_arr\[10\]\[2\] RF.reg_arr\[11\]\[2\]
+ _1043_ _1083_ VGND VGND VPWR VPWR _1825_ sky130_fd_sc_hd__mux4_1
XTAP_TAPCELL_ROW_56_928 VGND VPWR sky130_fd_sc_hd__tapvpwrvgnd_1
XFILLER_0_79_156 VGND VGND VPWR VPWR sky130_fd_sc_hd__decap_4
XFILLER_0_73_60 VGND VGND VPWR VPWR sky130_fd_sc_hd__fill_1
XTAP_TAPCELL_ROW_0_244 VGND VPWR sky130_fd_sc_hd__tapvpwrvgnd_1
XTAP_TAPCELL_ROW_0_255 VGND VPWR sky130_fd_sc_hd__tapvpwrvgnd_1
X_6987_ net366 _3428_ _3410_ VGND VGND VPWR VPWR _3429_ sky130_fd_sc_hd__mux2_1
X_8726_ clknet_leaf_36_CLK _0983_ VGND VGND VPWR VPWR RF.reg_arr\[14\]\[24\] sky130_fd_sc_hd__dfxtp_1
X_5938_ _2026_ _2709_ _2710_ _2711_ VGND VGND VPWR VPWR _2712_ sky130_fd_sc_hd__o211a_1
XTAP_TAPCELL_ROW_36_685 VGND VPWR sky130_fd_sc_hd__tapvpwrvgnd_1
XFILLER_0_75_373 VGND VGND VPWR VPWR sky130_fd_sc_hd__decap_8
X_5869_ _2644_ _2645_ _2175_ VGND VGND VPWR VPWR _2646_ sky130_fd_sc_hd__a21oi_1
XFILLER_0_75_384 VGND VGND VPWR VPWR sky130_fd_sc_hd__fill_2
X_8657_ clknet_leaf_7_CLK _0914_ VGND VGND VPWR VPWR RF.reg_arr\[8\]\[19\] sky130_fd_sc_hd__dfxtp_1
XTAP_TAPCELL_ROW_97_1418 VGND VPWR sky130_fd_sc_hd__tapvpwrvgnd_1
XFILLER_0_90_365 VGND VGND VPWR VPWR sky130_fd_sc_hd__fill_2
X_8588_ clknet_leaf_96_CLK _0845_ VGND VGND VPWR VPWR RF.reg_arr\[0\]\[14\] sky130_fd_sc_hd__dfxtp_1
X_7608_ net1029 _3428_ _3752_ VGND VGND VPWR VPWR _3762_ sky130_fd_sc_hd__mux2_1
X_7539_ _3725_ VGND VGND VPWR VPWR _0305_ sky130_fd_sc_hd__clkbuf_1
XFILLER_0_114_681 VGND VGND VPWR VPWR sky130_fd_sc_hd__decap_8
XFILLER_0_105_169 VGND VGND VPWR VPWR sky130_fd_sc_hd__decap_4
XFILLER_0_101_320 VGND VGND VPWR VPWR sky130_fd_sc_hd__fill_1
X_9209_ clknet_leaf_32_CLK _0442_ VGND VGND VPWR VPWR RF.reg_arr\[24\]\[27\] sky130_fd_sc_hd__dfxtp_1
Xoutput56 net56 VGND VGND VPWR VPWR result[16] sky130_fd_sc_hd__clkbuf_4
Xoutput67 net67 VGND VGND VPWR VPWR result[26] sky130_fd_sc_hd__clkbuf_4
XTAP_TAPCELL_ROW_8_344 VGND VPWR sky130_fd_sc_hd__tapvpwrvgnd_1
Xoutput78 net78 VGND VGND VPWR VPWR result[7] sky130_fd_sc_hd__clkbuf_4
XFILLER_0_98_421 VGND VGND VPWR VPWR sky130_fd_sc_hd__decap_6
XTAP_TAPCELL_ROW_106_1525 VGND VPWR sky130_fd_sc_hd__tapvpwrvgnd_1
XPHY_EDGE_ROW_113_Right_113 VGND VGND VPWR VPWR sky130_fd_sc_hd__decap_3
XFILLER_0_58_318 VGND VGND VPWR VPWR sky130_fd_sc_hd__fill_1
XFILLER_0_66_362 VGND VGND VPWR VPWR sky130_fd_sc_hd__fill_2
XFILLER_0_41_218 VGND VGND VPWR VPWR sky130_fd_sc_hd__decap_6
XFILLER_0_104_191 VGND VGND VPWR VPWR sky130_fd_sc_hd__fill_2
XFILLER_0_94_15 VGND VGND VPWR VPWR sky130_fd_sc_hd__fill_1
XFILLER_0_94_37 VGND VGND VPWR VPWR sky130_fd_sc_hd__fill_1
X_6910_ _3376_ VGND VGND VPWR VPWR _0025_ sky130_fd_sc_hd__clkbuf_1
X_7890_ _3107_ net371 _3908_ VGND VGND VPWR VPWR _3912_ sky130_fd_sc_hd__mux2_1
X_6841_ net391 _2986_ _3329_ VGND VGND VPWR VPWR _3338_ sky130_fd_sc_hd__mux2_1
XTAP_TAPCELL_ROW_81_1219 VGND VPWR sky130_fd_sc_hd__tapvpwrvgnd_1
X_6772_ _3117_ net826 _3292_ VGND VGND VPWR VPWR _3301_ sky130_fd_sc_hd__mux2_1
XFILLER_0_85_671 VGND VGND VPWR VPWR sky130_fd_sc_hd__fill_1
X_8511_ clknet_leaf_59_CLK _0768_ VGND VGND VPWR VPWR RF.reg_arr\[1\]\[1\] sky130_fd_sc_hd__dfxtp_1
XTAP_TAPCELL_ROW_33_644 VGND VPWR sky130_fd_sc_hd__tapvpwrvgnd_1
XFILLER_0_43_85 VGND VGND VPWR VPWR sky130_fd_sc_hd__fill_1
X_5723_ _2353_ _2489_ _2506_ _2022_ VGND VGND VPWR VPWR _2507_ sky130_fd_sc_hd__a2bb2o_1
X_9491_ clknet_leaf_42_CLK _0724_ VGND VGND VPWR VPWR RF.reg_arr\[11\]\[21\] sky130_fd_sc_hd__dfxtp_1
XTAP_TAPCELL_ROW_61_986 VGND VPWR sky130_fd_sc_hd__tapvpwrvgnd_1
X_8442_ net990 net33 _4196_ VGND VGND VPWR VPWR _4204_ sky130_fd_sc_hd__mux2_1
X_5654_ _1648_ _2331_ _2311_ VGND VGND VPWR VPWR _2441_ sky130_fd_sc_hd__o21a_1
XFILLER_0_72_343 VGND VGND VPWR VPWR sky130_fd_sc_hd__decap_4
XFILLER_0_115_445 VGND VGND VPWR VPWR sky130_fd_sc_hd__decap_3
X_8373_ _4167_ VGND VGND VPWR VPWR _0697_ sky130_fd_sc_hd__clkbuf_1
X_4605_ RF.reg_arr\[12\]\[6\] RF.reg_arr\[13\]\[6\] RF.reg_arr\[14\]\[6\] RF.reg_arr\[15\]\[6\]
+ _1051_ _1053_ VGND VGND VPWR VPWR _1394_ sky130_fd_sc_hd__mux4_1
X_5585_ _1833_ _1997_ _1114_ VGND VGND VPWR VPWR _2373_ sky130_fd_sc_hd__o21ai_1
X_7324_ _3610_ VGND VGND VPWR VPWR _0205_ sky130_fd_sc_hd__clkbuf_1
Xhold300 RF.reg_arr\[1\]\[14\] VGND VGND VPWR VPWR net382 sky130_fd_sc_hd__dlygate4sd3_1
XFILLER_0_25_281 VGND VGND VPWR VPWR sky130_fd_sc_hd__decap_3
Xhold311 RF.reg_arr\[18\]\[3\] VGND VGND VPWR VPWR net393 sky130_fd_sc_hd__dlygate4sd3_1
Xhold322 RF.reg_arr\[1\]\[25\] VGND VGND VPWR VPWR net404 sky130_fd_sc_hd__dlygate4sd3_1
X_4536_ _1323_ _1324_ _1308_ VGND VGND VPWR VPWR _1325_ sky130_fd_sc_hd__mux2_1
Xhold344 RF.reg_arr\[31\]\[20\] VGND VGND VPWR VPWR net426 sky130_fd_sc_hd__dlygate4sd3_1
Xhold333 RF.reg_arr\[7\]\[8\] VGND VGND VPWR VPWR net415 sky130_fd_sc_hd__dlygate4sd3_1
XFILLER_0_40_262 VGND VGND VPWR VPWR sky130_fd_sc_hd__fill_2
Xhold377 RF.reg_arr\[29\]\[29\] VGND VGND VPWR VPWR net459 sky130_fd_sc_hd__dlygate4sd3_1
XFILLER_0_111_673 VPWR VGND VPWR VGND sky130_ef_sc_hd__decap_12
XFILLER_0_111_651 VGND VGND VPWR VPWR sky130_fd_sc_hd__fill_1
XTAP_TAPCELL_ROW_92_1359 VGND VPWR sky130_fd_sc_hd__tapvpwrvgnd_1
Xhold355 RF.reg_arr\[7\]\[11\] VGND VGND VPWR VPWR net437 sky130_fd_sc_hd__dlygate4sd3_1
X_7255_ _3088_ net710 _3569_ VGND VGND VPWR VPWR _3574_ sky130_fd_sc_hd__mux2_1
X_4467_ RF.reg_arr\[20\]\[11\] RF.reg_arr\[21\]\[11\] RF.reg_arr\[22\]\[11\] RF.reg_arr\[23\]\[11\]
+ _1068_ _1069_ VGND VGND VPWR VPWR _1256_ sky130_fd_sc_hd__mux4_2
Xhold366 RF.reg_arr\[8\]\[10\] VGND VGND VPWR VPWR net448 sky130_fd_sc_hd__dlygate4sd3_1
X_6206_ _2960_ _2963_ VGND VGND VPWR VPWR _2964_ sky130_fd_sc_hd__xnor2_1
Xhold388 RF.reg_arr\[10\]\[27\] VGND VGND VPWR VPWR net470 sky130_fd_sc_hd__dlygate4sd3_1
Xhold399 RF.reg_arr\[4\]\[20\] VGND VGND VPWR VPWR net481 sky130_fd_sc_hd__dlygate4sd3_1
X_4398_ _1186_ VGND VGND VPWR VPWR _1187_ sky130_fd_sc_hd__buf_4
X_7186_ net332 _3418_ _3532_ VGND VGND VPWR VPWR _3537_ sky130_fd_sc_hd__mux2_1
X_6137_ _1432_ _2898_ VGND VGND VPWR VPWR _2899_ sky130_fd_sc_hd__xor2_1
XTAP_TAPCELL_ROW_5_314 VGND VPWR sky130_fd_sc_hd__tapvpwrvgnd_1
Xhold1000 RF.reg_arr\[12\]\[11\] VGND VGND VPWR VPWR net1082 sky130_fd_sc_hd__dlygate4sd3_1
Xhold1022 RF.reg_arr\[31\]\[31\] VGND VGND VPWR VPWR net1104 sky130_fd_sc_hd__dlygate4sd3_1
Xhold1033 RF.reg_arr\[26\]\[12\] VGND VGND VPWR VPWR net1115 sky130_fd_sc_hd__dlygate4sd3_1
Xhold1011 RF.reg_arr\[14\]\[11\] VGND VGND VPWR VPWR net1093 sky130_fd_sc_hd__dlygate4sd3_1
X_6068_ _1868_ _2813_ VGND VGND VPWR VPWR _2834_ sky130_fd_sc_hd__nor2_1
X_5019_ _1587_ _1799_ _1807_ VGND VGND VPWR VPWR _1808_ sky130_fd_sc_hd__a21oi_4
XFILLER_0_95_446 VGND VGND VPWR VPWR sky130_fd_sc_hd__fill_2
XFILLER_0_83_608 VGND VGND VPWR VPWR sky130_fd_sc_hd__decap_3
XTAP_TAPCELL_ROW_101_1466 VGND VPWR sky130_fd_sc_hd__tapvpwrvgnd_1
XFILLER_0_75_181 VGND VGND VPWR VPWR sky130_fd_sc_hd__fill_1
X_8709_ clknet_leaf_84_CLK _0966_ VGND VGND VPWR VPWR RF.reg_arr\[14\]\[7\] sky130_fd_sc_hd__dfxtp_1
XFILLER_0_51_505 VGND VGND VPWR VPWR sky130_fd_sc_hd__decap_6
XFILLER_0_16_270 VGND VGND VPWR VPWR sky130_fd_sc_hd__fill_1
XFILLER_0_51_549 VGND VGND VPWR VPWR sky130_fd_sc_hd__fill_2
XFILLER_0_31_273 VGND VGND VPWR VPWR sky130_fd_sc_hd__fill_1
XFILLER_0_101_161 VGND VGND VPWR VPWR sky130_fd_sc_hd__decap_6
XTAP_TAPCELL_ROW_112_1595 VGND VPWR sky130_fd_sc_hd__tapvpwrvgnd_1
XFILLER_0_98_273 VGND VGND VPWR VPWR sky130_fd_sc_hd__fill_1
XTAP_TAPCELL_ROW_67_1052 VGND VPWR sky130_fd_sc_hd__tapvpwrvgnd_1
XFILLER_0_59_638 VGND VGND VPWR VPWR sky130_fd_sc_hd__decap_4
XFILLER_0_86_446 VGND VGND VPWR VPWR sky130_fd_sc_hd__fill_2
XFILLER_0_39_373 VGND VGND VPWR VPWR sky130_fd_sc_hd__fill_1
XFILLER_0_82_663 VGND VGND VPWR VPWR sky130_fd_sc_hd__decap_4
XFILLER_0_82_641 VGND VGND VPWR VPWR sky130_fd_sc_hd__decap_3
XFILLER_0_81_140 VPWR VGND VPWR VGND sky130_ef_sc_hd__decap_12
XTAP_TAPCELL_ROW_30_614 VGND VPWR sky130_fd_sc_hd__tapvpwrvgnd_1
XFILLER_0_81_162 VGND VGND VPWR VPWR sky130_fd_sc_hd__decap_6
XFILLER_0_54_365 VGND VGND VPWR VPWR sky130_fd_sc_hd__decap_3
XFILLER_0_2_613 VPWR VGND VPWR VGND sky130_ef_sc_hd__decap_12
XFILLER_0_42_549 VGND VGND VPWR VPWR sky130_fd_sc_hd__decap_4
X_5370_ _2141_ _2158_ VGND VGND VPWR VPWR _2159_ sky130_fd_sc_hd__nand2_1
XTAP_TAPCELL_ROW_10_371 VGND VPWR sky130_fd_sc_hd__tapvpwrvgnd_1
XFILLER_0_2_657 VPWR VGND VPWR VGND sky130_ef_sc_hd__decap_12
XTAP_TAPCELL_ROW_78_1192 VGND VPWR sky130_fd_sc_hd__tapvpwrvgnd_1
XFILLER_0_10_435 VGND VGND VPWR VPWR sky130_fd_sc_hd__decap_8
X_4321_ _1055_ VGND VGND VPWR VPWR _1110_ sky130_fd_sc_hd__clkbuf_8
X_7040_ _3459_ VGND VGND VPWR VPWR _0072_ sky130_fd_sc_hd__clkbuf_1
X_4252_ _1032_ VGND VGND VPWR VPWR _1041_ sky130_fd_sc_hd__clkbuf_8
XFILLER_0_38_85 VGND VGND VPWR VPWR sky130_fd_sc_hd__decap_6
X_8991_ clknet_leaf_56_CLK _0224_ VGND VGND VPWR VPWR RF.reg_arr\[27\]\[1\] sky130_fd_sc_hd__dfxtp_1
XTAP_TAPCELL_ROW_38_703 VGND VPWR sky130_fd_sc_hd__tapvpwrvgnd_1
X_7942_ _3939_ VGND VGND VPWR VPWR _0494_ sky130_fd_sc_hd__clkbuf_1
X_7873_ _3090_ net736 _3897_ VGND VGND VPWR VPWR _3903_ sky130_fd_sc_hd__mux2_1
XFILLER_0_92_416 VGND VGND VPWR VPWR sky130_fd_sc_hd__fill_1
X_6824_ _3306_ VGND VGND VPWR VPWR _3329_ sky130_fd_sc_hd__buf_4
XFILLER_0_9_223 VGND VGND VPWR VPWR sky130_fd_sc_hd__fill_1
XTAP_TAPCELL_ROW_18_471 VGND VPWR sky130_fd_sc_hd__tapvpwrvgnd_1
X_6755_ _3269_ VGND VGND VPWR VPWR _3292_ sky130_fd_sc_hd__clkbuf_8
X_5706_ _1739_ _2489_ _2490_ _2051_ VGND VGND VPWR VPWR _2491_ sky130_fd_sc_hd__o22a_1
XFILLER_0_70_72 VGND VGND VPWR VPWR sky130_fd_sc_hd__fill_1
X_9474_ clknet_leaf_72_CLK _0707_ VGND VGND VPWR VPWR RF.reg_arr\[11\]\[4\] sky130_fd_sc_hd__dfxtp_1
X_6686_ _3100_ net808 _3254_ VGND VGND VPWR VPWR _3255_ sky130_fd_sc_hd__mux2_1
X_8425_ net754 _3428_ _4185_ VGND VGND VPWR VPWR _4195_ sky130_fd_sc_hd__mux2_1
X_5637_ _1999_ _2159_ _2366_ VGND VGND VPWR VPWR _2424_ sky130_fd_sc_hd__mux2_1
X_5568_ _2354_ _2355_ VGND VGND VPWR VPWR _2356_ sky130_fd_sc_hd__or2_1
X_8356_ _4158_ VGND VGND VPWR VPWR _0689_ sky130_fd_sc_hd__clkbuf_1
Xhold152 RF.reg_arr\[1\]\[28\] VGND VGND VPWR VPWR net234 sky130_fd_sc_hd__dlygate4sd3_1
Xhold141 RF.reg_arr\[21\]\[27\] VGND VGND VPWR VPWR net223 sky130_fd_sc_hd__dlygate4sd3_1
X_4519_ _1133_ VGND VGND VPWR VPWR _1308_ sky130_fd_sc_hd__buf_4
Xhold130 RF.reg_arr\[4\]\[31\] VGND VGND VPWR VPWR net212 sky130_fd_sc_hd__dlygate4sd3_1
XFILLER_0_13_273 VGND VGND VPWR VPWR sky130_fd_sc_hd__decap_6
X_7307_ _3601_ VGND VGND VPWR VPWR _0197_ sky130_fd_sc_hd__clkbuf_1
X_8287_ net406 _3426_ _4113_ VGND VGND VPWR VPWR _4122_ sky130_fd_sc_hd__mux2_1
XFILLER_0_41_593 VGND VGND VPWR VPWR sky130_fd_sc_hd__decap_4
Xhold174 RF.reg_arr\[2\]\[20\] VGND VGND VPWR VPWR net256 sky130_fd_sc_hd__dlygate4sd3_1
X_7238_ _3071_ net834 _3558_ VGND VGND VPWR VPWR _3565_ sky130_fd_sc_hd__mux2_1
Xhold185 RF.reg_arr\[2\]\[14\] VGND VGND VPWR VPWR net267 sky130_fd_sc_hd__dlygate4sd3_1
X_5499_ RF.reg_arr\[4\]\[3\] RF.reg_arr\[5\]\[3\] RF.reg_arr\[6\]\[3\] RF.reg_arr\[7\]\[3\]
+ _1846_ _1849_ VGND VGND VPWR VPWR _2288_ sky130_fd_sc_hd__mux4_1
Xhold163 RF.reg_arr\[8\]\[1\] VGND VGND VPWR VPWR net245 sky130_fd_sc_hd__dlygate4sd3_1
Xhold196 RF.reg_arr\[7\]\[3\] VGND VGND VPWR VPWR net278 sky130_fd_sc_hd__dlygate4sd3_1
X_7169_ net243 _3401_ _3521_ VGND VGND VPWR VPWR _3528_ sky130_fd_sc_hd__mux2_1
XFILLER_0_76_490 VGND VGND VPWR VPWR sky130_fd_sc_hd__decap_8
XFILLER_0_36_332 VPWR VGND VPWR VGND sky130_ef_sc_hd__decap_12
XFILLER_0_63_151 VGND VGND VPWR VPWR sky130_fd_sc_hd__fill_1
XFILLER_0_51_302 VGND VGND VPWR VPWR sky130_fd_sc_hd__decap_3
XFILLER_0_106_253 VGND VGND VPWR VPWR sky130_fd_sc_hd__decap_4
XFILLER_0_106_242 VGND VGND VPWR VPWR sky130_fd_sc_hd__fill_1
XFILLER_0_51_335 VGND VGND VPWR VPWR sky130_fd_sc_hd__fill_1
XFILLER_0_51_346 VGND VGND VPWR VPWR sky130_fd_sc_hd__decap_6
XTAP_TAPCELL_ROW_114_1624 VGND VPWR sky130_fd_sc_hd__tapvpwrvgnd_1
XFILLER_0_75_17 VGND VGND VPWR VPWR sky130_fd_sc_hd__decap_4
XFILLER_0_86_243 VGND VGND VPWR VPWR sky130_fd_sc_hd__fill_2
X_4870_ RF.reg_arr\[4\]\[30\] RF.reg_arr\[5\]\[30\] RF.reg_arr\[6\]\[30\] RF.reg_arr\[7\]\[30\]
+ _1593_ _1600_ VGND VGND VPWR VPWR _1659_ sky130_fd_sc_hd__mux4_1
XTAP_TAPCELL_ROW_15_430 VGND VPWR sky130_fd_sc_hd__tapvpwrvgnd_1
XFILLER_0_46_118 VGND VGND VPWR VPWR sky130_fd_sc_hd__decap_4
X_6540_ _3177_ VGND VGND VPWR VPWR _0878_ sky130_fd_sc_hd__clkbuf_1
XFILLER_0_27_332 VGND VGND VPWR VPWR sky130_fd_sc_hd__decap_4
XTAP_TAPCELL_ROW_43_772 VGND VPWR sky130_fd_sc_hd__tapvpwrvgnd_1
XFILLER_0_15_538 VGND VGND VPWR VPWR sky130_fd_sc_hd__decap_4
X_6471_ _3140_ VGND VGND VPWR VPWR _0846_ sky130_fd_sc_hd__clkbuf_1
X_9190_ clknet_leaf_82_CLK _0423_ VGND VGND VPWR VPWR RF.reg_arr\[24\]\[8\] sky130_fd_sc_hd__dfxtp_1
XFILLER_0_2_421 VGND VGND VPWR VPWR sky130_fd_sc_hd__decap_6
X_5422_ _1617_ _2210_ VGND VGND VPWR VPWR _2211_ sky130_fd_sc_hd__nor2_1
X_8210_ _4081_ VGND VGND VPWR VPWR _0620_ sky130_fd_sc_hd__clkbuf_1
XFILLER_0_40_97 VGND VGND VPWR VPWR sky130_fd_sc_hd__fill_2
X_5353_ RF.reg_arr\[20\]\[15\] RF.reg_arr\[21\]\[15\] RF.reg_arr\[22\]\[15\] RF.reg_arr\[23\]\[15\]
+ _1847_ _1850_ VGND VGND VPWR VPWR _2142_ sky130_fd_sc_hd__mux4_1
X_8141_ net861 _3416_ _4041_ VGND VGND VPWR VPWR _4045_ sky130_fd_sc_hd__mux2_1
XFILLER_0_100_429 VGND VGND VPWR VPWR sky130_fd_sc_hd__fill_2
X_4304_ _1026_ VGND VGND VPWR VPWR _1093_ sky130_fd_sc_hd__buf_12
X_8072_ _4008_ VGND VGND VPWR VPWR _0555_ sky130_fd_sc_hd__clkbuf_1
X_5284_ RF.reg_arr\[24\]\[11\] RF.reg_arr\[25\]\[11\] RF.reg_arr\[26\]\[11\] RF.reg_arr\[27\]\[11\]
+ _1625_ _1598_ VGND VGND VPWR VPWR _2073_ sky130_fd_sc_hd__mux4_1
X_4235_ net48 VGND VGND VPWR VPWR _1024_ sky130_fd_sc_hd__buf_2
X_7023_ net482 _3391_ _3449_ VGND VGND VPWR VPWR _3451_ sky130_fd_sc_hd__mux2_1
XFILLER_0_4_64 VGND VGND VPWR VPWR sky130_fd_sc_hd__fill_1
X_8974_ clknet_leaf_6_CLK _0207_ VGND VGND VPWR VPWR RF.reg_arr\[31\]\[16\] sky130_fd_sc_hd__dfxtp_1
X_7925_ _3930_ VGND VGND VPWR VPWR _0486_ sky130_fd_sc_hd__clkbuf_1
X_7856_ _3073_ net961 _3886_ VGND VGND VPWR VPWR _3894_ sky130_fd_sc_hd__mux2_1
XFILLER_0_77_276 VGND VGND VPWR VPWR sky130_fd_sc_hd__fill_1
X_6807_ _3320_ VGND VGND VPWR VPWR _1002_ sky130_fd_sc_hd__clkbuf_1
X_4999_ _1637_ _1787_ _1644_ VGND VGND VPWR VPWR _1788_ sky130_fd_sc_hd__o21ai_1
X_7787_ _3073_ net1045 _3849_ VGND VGND VPWR VPWR _3857_ sky130_fd_sc_hd__mux2_1
X_6738_ _3283_ VGND VGND VPWR VPWR _0970_ sky130_fd_sc_hd__clkbuf_1
X_6669_ _3084_ net1064 _3243_ VGND VGND VPWR VPWR _3246_ sky130_fd_sc_hd__mux2_1
X_9457_ clknet_leaf_8_CLK _0690_ VGND VGND VPWR VPWR RF.reg_arr\[12\]\[19\] sky130_fd_sc_hd__dfxtp_1
XFILLER_0_5_281 VGND VGND VPWR VPWR sky130_fd_sc_hd__decap_4
XTAP_TAPCELL_ROW_21_499 VGND VPWR sky130_fd_sc_hd__tapvpwrvgnd_1
X_9388_ clknet_leaf_94_CLK _0621_ VGND VGND VPWR VPWR RF.reg_arr\[13\]\[14\] sky130_fd_sc_hd__dfxtp_1
X_8408_ _4186_ VGND VGND VPWR VPWR _0713_ sky130_fd_sc_hd__clkbuf_1
X_8339_ _3018_ net1042 _4149_ VGND VGND VPWR VPWR _4150_ sky130_fd_sc_hd__mux2_1
XFILLER_0_96_530 VGND VGND VPWR VPWR sky130_fd_sc_hd__fill_2
XTAP_TAPCELL_ROW_64_1022 VGND VPWR sky130_fd_sc_hd__tapvpwrvgnd_1
XTAP_TAPCELL_ROW_29_599 VGND VPWR sky130_fd_sc_hd__tapvpwrvgnd_1
XTAP_TAPCELL_ROW_12_400 VGND VPWR sky130_fd_sc_hd__tapvpwrvgnd_1
XTAP_TAPCELL_ROW_40_731 VGND VPWR sky130_fd_sc_hd__tapvpwrvgnd_1
XFILLER_0_36_195 VGND VGND VPWR VPWR sky130_fd_sc_hd__fill_1
XFILLER_0_10_23 VGND VGND VPWR VPWR sky130_fd_sc_hd__fill_2
XTAP_TAPCELL_ROW_75_1151 VGND VPWR sky130_fd_sc_hd__tapvpwrvgnd_1
XFILLER_0_20_541 VGND VGND VPWR VPWR sky130_fd_sc_hd__decap_3
XTAP_TAPCELL_ROW_48_831 VGND VPWR sky130_fd_sc_hd__tapvpwrvgnd_1
X_5971_ _1980_ _2726_ VGND VGND VPWR VPWR _2743_ sky130_fd_sc_hd__nor2_1
X_4922_ _1619_ _1710_ VGND VGND VPWR VPWR _1711_ sky130_fd_sc_hd__nor2_1
XFILLER_0_87_574 VPWR VGND VPWR VGND sky130_ef_sc_hd__decap_12
XTAP_TAPCELL_ROW_86_1280 VGND VPWR sky130_fd_sc_hd__tapvpwrvgnd_1
X_8690_ clknet_leaf_16_CLK _0947_ VGND VGND VPWR VPWR RF.reg_arr\[15\]\[20\] sky130_fd_sc_hd__dfxtp_1
X_7710_ _3816_ VGND VGND VPWR VPWR _0385_ sky130_fd_sc_hd__clkbuf_1
X_7641_ _3063_ net670 _3777_ VGND VGND VPWR VPWR _3780_ sky130_fd_sc_hd__mux2_1
X_4853_ _1641_ VGND VGND VPWR VPWR _1642_ sky130_fd_sc_hd__buf_6
X_4784_ RF.reg_arr\[8\]\[24\] RF.reg_arr\[9\]\[24\] RF.reg_arr\[10\]\[24\] RF.reg_arr\[11\]\[24\]
+ _1302_ _1322_ VGND VGND VPWR VPWR _1573_ sky130_fd_sc_hd__mux4_1
X_7572_ _3743_ VGND VGND VPWR VPWR _0320_ sky130_fd_sc_hd__clkbuf_1
XFILLER_0_28_663 VGND VGND VPWR VPWR sky130_fd_sc_hd__decap_3
X_9311_ clknet_leaf_56_CLK _0544_ VGND VGND VPWR VPWR RF.reg_arr\[20\]\[1\] sky130_fd_sc_hd__dfxtp_1
X_6523_ _3168_ VGND VGND VPWR VPWR _0870_ sky130_fd_sc_hd__clkbuf_1
XFILLER_0_42_121 VGND VGND VPWR VPWR sky130_fd_sc_hd__fill_1
X_9242_ clknet_leaf_30_CLK _0475_ VGND VGND VPWR VPWR RF.reg_arr\[22\]\[28\] sky130_fd_sc_hd__dfxtp_1
X_6454_ net120 VGND VGND VPWR VPWR _3132_ sky130_fd_sc_hd__clkbuf_1
Xclkload50 clknet_leaf_39_CLK VGND VGND VPWR VPWR clkload50/Y sky130_fd_sc_hd__bufinv_16
X_5405_ _1114_ _2193_ VGND VGND VPWR VPWR _2194_ sky130_fd_sc_hd__or2_1
Xclkload61 clknet_leaf_91_CLK VGND VGND VPWR VPWR clkload61/Y sky130_fd_sc_hd__inv_6
X_9173_ clknet_leaf_40_CLK _0406_ VGND VGND VPWR VPWR RF.reg_arr\[9\]\[23\] sky130_fd_sc_hd__dfxtp_1
Xclkload83 clknet_leaf_45_CLK VGND VGND VPWR VPWR clkload83/Y sky130_fd_sc_hd__clkinvlp_4
X_6385_ net19 VGND VGND VPWR VPWR _3088_ sky130_fd_sc_hd__clkbuf_2
Xclkload72 clknet_leaf_74_CLK VGND VGND VPWR VPWR clkload72/Y sky130_fd_sc_hd__inv_6
Xclkload94 clknet_leaf_64_CLK VGND VGND VPWR VPWR clkload94/Y sky130_fd_sc_hd__clkinvlp_4
X_5336_ RF.reg_arr\[20\]\[14\] RF.reg_arr\[21\]\[14\] RF.reg_arr\[22\]\[14\] RF.reg_arr\[23\]\[14\]
+ _2087_ _1859_ VGND VGND VPWR VPWR _2125_ sky130_fd_sc_hd__mux4_1
X_8124_ net655 _3399_ _4030_ VGND VGND VPWR VPWR _4036_ sky130_fd_sc_hd__mux2_1
X_8055_ _3999_ VGND VGND VPWR VPWR _0547_ sky130_fd_sc_hd__clkbuf_1
X_5267_ RF.reg_arr\[24\]\[10\] RF.reg_arr\[25\]\[10\] RF.reg_arr\[26\]\[10\] RF.reg_arr\[27\]\[10\]
+ _1947_ _1948_ VGND VGND VPWR VPWR _2056_ sky130_fd_sc_hd__mux4_1
X_7006_ net564 _3375_ _3431_ VGND VGND VPWR VPWR _3441_ sky130_fd_sc_hd__mux2_1
XFILLER_0_76_71 VGND VGND VPWR VPWR sky130_fd_sc_hd__fill_1
X_5198_ _1985_ _1986_ _1611_ VGND VGND VPWR VPWR _1987_ sky130_fd_sc_hd__mux2_1
X_8957_ clknet_leaf_20_CLK _0190_ VGND VGND VPWR VPWR RF.reg_arr\[29\]\[31\] sky130_fd_sc_hd__dfxtp_1
X_7908_ _2996_ _3884_ VGND VGND VPWR VPWR _3921_ sky130_fd_sc_hd__nand2_4
X_8888_ clknet_leaf_50_CLK _0121_ VGND VGND VPWR VPWR RF.reg_arr\[3\]\[26\] sky130_fd_sc_hd__dfxtp_1
XFILLER_0_78_585 VGND VGND VPWR VPWR sky130_fd_sc_hd__decap_3
XTAP_TAPCELL_ROW_26_558 VGND VPWR sky130_fd_sc_hd__tapvpwrvgnd_1
XTAP_TAPCELL_ROW_26_569 VGND VPWR sky130_fd_sc_hd__tapvpwrvgnd_1
X_7839_ _2975_ _2973_ _2974_ _2972_ VGND VGND VPWR VPWR _3884_ sky130_fd_sc_hd__and4b_2
XFILLER_0_53_408 VGND VGND VPWR VPWR sky130_fd_sc_hd__decap_8
XFILLER_0_18_195 VGND VGND VPWR VPWR sky130_fd_sc_hd__fill_1
X_9509_ clknet_leaf_97_CLK _0742_ VGND VGND VPWR VPWR RF.reg_arr\[10\]\[7\] sky130_fd_sc_hd__dfxtp_1
Xclkload0 clknet_3_0__leaf_CLK VGND VGND VPWR VPWR clkload0/X sky130_fd_sc_hd__clkbuf_8
XFILLER_0_104_543 VGND VGND VPWR VPWR sky130_fd_sc_hd__fill_2
XFILLER_0_104_587 VGND VGND VPWR VPWR sky130_fd_sc_hd__fill_1
XTAP_TAPCELL_ROW_70_1092 VGND VPWR sky130_fd_sc_hd__tapvpwrvgnd_1
XTAP_TAPCELL_ROW_109_1556 VGND VPWR sky130_fd_sc_hd__tapvpwrvgnd_1
XFILLER_0_69_574 VGND VGND VPWR VPWR sky130_fd_sc_hd__fill_2
XFILLER_0_84_533 VGND VGND VPWR VPWR sky130_fd_sc_hd__decap_4
XFILLER_0_29_449 VGND VGND VPWR VPWR sky130_fd_sc_hd__decap_4
XFILLER_0_114_307 VGND VGND VPWR VPWR sky130_fd_sc_hd__fill_1
XFILLER_0_21_88 VGND VGND VPWR VPWR sky130_fd_sc_hd__fill_1
XFILLER_0_25_655 VGND VGND VPWR VPWR sky130_fd_sc_hd__decap_3
Xhold707 RF.reg_arr\[29\]\[21\] VGND VGND VPWR VPWR net789 sky130_fd_sc_hd__dlygate4sd3_1
Xhold718 RF.reg_arr\[27\]\[6\] VGND VGND VPWR VPWR net800 sky130_fd_sc_hd__dlygate4sd3_1
XFILLER_0_52_485 VGND VGND VPWR VPWR sky130_fd_sc_hd__decap_4
Xhold729 RF.reg_arr\[27\]\[22\] VGND VGND VPWR VPWR net811 sky130_fd_sc_hd__dlygate4sd3_1
X_6170_ _2200_ _2845_ _2930_ _2420_ VGND VGND VPWR VPWR _2931_ sky130_fd_sc_hd__a22o_1
XFILLER_0_110_579 VGND VGND VPWR VPWR sky130_fd_sc_hd__fill_2
X_5121_ _1636_ _1909_ _1643_ VGND VGND VPWR VPWR _1910_ sky130_fd_sc_hd__o21ai_1
X_5052_ _1839_ _1840_ _1611_ VGND VGND VPWR VPWR _1841_ sky130_fd_sc_hd__mux2_1
XFILLER_0_46_85 VGND VGND VPWR VPWR sky130_fd_sc_hd__fill_2
X_8811_ clknet_leaf_90_CLK _0044_ VGND VGND VPWR VPWR RF.reg_arr\[4\]\[13\] sky130_fd_sc_hd__dfxtp_1
X_8742_ clknet_leaf_87_CLK _0999_ VGND VGND VPWR VPWR RF.reg_arr\[6\]\[8\] sky130_fd_sc_hd__dfxtp_1
X_5954_ _1980_ _2726_ VGND VGND VPWR VPWR _2727_ sky130_fd_sc_hd__xnor2_1
X_5885_ _1092_ _2027_ VGND VGND VPWR VPWR _2662_ sky130_fd_sc_hd__or2_1
X_4905_ _1692_ _1693_ _1614_ VGND VGND VPWR VPWR _1694_ sky130_fd_sc_hd__mux2_1
XFILLER_0_75_533 VGND VGND VPWR VPWR sky130_fd_sc_hd__decap_8
XTAP_TAPCELL_ROW_23_528 VGND VPWR sky130_fd_sc_hd__tapvpwrvgnd_1
X_8673_ clknet_leaf_65_CLK _0930_ VGND VGND VPWR VPWR RF.reg_arr\[15\]\[3\] sky130_fd_sc_hd__dfxtp_1
X_7624_ _3770_ VGND VGND VPWR VPWR _0345_ sky130_fd_sc_hd__clkbuf_1
X_4836_ _1624_ VGND VGND VPWR VPWR _1625_ sky130_fd_sc_hd__buf_4
XFILLER_0_47_279 VGND VGND VPWR VPWR sky130_fd_sc_hd__fill_1
XTAP_TAPCELL_ROW_51_859 VGND VPWR sky130_fd_sc_hd__tapvpwrvgnd_1
X_7555_ net349 _3375_ _3727_ VGND VGND VPWR VPWR _3734_ sky130_fd_sc_hd__mux2_1
XFILLER_0_7_343 VGND VGND VPWR VPWR sky130_fd_sc_hd__fill_1
XFILLER_0_15_110 VGND VGND VPWR VPWR sky130_fd_sc_hd__fill_2
X_4767_ RF.reg_arr\[8\]\[25\] RF.reg_arr\[9\]\[25\] RF.reg_arr\[10\]\[25\] RF.reg_arr\[11\]\[25\]
+ _1327_ _1328_ VGND VGND VPWR VPWR _1556_ sky130_fd_sc_hd__mux4_1
X_6506_ _3157_ _3158_ VGND VGND VPWR VPWR _3159_ sky130_fd_sc_hd__nor2_4
X_7486_ _3696_ VGND VGND VPWR VPWR _0281_ sky130_fd_sc_hd__clkbuf_1
X_4698_ RF.reg_arr\[28\]\[12\] RF.reg_arr\[29\]\[12\] RF.reg_arr\[30\]\[12\] RF.reg_arr\[31\]\[12\]
+ _1051_ _1053_ VGND VGND VPWR VPWR _1487_ sky130_fd_sc_hd__mux4_1
X_6437_ net38 VGND VGND VPWR VPWR _3123_ sky130_fd_sc_hd__buf_2
X_9225_ clknet_leaf_12_CLK _0458_ VGND VGND VPWR VPWR RF.reg_arr\[22\]\[11\] sky130_fd_sc_hd__dfxtp_1
X_6368_ _3076_ VGND VGND VPWR VPWR _0807_ sky130_fd_sc_hd__clkbuf_1
X_9156_ clknet_leaf_85_CLK _0389_ VGND VGND VPWR VPWR RF.reg_arr\[9\]\[6\] sky130_fd_sc_hd__dfxtp_1
X_8107_ _4026_ VGND VGND VPWR VPWR _0572_ sky130_fd_sc_hd__clkbuf_1
XFILLER_0_11_393 VGND VGND VPWR VPWR sky130_fd_sc_hd__decap_6
X_5319_ RF.reg_arr\[28\]\[9\] RF.reg_arr\[29\]\[9\] RF.reg_arr\[30\]\[9\] RF.reg_arr\[31\]\[9\]
+ _1623_ _1596_ VGND VGND VPWR VPWR _2108_ sky130_fd_sc_hd__mux4_1
X_9087_ clknet_leaf_58_CLK _0320_ VGND VGND VPWR VPWR RF.reg_arr\[2\]\[1\] sky130_fd_sc_hd__dfxtp_1
Xhold23 RF.reg_arr\[0\]\[3\] VGND VGND VPWR VPWR net105 sky130_fd_sc_hd__dlygate4sd3_1
X_6299_ net142 _3031_ _3019_ VGND VGND VPWR VPWR _3032_ sky130_fd_sc_hd__mux2_1
X_8038_ _2988_ net572 _3980_ VGND VGND VPWR VPWR _3990_ sky130_fd_sc_hd__mux2_1
Xhold34 RF.reg_arr\[0\]\[25\] VGND VGND VPWR VPWR net116 sky130_fd_sc_hd__dlygate4sd3_1
Xhold56 RF.reg_arr\[5\]\[1\] VGND VGND VPWR VPWR net138 sky130_fd_sc_hd__dlygate4sd3_1
Xhold45 RF.reg_arr\[0\]\[10\] VGND VGND VPWR VPWR net127 sky130_fd_sc_hd__dlygate4sd3_1
Xhold89 RF.reg_arr\[3\]\[24\] VGND VGND VPWR VPWR net171 sky130_fd_sc_hd__dlygate4sd3_1
Xhold67 RF.reg_arr\[11\]\[30\] VGND VGND VPWR VPWR net149 sky130_fd_sc_hd__dlygate4sd3_1
XTAP_TAPCELL_ROW_59_959 VGND VPWR sky130_fd_sc_hd__tapvpwrvgnd_1
Xhold78 RF.reg_arr\[6\]\[3\] VGND VGND VPWR VPWR net160 sky130_fd_sc_hd__dlygate4sd3_1
XTAP_TAPCELL_ROW_3_286 VGND VPWR sky130_fd_sc_hd__tapvpwrvgnd_1
XFILLER_0_66_500 VGND VGND VPWR VPWR sky130_fd_sc_hd__decap_8
XFILLER_0_109_602 VGND VGND VPWR VPWR sky130_fd_sc_hd__decap_8
XTAP_TAPCELL_ROW_104_1497 VGND VPWR sky130_fd_sc_hd__tapvpwrvgnd_1
XFILLER_0_109_668 VGND VGND VPWR VPWR sky130_fd_sc_hd__fill_1
XFILLER_0_34_485 VGND VGND VPWR VPWR sky130_fd_sc_hd__decap_4
XANTENNA_9 _1603_ VGND VGND VPWR VPWR sky130_fd_sc_hd__diode_2
XFILLER_0_21_113 VGND VGND VPWR VPWR sky130_fd_sc_hd__decap_4
XTAP_TAPCELL_ROW_72_1110 VGND VPWR sky130_fd_sc_hd__tapvpwrvgnd_1
Xclkbuf_leaf_106_CLK clknet_3_0__leaf_CLK VGND VGND VPWR VPWR clknet_leaf_106_CLK
+ sky130_fd_sc_hd__clkbuf_8
XTAP_TAPCELL_ROW_72_1121 VGND VPWR sky130_fd_sc_hd__tapvpwrvgnd_1
XFILLER_0_89_614 VGND VGND VPWR VPWR sky130_fd_sc_hd__fill_2
XTAP_TAPCELL_ROW_83_1250 VGND VPWR sky130_fd_sc_hd__tapvpwrvgnd_1
X_5670_ _2292_ _2455_ VGND VGND VPWR VPWR _2456_ sky130_fd_sc_hd__xnor2_1
XFILLER_0_44_205 VGND VGND VPWR VPWR sky130_fd_sc_hd__decap_8
X_4621_ _1062_ _1409_ VGND VGND VPWR VPWR _1410_ sky130_fd_sc_hd__nand2_1
XFILLER_0_44_238 VGND VGND VPWR VPWR sky130_fd_sc_hd__decap_4
X_4552_ _1339_ _1340_ _1042_ VGND VGND VPWR VPWR _1341_ sky130_fd_sc_hd__mux2_1
X_7340_ _3105_ net778 _3616_ VGND VGND VPWR VPWR _3619_ sky130_fd_sc_hd__mux2_1
XFILLER_0_13_614 VGND VGND VPWR VPWR sky130_fd_sc_hd__fill_2
Xhold504 RF.reg_arr\[4\]\[27\] VGND VGND VPWR VPWR net586 sky130_fd_sc_hd__dlygate4sd3_1
X_7271_ _3582_ VGND VGND VPWR VPWR _0180_ sky130_fd_sc_hd__clkbuf_1
Xhold526 RF.reg_arr\[13\]\[22\] VGND VGND VPWR VPWR net608 sky130_fd_sc_hd__dlygate4sd3_1
X_4483_ _1159_ VGND VGND VPWR VPWR _1272_ sky130_fd_sc_hd__buf_4
Xhold515 RF.reg_arr\[11\]\[4\] VGND VGND VPWR VPWR net597 sky130_fd_sc_hd__dlygate4sd3_1
Xhold559 RF.reg_arr\[24\]\[26\] VGND VGND VPWR VPWR net641 sky130_fd_sc_hd__dlygate4sd3_1
X_6222_ net181 _2970_ _2978_ VGND VGND VPWR VPWR _2979_ sky130_fd_sc_hd__mux2_1
Xhold537 RF.reg_arr\[30\]\[27\] VGND VGND VPWR VPWR net619 sky130_fd_sc_hd__dlygate4sd3_1
X_9010_ clknet_leaf_17_CLK _0243_ VGND VGND VPWR VPWR RF.reg_arr\[27\]\[20\] sky130_fd_sc_hd__dfxtp_1
Xhold548 RF.reg_arr\[14\]\[7\] VGND VGND VPWR VPWR net630 sky130_fd_sc_hd__dlygate4sd3_1
X_6153_ _2759_ _2913_ VGND VGND VPWR VPWR _2914_ sky130_fd_sc_hd__nor2_1
X_5104_ _1792_ _1892_ VGND VGND VPWR VPWR _1893_ sky130_fd_sc_hd__nand2_1
X_6084_ _2597_ _2714_ VGND VGND VPWR VPWR _2849_ sky130_fd_sc_hd__or2_1
X_5035_ _1077_ _1823_ VGND VGND VPWR VPWR _1824_ sky130_fd_sc_hd__nand2_1
XFILLER_0_79_113 VGND VGND VPWR VPWR sky130_fd_sc_hd__decap_4
XTAP_TAPCELL_ROW_56_918 VGND VPWR sky130_fd_sc_hd__tapvpwrvgnd_1
XTAP_TAPCELL_ROW_56_929 VGND VPWR sky130_fd_sc_hd__tapvpwrvgnd_1
XTAP_TAPCELL_ROW_0_234 VGND VPWR sky130_fd_sc_hd__tapvpwrvgnd_1
XTAP_TAPCELL_ROW_0_245 VGND VPWR sky130_fd_sc_hd__tapvpwrvgnd_1
XTAP_TAPCELL_ROW_0_256 VGND VPWR sky130_fd_sc_hd__tapvpwrvgnd_1
X_6986_ net24 VGND VGND VPWR VPWR _3428_ sky130_fd_sc_hd__buf_2
X_5937_ _2564_ _2587_ _2662_ _2463_ _1024_ VGND VGND VPWR VPWR _2711_ sky130_fd_sc_hd__o221a_1
X_8725_ clknet_leaf_40_CLK _0982_ VGND VGND VPWR VPWR RF.reg_arr\[14\]\[23\] sky130_fd_sc_hd__dfxtp_1
XFILLER_0_75_330 VGND VGND VPWR VPWR sky130_fd_sc_hd__fill_2
XTAP_TAPCELL_ROW_36_686 VGND VPWR sky130_fd_sc_hd__tapvpwrvgnd_1
XFILLER_0_75_363 VGND VGND VPWR VPWR sky130_fd_sc_hd__fill_1
XFILLER_0_63_514 VGND VGND VPWR VPWR sky130_fd_sc_hd__fill_1
X_8656_ clknet_leaf_2_CLK _0913_ VGND VGND VPWR VPWR RF.reg_arr\[8\]\[18\] sky130_fd_sc_hd__dfxtp_1
X_5868_ _2447_ net81 _1499_ VGND VGND VPWR VPWR _2645_ sky130_fd_sc_hd__o21ai_1
XFILLER_0_63_536 VGND VGND VPWR VPWR sky130_fd_sc_hd__fill_2
X_7607_ _3761_ VGND VGND VPWR VPWR _0337_ sky130_fd_sc_hd__clkbuf_1
XTAP_TAPCELL_ROW_97_1419 VGND VPWR sky130_fd_sc_hd__tapvpwrvgnd_1
X_5799_ _2574_ _2579_ VGND VGND VPWR VPWR _2580_ sky130_fd_sc_hd__and2_1
X_4819_ RF.reg_arr\[16\]\[31\] RF.reg_arr\[17\]\[31\] RF.reg_arr\[18\]\[31\] RF.reg_arr\[19\]\[31\]
+ _1593_ _1600_ VGND VGND VPWR VPWR _1608_ sky130_fd_sc_hd__mux4_1
X_8587_ clknet_leaf_64_CLK _0844_ VGND VGND VPWR VPWR RF.reg_arr\[0\]\[13\] sky130_fd_sc_hd__dfxtp_1
XFILLER_0_16_474 VGND VGND VPWR VPWR sky130_fd_sc_hd__fill_2
X_7538_ net435 _3426_ _3716_ VGND VGND VPWR VPWR _3725_ sky130_fd_sc_hd__mux2_1
X_7469_ _3687_ VGND VGND VPWR VPWR _0273_ sky130_fd_sc_hd__clkbuf_1
XFILLER_0_31_422 VGND VGND VPWR VPWR sky130_fd_sc_hd__fill_1
X_9208_ clknet_leaf_35_CLK _0441_ VGND VGND VPWR VPWR RF.reg_arr\[24\]\[26\] sky130_fd_sc_hd__dfxtp_1
XFILLER_0_113_181 VGND VGND VPWR VPWR sky130_fd_sc_hd__decap_6
Xoutput57 net57 VGND VGND VPWR VPWR result[17] sky130_fd_sc_hd__clkbuf_4
XFILLER_0_12_691 VGND VGND VPWR VPWR sky130_fd_sc_hd__fill_1
XTAP_TAPCELL_ROW_8_345 VGND VPWR sky130_fd_sc_hd__tapvpwrvgnd_1
Xoutput68 net68 VGND VGND VPWR VPWR result[27] sky130_fd_sc_hd__clkbuf_4
Xoutput79 net79 VGND VGND VPWR VPWR result[8] sky130_fd_sc_hd__clkbuf_4
X_9139_ clknet_leaf_46_CLK _0372_ VGND VGND VPWR VPWR RF.reg_arr\[30\]\[21\] sky130_fd_sc_hd__dfxtp_1
XTAP_TAPCELL_ROW_106_1526 VGND VPWR sky130_fd_sc_hd__tapvpwrvgnd_1
XFILLER_0_86_606 VGND VGND VPWR VPWR sky130_fd_sc_hd__decap_3
XFILLER_0_98_499 VGND VGND VPWR VPWR sky130_fd_sc_hd__decap_3
XPHY_EDGE_ROW_19_Right_19 VGND VGND VPWR VPWR sky130_fd_sc_hd__decap_3
XFILLER_0_39_511 VGND VGND VPWR VPWR sky130_fd_sc_hd__fill_1
XFILLER_0_26_205 VGND VGND VPWR VPWR sky130_fd_sc_hd__fill_2
XFILLER_0_54_525 VGND VGND VPWR VPWR sky130_fd_sc_hd__decap_6
XFILLER_0_26_249 VGND VGND VPWR VPWR sky130_fd_sc_hd__decap_3
XFILLER_0_105_682 VGND VGND VPWR VPWR sky130_fd_sc_hd__decap_8
XPHY_EDGE_ROW_28_Right_28 VGND VGND VPWR VPWR sky130_fd_sc_hd__decap_3
XFILLER_0_94_27 VGND VGND VPWR VPWR sky130_fd_sc_hd__fill_1
XFILLER_0_27_65 VGND VGND VPWR VPWR sky130_fd_sc_hd__fill_2
XPHY_EDGE_ROW_37_Right_37 VGND VGND VPWR VPWR sky130_fd_sc_hd__decap_3
X_6840_ _3337_ VGND VGND VPWR VPWR _1018_ sky130_fd_sc_hd__clkbuf_1
XFILLER_0_89_477 VGND VGND VPWR VPWR sky130_fd_sc_hd__decap_4
X_6771_ _3300_ VGND VGND VPWR VPWR _0986_ sky130_fd_sc_hd__clkbuf_1
XFILLER_0_9_416 VGND VGND VPWR VPWR sky130_fd_sc_hd__decap_4
X_5722_ _2359_ _2369_ _1831_ VGND VGND VPWR VPWR _2506_ sky130_fd_sc_hd__mux2_1
XFILLER_0_85_650 VGND VGND VPWR VPWR sky130_fd_sc_hd__decap_6
XTAP_TAPCELL_ROW_33_645 VGND VPWR sky130_fd_sc_hd__tapvpwrvgnd_1
X_8510_ clknet_leaf_66_CLK _0767_ VGND VGND VPWR VPWR RF.reg_arr\[1\]\[0\] sky130_fd_sc_hd__dfxtp_1
XFILLER_0_45_503 VGND VGND VPWR VPWR sky130_fd_sc_hd__fill_1
XFILLER_0_91_119 VGND VGND VPWR VPWR sky130_fd_sc_hd__fill_2
X_9490_ clknet_leaf_15_CLK _0723_ VGND VGND VPWR VPWR RF.reg_arr\[11\]\[20\] sky130_fd_sc_hd__dfxtp_1
XTAP_TAPCELL_ROW_61_987 VGND VPWR sky130_fd_sc_hd__tapvpwrvgnd_1
XFILLER_0_45_514 VGND VGND VPWR VPWR sky130_fd_sc_hd__fill_1
XFILLER_0_115_424 VGND VGND VPWR VPWR sky130_fd_sc_hd__fill_2
X_8441_ _4203_ VGND VGND VPWR VPWR _0729_ sky130_fd_sc_hd__clkbuf_1
X_5653_ _2436_ _2439_ _2021_ VGND VGND VPWR VPWR _2440_ sky130_fd_sc_hd__mux2_1
XFILLER_0_17_238 VGND VGND VPWR VPWR sky130_fd_sc_hd__fill_2
X_8372_ _2982_ net987 _4160_ VGND VGND VPWR VPWR _4167_ sky130_fd_sc_hd__mux2_1
X_5584_ _2370_ _2371_ VGND VGND VPWR VPWR _2372_ sky130_fd_sc_hd__nand2_1
XFILLER_0_4_110 VGND VGND VPWR VPWR sky130_fd_sc_hd__decap_4
X_4604_ RF.reg_arr\[8\]\[6\] RF.reg_arr\[9\]\[6\] RF.reg_arr\[10\]\[6\] RF.reg_arr\[11\]\[6\]
+ _1051_ _1053_ VGND VGND VPWR VPWR _1393_ sky130_fd_sc_hd__mux4_1
XPHY_EDGE_ROW_46_Right_46 VGND VGND VPWR VPWR sky130_fd_sc_hd__decap_3
X_4535_ RF.reg_arr\[12\]\[23\] RF.reg_arr\[13\]\[23\] RF.reg_arr\[14\]\[23\] RF.reg_arr\[15\]\[23\]
+ _1302_ _1322_ VGND VGND VPWR VPWR _1324_ sky130_fd_sc_hd__mux4_1
Xhold301 RF.reg_arr\[5\]\[11\] VGND VGND VPWR VPWR net383 sky130_fd_sc_hd__dlygate4sd3_1
X_7323_ _3088_ net664 _3605_ VGND VGND VPWR VPWR _3610_ sky130_fd_sc_hd__mux2_1
Xhold323 RF.reg_arr\[29\]\[26\] VGND VGND VPWR VPWR net405 sky130_fd_sc_hd__dlygate4sd3_1
Xhold334 RF.reg_arr\[8\]\[24\] VGND VGND VPWR VPWR net416 sky130_fd_sc_hd__dlygate4sd3_1
Xhold312 RF.reg_arr\[23\]\[1\] VGND VGND VPWR VPWR net394 sky130_fd_sc_hd__dlygate4sd3_1
Xhold367 RF.reg_arr\[11\]\[26\] VGND VGND VPWR VPWR net449 sky130_fd_sc_hd__dlygate4sd3_1
Xhold378 RF.reg_arr\[8\]\[23\] VGND VGND VPWR VPWR net460 sky130_fd_sc_hd__dlygate4sd3_1
X_7254_ _3573_ VGND VGND VPWR VPWR _0172_ sky130_fd_sc_hd__clkbuf_1
Xhold345 RF.reg_arr\[21\]\[10\] VGND VGND VPWR VPWR net427 sky130_fd_sc_hd__dlygate4sd3_1
Xhold356 RF.reg_arr\[17\]\[10\] VGND VGND VPWR VPWR net438 sky130_fd_sc_hd__dlygate4sd3_1
X_4466_ _1025_ _1246_ _1250_ _1254_ VGND VGND VPWR VPWR _1255_ sky130_fd_sc_hd__o22a_4
XFILLER_0_111_685 VGND VGND VPWR VPWR sky130_fd_sc_hd__decap_6
X_6205_ _2961_ _2962_ VGND VGND VPWR VPWR _2963_ sky130_fd_sc_hd__xnor2_1
Xhold389 RF.reg_arr\[13\]\[29\] VGND VGND VPWR VPWR net471 sky130_fd_sc_hd__dlygate4sd3_1
X_4397_ _1050_ VGND VGND VPWR VPWR _1186_ sky130_fd_sc_hd__buf_12
X_7185_ _3536_ VGND VGND VPWR VPWR _0140_ sky130_fd_sc_hd__clkbuf_1
X_6136_ net86 _1581_ _2859_ _2759_ VGND VGND VPWR VPWR _2898_ sky130_fd_sc_hd__a31o_1
XTAP_TAPCELL_ROW_5_315 VGND VPWR sky130_fd_sc_hd__tapvpwrvgnd_1
Xhold1001 RF.reg_arr\[23\]\[23\] VGND VGND VPWR VPWR net1083 sky130_fd_sc_hd__dlygate4sd3_1
Xhold1023 RF.reg_arr\[21\]\[7\] VGND VGND VPWR VPWR net1105 sky130_fd_sc_hd__dlygate4sd3_1
Xhold1012 RF.reg_arr\[26\]\[19\] VGND VGND VPWR VPWR net1094 sky130_fd_sc_hd__dlygate4sd3_1
X_6067_ _2831_ net1127 VGND VGND VPWR VPWR _2833_ sky130_fd_sc_hd__nor2_1
Xhold1034 RF.reg_arr\[23\]\[17\] VGND VGND VPWR VPWR net1116 sky130_fd_sc_hd__dlygate4sd3_1
XPHY_EDGE_ROW_55_Right_55 VGND VGND VPWR VPWR sky130_fd_sc_hd__decap_3
X_5018_ _1801_ _1803_ _1806_ _1636_ _1644_ VGND VGND VPWR VPWR _1807_ sky130_fd_sc_hd__o221a_1
XFILLER_0_95_458 VGND VGND VPWR VPWR sky130_fd_sc_hd__decap_6
X_6969_ net541 _3416_ _3410_ VGND VGND VPWR VPWR _3417_ sky130_fd_sc_hd__mux2_1
X_8708_ clknet_leaf_84_CLK _0965_ VGND VGND VPWR VPWR RF.reg_arr\[14\]\[6\] sky130_fd_sc_hd__dfxtp_1
XFILLER_0_106_413 VGND VGND VPWR VPWR sky130_fd_sc_hd__fill_2
XTAP_TAPCELL_ROW_101_1467 VGND VPWR sky130_fd_sc_hd__tapvpwrvgnd_1
XFILLER_0_90_141 VGND VGND VPWR VPWR sky130_fd_sc_hd__fill_2
XPHY_EDGE_ROW_64_Right_64 VGND VGND VPWR VPWR sky130_fd_sc_hd__decap_3
XFILLER_0_8_460 VPWR VGND VPWR VGND sky130_ef_sc_hd__decap_12
X_8639_ clknet_leaf_68_CLK _0896_ VGND VGND VPWR VPWR RF.reg_arr\[8\]\[1\] sky130_fd_sc_hd__dfxtp_1
Xhold890 RF.reg_arr\[19\]\[19\] VGND VGND VPWR VPWR net972 sky130_fd_sc_hd__dlygate4sd3_1
XTAP_TAPCELL_ROW_112_1596 VGND VPWR sky130_fd_sc_hd__tapvpwrvgnd_1
XPHY_EDGE_ROW_73_Right_73 VGND VGND VPWR VPWR sky130_fd_sc_hd__decap_3
XFILLER_0_59_606 VGND VGND VPWR VPWR sky130_fd_sc_hd__decap_6
XFILLER_0_80_29 VGND VGND VPWR VPWR sky130_fd_sc_hd__fill_2
XTAP_TAPCELL_ROW_67_1053 VGND VPWR sky130_fd_sc_hd__tapvpwrvgnd_1
XFILLER_0_58_127 VGND VGND VPWR VPWR sky130_fd_sc_hd__fill_2
XFILLER_0_73_108 VGND VGND VPWR VPWR sky130_fd_sc_hd__fill_1
XPHY_EDGE_ROW_17_Left_134 VGND VGND VPWR VPWR sky130_fd_sc_hd__decap_3
XFILLER_0_39_341 VGND VGND VPWR VPWR sky130_fd_sc_hd__fill_1
XPHY_EDGE_ROW_82_Right_82 VGND VGND VPWR VPWR sky130_fd_sc_hd__decap_3
XFILLER_0_81_130 VGND VGND VPWR VPWR sky130_fd_sc_hd__fill_1
XTAP_TAPCELL_ROW_30_615 VGND VPWR sky130_fd_sc_hd__tapvpwrvgnd_1
XFILLER_0_81_152 VGND VGND VPWR VPWR sky130_fd_sc_hd__fill_2
XTAP_TAPCELL_ROW_10_372 VGND VPWR sky130_fd_sc_hd__tapvpwrvgnd_1
XFILLER_0_2_625 VPWR VGND VPWR VGND sky130_ef_sc_hd__decap_12
XTAP_TAPCELL_ROW_78_1193 VGND VPWR sky130_fd_sc_hd__tapvpwrvgnd_1
XTAP_TAPCELL_ROW_78_1182 VGND VPWR sky130_fd_sc_hd__tapvpwrvgnd_1
XFILLER_0_10_425 VGND VGND VPWR VPWR sky130_fd_sc_hd__fill_1
XFILLER_0_1_146 VGND VGND VPWR VPWR sky130_fd_sc_hd__fill_2
XFILLER_0_2_669 VPWR VGND VPWR VGND sky130_ef_sc_hd__decap_12
X_4320_ _1107_ _1108_ _1075_ VGND VGND VPWR VPWR _1109_ sky130_fd_sc_hd__mux2_2
X_4251_ _1035_ _1038_ _1039_ VGND VGND VPWR VPWR _1040_ sky130_fd_sc_hd__mux2_1
XPHY_EDGE_ROW_26_Left_143 VGND VGND VPWR VPWR sky130_fd_sc_hd__decap_3
XPHY_EDGE_ROW_91_Right_91 VGND VGND VPWR VPWR sky130_fd_sc_hd__decap_3
X_8990_ clknet_leaf_75_CLK _0223_ VGND VGND VPWR VPWR RF.reg_arr\[27\]\[0\] sky130_fd_sc_hd__dfxtp_1
XTAP_TAPCELL_ROW_38_704 VGND VPWR sky130_fd_sc_hd__tapvpwrvgnd_1
X_7941_ _3029_ net899 _3933_ VGND VGND VPWR VPWR _3939_ sky130_fd_sc_hd__mux2_1
X_7872_ _3902_ VGND VGND VPWR VPWR _0461_ sky130_fd_sc_hd__clkbuf_1
XFILLER_0_89_285 VGND VGND VPWR VPWR sky130_fd_sc_hd__fill_1
XFILLER_0_77_436 VGND VGND VPWR VPWR sky130_fd_sc_hd__decap_3
XPHY_EDGE_ROW_35_Left_152 VGND VGND VPWR VPWR sky130_fd_sc_hd__decap_3
XFILLER_0_77_458 VGND VGND VPWR VPWR sky130_fd_sc_hd__decap_4
XTAP_TAPCELL_ROW_18_472 VGND VPWR sky130_fd_sc_hd__tapvpwrvgnd_1
X_6823_ _3328_ VGND VGND VPWR VPWR _1010_ sky130_fd_sc_hd__clkbuf_1
Xclkbuf_leaf_95_CLK clknet_3_1__leaf_CLK VGND VGND VPWR VPWR clknet_leaf_95_CLK sky130_fd_sc_hd__clkbuf_8
X_6754_ _3291_ VGND VGND VPWR VPWR _0978_ sky130_fd_sc_hd__clkbuf_1
X_5705_ _1812_ _1930_ _1831_ VGND VGND VPWR VPWR _2490_ sky130_fd_sc_hd__mux2_1
X_6685_ _3231_ VGND VGND VPWR VPWR _3254_ sky130_fd_sc_hd__clkbuf_8
XFILLER_0_72_130 VGND VGND VPWR VPWR sky130_fd_sc_hd__fill_1
XFILLER_0_9_279 VGND VGND VPWR VPWR sky130_fd_sc_hd__fill_1
X_9473_ clknet_leaf_65_CLK _0706_ VGND VGND VPWR VPWR RF.reg_arr\[11\]\[3\] sky130_fd_sc_hd__dfxtp_1
XFILLER_0_92_3 VPWR VGND VPWR VGND sky130_ef_sc_hd__decap_12
X_5636_ _2086_ _2195_ _2029_ VGND VGND VPWR VPWR _2423_ sky130_fd_sc_hd__mux2_1
X_8424_ _4194_ VGND VGND VPWR VPWR _0721_ sky130_fd_sc_hd__clkbuf_1
XFILLER_0_60_336 VGND VGND VPWR VPWR sky130_fd_sc_hd__fill_2
XFILLER_0_5_441 VGND VGND VPWR VPWR sky130_fd_sc_hd__decap_6
XFILLER_0_115_287 VGND VGND VPWR VPWR sky130_fd_sc_hd__fill_1
X_5567_ net97 _1773_ VGND VGND VPWR VPWR _2355_ sky130_fd_sc_hd__nor2_1
XFILLER_0_103_449 VGND VGND VPWR VPWR sky130_fd_sc_hd__decap_8
XFILLER_0_13_252 VGND VGND VPWR VPWR sky130_fd_sc_hd__fill_1
X_8355_ _3035_ net274 _4149_ VGND VGND VPWR VPWR _4158_ sky130_fd_sc_hd__mux2_1
X_4518_ RF.reg_arr\[12\]\[29\] RF.reg_arr\[13\]\[29\] RF.reg_arr\[14\]\[29\] RF.reg_arr\[15\]\[29\]
+ _1303_ _1305_ VGND VGND VPWR VPWR _1307_ sky130_fd_sc_hd__mux4_1
Xhold142 RF.reg_arr\[7\]\[20\] VGND VGND VPWR VPWR net224 sky130_fd_sc_hd__dlygate4sd3_1
Xhold131 RF.reg_arr\[19\]\[15\] VGND VGND VPWR VPWR net213 sky130_fd_sc_hd__dlygate4sd3_1
X_7306_ _3071_ net919 _3594_ VGND VGND VPWR VPWR _3601_ sky130_fd_sc_hd__mux2_1
X_8286_ _4121_ VGND VGND VPWR VPWR _0656_ sky130_fd_sc_hd__clkbuf_1
Xhold120 RF.reg_arr\[17\]\[8\] VGND VGND VPWR VPWR net202 sky130_fd_sc_hd__dlygate4sd3_1
Xhold153 RF.reg_arr\[16\]\[3\] VGND VGND VPWR VPWR net235 sky130_fd_sc_hd__dlygate4sd3_1
XPHY_EDGE_ROW_44_Left_161 VGND VGND VPWR VPWR sky130_fd_sc_hd__decap_3
X_5498_ _1617_ _2286_ VGND VGND VPWR VPWR _2287_ sky130_fd_sc_hd__nor2_1
Xhold164 RF.reg_arr\[7\]\[29\] VGND VGND VPWR VPWR net246 sky130_fd_sc_hd__dlygate4sd3_1
Xhold186 RF.reg_arr\[2\]\[21\] VGND VGND VPWR VPWR net268 sky130_fd_sc_hd__dlygate4sd3_1
X_7237_ _3564_ VGND VGND VPWR VPWR _0164_ sky130_fd_sc_hd__clkbuf_1
Xhold175 RF.reg_arr\[25\]\[13\] VGND VGND VPWR VPWR net257 sky130_fd_sc_hd__dlygate4sd3_1
X_4449_ _1232_ _1234_ _1237_ _1055_ net8 VGND VGND VPWR VPWR _1238_ sky130_fd_sc_hd__a221o_1
XFILLER_0_0_190 VGND VGND VPWR VPWR sky130_fd_sc_hd__fill_2
XFILLER_0_1_691 VGND VGND VPWR VPWR sky130_fd_sc_hd__fill_1
Xhold197 RF.reg_arr\[5\]\[5\] VGND VGND VPWR VPWR net279 sky130_fd_sc_hd__dlygate4sd3_1
XFILLER_0_95_92 VGND VGND VPWR VPWR sky130_fd_sc_hd__fill_1
X_7168_ _3527_ VGND VGND VPWR VPWR _0132_ sky130_fd_sc_hd__clkbuf_1
X_6119_ _2436_ _2588_ _2443_ VGND VGND VPWR VPWR _2882_ sky130_fd_sc_hd__o21ai_1
X_7099_ net462 _3399_ _3485_ VGND VGND VPWR VPWR _3491_ sky130_fd_sc_hd__mux2_1
XPHY_EDGE_ROW_53_Left_170 VGND VGND VPWR VPWR sky130_fd_sc_hd__decap_3
Xclkbuf_leaf_86_CLK clknet_3_4__leaf_CLK VGND VGND VPWR VPWR clknet_leaf_86_CLK sky130_fd_sc_hd__clkbuf_8
XFILLER_0_36_322 VGND VGND VPWR VPWR sky130_fd_sc_hd__fill_1
XFILLER_0_17_580 VGND VGND VPWR VPWR sky130_fd_sc_hd__fill_1
XTAP_TAPCELL_ROW_114_1625 VGND VPWR sky130_fd_sc_hd__tapvpwrvgnd_1
XTAP_TAPCELL_ROW_114_1614 VGND VPWR sky130_fd_sc_hd__tapvpwrvgnd_1
XFILLER_0_102_460 VGND VGND VPWR VPWR sky130_fd_sc_hd__fill_1
Xclkbuf_leaf_10_CLK clknet_3_1__leaf_CLK VGND VGND VPWR VPWR clknet_leaf_10_CLK sky130_fd_sc_hd__clkbuf_8
XFILLER_0_99_561 VGND VGND VPWR VPWR sky130_fd_sc_hd__decap_6
XFILLER_0_59_447 VGND VGND VPWR VPWR sky130_fd_sc_hd__fill_1
XFILLER_0_115_57 VPWR VGND VPWR VGND sky130_ef_sc_hd__decap_12
Xclkbuf_leaf_77_CLK clknet_3_5__leaf_CLK VGND VGND VPWR VPWR clknet_leaf_77_CLK sky130_fd_sc_hd__clkbuf_8
XTAP_TAPCELL_ROW_15_431 VGND VPWR sky130_fd_sc_hd__tapvpwrvgnd_1
XFILLER_0_24_88 VGND VGND VPWR VPWR sky130_fd_sc_hd__fill_2
XTAP_TAPCELL_ROW_43_762 VGND VPWR sky130_fd_sc_hd__tapvpwrvgnd_1
XFILLER_0_46_108 VGND VGND VPWR VPWR sky130_fd_sc_hd__fill_2
XFILLER_0_27_344 VGND VGND VPWR VPWR sky130_fd_sc_hd__fill_2
XTAP_TAPCELL_ROW_43_773 VGND VPWR sky130_fd_sc_hd__tapvpwrvgnd_1
XFILLER_0_6_249 VGND VGND VPWR VPWR sky130_fd_sc_hd__decap_3
X_6470_ net106 VGND VGND VPWR VPWR _3140_ sky130_fd_sc_hd__clkbuf_1
X_5421_ _2208_ _2209_ _1603_ VGND VGND VPWR VPWR _2210_ sky130_fd_sc_hd__mux2_1
X_5352_ _1895_ _2140_ _1667_ VGND VGND VPWR VPWR _2141_ sky130_fd_sc_hd__o21ai_1
X_8140_ _4044_ VGND VGND VPWR VPWR _0587_ sky130_fd_sc_hd__clkbuf_1
X_4303_ _1091_ VGND VGND VPWR VPWR _1092_ sky130_fd_sc_hd__buf_2
X_8071_ _3023_ net949 _4005_ VGND VGND VPWR VPWR _4008_ sky130_fd_sc_hd__mux2_1
XFILLER_0_2_488 VGND VGND VPWR VPWR sky130_fd_sc_hd__fill_2
X_7022_ _3450_ VGND VGND VPWR VPWR _0063_ sky130_fd_sc_hd__clkbuf_1
X_5283_ RF.reg_arr\[28\]\[11\] RF.reg_arr\[29\]\[11\] RF.reg_arr\[30\]\[11\] RF.reg_arr\[31\]\[11\]
+ _1625_ _1598_ VGND VGND VPWR VPWR _2072_ sky130_fd_sc_hd__mux4_1
X_8973_ clknet_leaf_105_CLK _0206_ VGND VGND VPWR VPWR RF.reg_arr\[31\]\[15\] sky130_fd_sc_hd__dfxtp_1
X_7924_ _3012_ net1105 _3922_ VGND VGND VPWR VPWR _3930_ sky130_fd_sc_hd__mux2_1
X_7855_ _3893_ VGND VGND VPWR VPWR _0453_ sky130_fd_sc_hd__clkbuf_1
XFILLER_0_65_417 VGND VGND VPWR VPWR sky130_fd_sc_hd__decap_3
X_6806_ net533 _3021_ _3318_ VGND VGND VPWR VPWR _3320_ sky130_fd_sc_hd__mux2_1
Xclkbuf_leaf_68_CLK clknet_3_7__leaf_CLK VGND VGND VPWR VPWR clknet_leaf_68_CLK sky130_fd_sc_hd__clkbuf_8
X_4998_ _1785_ _1786_ _1613_ VGND VGND VPWR VPWR _1787_ sky130_fd_sc_hd__mux2_1
X_9525_ clknet_leaf_16_CLK _0758_ VGND VGND VPWR VPWR RF.reg_arr\[10\]\[23\] sky130_fd_sc_hd__dfxtp_1
X_7786_ _3856_ VGND VGND VPWR VPWR _0421_ sky130_fd_sc_hd__clkbuf_1
X_6737_ _3082_ net1093 _3281_ VGND VGND VPWR VPWR _3283_ sky130_fd_sc_hd__mux2_1
X_9456_ clknet_leaf_2_CLK _0689_ VGND VGND VPWR VPWR RF.reg_arr\[12\]\[18\] sky130_fd_sc_hd__dfxtp_1
X_6668_ _3245_ VGND VGND VPWR VPWR _0938_ sky130_fd_sc_hd__clkbuf_1
XFILLER_0_116_585 VGND VGND VPWR VPWR sky130_fd_sc_hd__decap_3
X_5619_ _2405_ _2406_ VGND VGND VPWR VPWR _2407_ sky130_fd_sc_hd__nand2_1
X_9387_ clknet_leaf_93_CLK _0620_ VGND VGND VPWR VPWR RF.reg_arr\[13\]\[13\] sky130_fd_sc_hd__dfxtp_1
X_6599_ net708 _3021_ _3207_ VGND VGND VPWR VPWR _3209_ sky130_fd_sc_hd__mux2_1
X_8407_ net783 _3409_ _4185_ VGND VGND VPWR VPWR _4186_ sky130_fd_sc_hd__mux2_1
X_8338_ _4137_ VGND VGND VPWR VPWR _4149_ sky130_fd_sc_hd__clkbuf_8
X_8269_ _4112_ VGND VGND VPWR VPWR _0648_ sky130_fd_sc_hd__clkbuf_1
XTAP_TAPCELL_ROW_64_1023 VGND VPWR sky130_fd_sc_hd__tapvpwrvgnd_1
Xclkbuf_leaf_59_CLK clknet_3_7__leaf_CLK VGND VGND VPWR VPWR clknet_leaf_59_CLK sky130_fd_sc_hd__clkbuf_8
XFILLER_0_68_266 VGND VGND VPWR VPWR sky130_fd_sc_hd__fill_1
XFILLER_0_83_236 VGND VGND VPWR VPWR sky130_fd_sc_hd__fill_2
XTAP_TAPCELL_ROW_12_401 VGND VPWR sky130_fd_sc_hd__tapvpwrvgnd_1
XFILLER_0_49_491 VGND VGND VPWR VPWR sky130_fd_sc_hd__fill_1
XTAP_TAPCELL_ROW_40_732 VGND VPWR sky130_fd_sc_hd__tapvpwrvgnd_1
XFILLER_0_3_219 VGND VGND VPWR VPWR sky130_fd_sc_hd__decap_4
XPHY_EDGE_ROW_108_Right_108 VGND VGND VPWR VPWR sky130_fd_sc_hd__decap_3
XFILLER_0_51_166 VGND VGND VPWR VPWR sky130_fd_sc_hd__fill_2
XTAP_TAPCELL_ROW_75_1152 VGND VPWR sky130_fd_sc_hd__tapvpwrvgnd_1
XFILLER_0_20_531 VGND VGND VPWR VPWR sky130_fd_sc_hd__fill_1
XFILLER_0_20_553 VGND VGND VPWR VPWR sky130_fd_sc_hd__decap_8
XTAP_TAPCELL_ROW_48_832 VGND VPWR sky130_fd_sc_hd__tapvpwrvgnd_1
X_5970_ _1980_ _2726_ VGND VGND VPWR VPWR _2742_ sky130_fd_sc_hd__nand2_1
XFILLER_0_59_211 VGND VGND VPWR VPWR sky130_fd_sc_hd__fill_2
X_4921_ _1708_ _1709_ _1605_ VGND VGND VPWR VPWR _1710_ sky130_fd_sc_hd__mux2_1
XTAP_TAPCELL_ROW_86_1281 VGND VPWR sky130_fd_sc_hd__tapvpwrvgnd_1
XFILLER_0_19_119 VGND VGND VPWR VPWR sky130_fd_sc_hd__decap_4
X_4852_ net5 VGND VGND VPWR VPWR _1641_ sky130_fd_sc_hd__inv_2
X_7640_ _3779_ VGND VGND VPWR VPWR _0352_ sky130_fd_sc_hd__clkbuf_1
XFILLER_0_28_642 VGND VGND VPWR VPWR sky130_fd_sc_hd__fill_2
X_4783_ RF.reg_arr\[12\]\[24\] RF.reg_arr\[13\]\[24\] RF.reg_arr\[14\]\[24\] RF.reg_arr\[15\]\[24\]
+ _1302_ _1322_ VGND VGND VPWR VPWR _1572_ sky130_fd_sc_hd__mux4_1
X_7571_ net329 _3391_ _3741_ VGND VGND VPWR VPWR _3743_ sky130_fd_sc_hd__mux2_1
XFILLER_0_7_525 VGND VGND VPWR VPWR sky130_fd_sc_hd__fill_1
X_6522_ net965 _3012_ _3160_ VGND VGND VPWR VPWR _3168_ sky130_fd_sc_hd__mux2_1
X_9310_ clknet_leaf_75_CLK _0543_ VGND VGND VPWR VPWR RF.reg_arr\[20\]\[0\] sky130_fd_sc_hd__dfxtp_1
XFILLER_0_42_100 VGND VGND VPWR VPWR sky130_fd_sc_hd__fill_1
X_9241_ clknet_leaf_33_CLK _0474_ VGND VGND VPWR VPWR RF.reg_arr\[22\]\[27\] sky130_fd_sc_hd__dfxtp_1
X_6453_ _3131_ VGND VGND VPWR VPWR _0837_ sky130_fd_sc_hd__clkbuf_1
Xclkload40 clknet_leaf_31_CLK VGND VGND VPWR VPWR clkload40/Y sky130_fd_sc_hd__bufinv_16
Xclkload51 clknet_leaf_40_CLK VGND VGND VPWR VPWR clkload51/X sky130_fd_sc_hd__clkbuf_4
X_5404_ _1649_ _2192_ VGND VGND VPWR VPWR _2193_ sky130_fd_sc_hd__and2b_1
XFILLER_0_70_486 VGND VGND VPWR VPWR sky130_fd_sc_hd__fill_1
X_9172_ clknet_leaf_43_CLK _0405_ VGND VGND VPWR VPWR RF.reg_arr\[9\]\[22\] sky130_fd_sc_hd__dfxtp_1
Xclkload62 clknet_leaf_92_CLK VGND VGND VPWR VPWR clkload62/Y sky130_fd_sc_hd__clkinv_8
Xclkload84 clknet_leaf_46_CLK VGND VGND VPWR VPWR clkload84/Y sky130_fd_sc_hd__clkinv_4
Xclkload95 clknet_leaf_55_CLK VGND VGND VPWR VPWR clkload95/Y sky130_fd_sc_hd__bufinv_16
X_8123_ _4035_ VGND VGND VPWR VPWR _0579_ sky130_fd_sc_hd__clkbuf_1
Xclkload73 clknet_leaf_75_CLK VGND VGND VPWR VPWR clkload73/Y sky130_fd_sc_hd__clkinv_4
XFILLER_0_23_391 VGND VGND VPWR VPWR sky130_fd_sc_hd__fill_1
X_6384_ _3087_ VGND VGND VPWR VPWR _0812_ sky130_fd_sc_hd__clkbuf_1
XFILLER_0_100_249 VGND VGND VPWR VPWR sky130_fd_sc_hd__decap_3
X_5335_ _2086_ _2123_ _2001_ VGND VGND VPWR VPWR _2124_ sky130_fd_sc_hd__mux2_1
X_8054_ _3006_ net691 _3994_ VGND VGND VPWR VPWR _3999_ sky130_fd_sc_hd__mux2_1
X_5266_ RF.reg_arr\[28\]\[10\] RF.reg_arr\[29\]\[10\] RF.reg_arr\[30\]\[10\] RF.reg_arr\[31\]\[10\]
+ _1947_ _1948_ VGND VGND VPWR VPWR _2055_ sky130_fd_sc_hd__mux4_1
X_7005_ _3440_ VGND VGND VPWR VPWR _0056_ sky130_fd_sc_hd__clkbuf_1
X_5197_ RF.reg_arr\[16\]\[17\] RF.reg_arr\[17\]\[17\] RF.reg_arr\[18\]\[17\] RF.reg_arr\[19\]\[17\]
+ _1883_ _1885_ VGND VGND VPWR VPWR _1986_ sky130_fd_sc_hd__mux4_1
X_8956_ clknet_leaf_20_CLK _0189_ VGND VGND VPWR VPWR RF.reg_arr\[29\]\[30\] sky130_fd_sc_hd__dfxtp_1
X_7907_ _3920_ VGND VGND VPWR VPWR _0478_ sky130_fd_sc_hd__clkbuf_1
XFILLER_0_93_501 VGND VGND VPWR VPWR sky130_fd_sc_hd__decap_3
X_8887_ clknet_leaf_38_CLK _0120_ VGND VGND VPWR VPWR RF.reg_arr\[3\]\[25\] sky130_fd_sc_hd__dfxtp_1
XTAP_TAPCELL_ROW_26_559 VGND VPWR sky130_fd_sc_hd__tapvpwrvgnd_1
XFILLER_0_38_406 VGND VGND VPWR VPWR sky130_fd_sc_hd__fill_2
X_7838_ _3883_ VGND VGND VPWR VPWR _0446_ sky130_fd_sc_hd__clkbuf_1
X_7769_ net134 _3385_ _3812_ VGND VGND VPWR VPWR _3847_ sky130_fd_sc_hd__mux2_1
XFILLER_0_18_174 VGND VGND VPWR VPWR sky130_fd_sc_hd__decap_4
X_9508_ clknet_leaf_84_CLK _0741_ VGND VGND VPWR VPWR RF.reg_arr\[10\]\[6\] sky130_fd_sc_hd__dfxtp_1
XFILLER_0_33_111 VGND VGND VPWR VPWR sky130_fd_sc_hd__fill_1
Xclkload1 clknet_3_1__leaf_CLK VGND VGND VPWR VPWR clkload1/Y sky130_fd_sc_hd__clkinvlp_4
XFILLER_0_34_645 VGND VGND VPWR VPWR sky130_fd_sc_hd__decap_6
XFILLER_0_46_472 VGND VGND VPWR VPWR sky130_fd_sc_hd__decap_4
XFILLER_0_116_382 VGND VGND VPWR VPWR sky130_fd_sc_hd__fill_2
XFILLER_0_34_667 VGND VGND VPWR VPWR sky130_fd_sc_hd__fill_2
X_9439_ clknet_leaf_68_CLK _0672_ VGND VGND VPWR VPWR RF.reg_arr\[12\]\[1\] sky130_fd_sc_hd__dfxtp_1
XFILLER_0_104_533 VGND VGND VPWR VPWR sky130_fd_sc_hd__decap_6
XFILLER_0_88_317 VGND VGND VPWR VPWR sky130_fd_sc_hd__fill_2
XTAP_TAPCELL_ROW_70_1093 VGND VPWR sky130_fd_sc_hd__tapvpwrvgnd_1
XTAP_TAPCELL_ROW_109_1557 VGND VPWR sky130_fd_sc_hd__tapvpwrvgnd_1
XFILLER_0_84_589 VGND VGND VPWR VPWR sky130_fd_sc_hd__decap_4
XTAP_TAPCELL_ROW_53_890 VGND VPWR sky130_fd_sc_hd__tapvpwrvgnd_1
XFILLER_0_71_217 VGND VGND VPWR VPWR sky130_fd_sc_hd__fill_2
XFILLER_0_24_122 VGND VGND VPWR VPWR sky130_fd_sc_hd__decap_6
XFILLER_0_25_667 VGND VGND VPWR VPWR sky130_fd_sc_hd__decap_4
Xhold708 RF.reg_arr\[22\]\[1\] VGND VGND VPWR VPWR net790 sky130_fd_sc_hd__dlygate4sd3_1
Xhold719 RF.reg_arr\[26\]\[15\] VGND VGND VPWR VPWR net801 sky130_fd_sc_hd__dlygate4sd3_1
X_5120_ _1907_ _1908_ _1612_ VGND VGND VPWR VPWR _1909_ sky130_fd_sc_hd__mux2_1
X_5051_ RF.reg_arr\[16\]\[22\] RF.reg_arr\[17\]\[22\] RF.reg_arr\[18\]\[22\] RF.reg_arr\[19\]\[22\]
+ _1590_ _1835_ VGND VGND VPWR VPWR _1840_ sky130_fd_sc_hd__mux4_1
XTAP_TAPCELL_ROW_88_1310 VGND VPWR sky130_fd_sc_hd__tapvpwrvgnd_1
X_8810_ clknet_leaf_96_CLK _0043_ VGND VGND VPWR VPWR RF.reg_arr\[4\]\[12\] sky130_fd_sc_hd__dfxtp_1
XPHY_EDGE_ROW_9_Left_126 VGND VGND VPWR VPWR sky130_fd_sc_hd__decap_3
XFILLER_0_1_55 VGND VGND VPWR VPWR sky130_fd_sc_hd__fill_1
X_8741_ clknet_leaf_89_CLK _0998_ VGND VGND VPWR VPWR RF.reg_arr\[6\]\[7\] sky130_fd_sc_hd__dfxtp_1
X_5953_ _1143_ _2725_ VGND VGND VPWR VPWR _2726_ sky130_fd_sc_hd__xnor2_1
X_5884_ _2495_ _2660_ _2022_ VGND VGND VPWR VPWR _2661_ sky130_fd_sc_hd__mux2_1
X_4904_ RF.reg_arr\[0\]\[29\] RF.reg_arr\[1\]\[29\] RF.reg_arr\[2\]\[29\] RF.reg_arr\[3\]\[29\]
+ _1627_ _1629_ VGND VGND VPWR VPWR _1693_ sky130_fd_sc_hd__mux4_1
XFILLER_0_75_545 VGND VGND VPWR VPWR sky130_fd_sc_hd__fill_1
XTAP_TAPCELL_ROW_23_529 VGND VPWR sky130_fd_sc_hd__tapvpwrvgnd_1
X_8672_ clknet_leaf_65_CLK _0929_ VGND VGND VPWR VPWR RF.reg_arr\[15\]\[2\] sky130_fd_sc_hd__dfxtp_1
X_7623_ net273 _3375_ _3763_ VGND VGND VPWR VPWR _3770_ sky130_fd_sc_hd__mux2_1
XFILLER_0_16_601 VGND VGND VPWR VPWR sky130_fd_sc_hd__decap_6
X_4835_ _1623_ VGND VGND VPWR VPWR _1624_ sky130_fd_sc_hd__buf_4
X_7554_ _3733_ VGND VGND VPWR VPWR _0312_ sky130_fd_sc_hd__clkbuf_1
X_4766_ _1551_ _1552_ _1553_ _1554_ _1296_ _1173_ VGND VGND VPWR VPWR _1555_ sky130_fd_sc_hd__mux4_1
XFILLER_0_43_420 VGND VGND VPWR VPWR sky130_fd_sc_hd__decap_3
X_6505_ _2975_ _2973_ _2974_ _2972_ VGND VGND VPWR VPWR _3158_ sky130_fd_sc_hd__or4bb_4
X_7485_ _3113_ net559 _3689_ VGND VGND VPWR VPWR _3696_ sky130_fd_sc_hd__mux2_1
XFILLER_0_70_250 VGND VGND VPWR VPWR sky130_fd_sc_hd__fill_2
X_4697_ _1484_ _1485_ _1042_ VGND VGND VPWR VPWR _1486_ sky130_fd_sc_hd__mux2_1
XFILLER_0_31_615 VGND VGND VPWR VPWR sky130_fd_sc_hd__fill_1
X_6436_ _3122_ VGND VGND VPWR VPWR _0829_ sky130_fd_sc_hd__clkbuf_1
XFILLER_0_3_561 VGND VGND VPWR VPWR sky130_fd_sc_hd__decap_3
X_9224_ clknet_leaf_10_CLK _0457_ VGND VGND VPWR VPWR RF.reg_arr\[22\]\[10\] sky130_fd_sc_hd__dfxtp_1
XFILLER_0_113_385 VGND VGND VPWR VPWR sky130_fd_sc_hd__fill_1
X_6367_ _3075_ net653 _3059_ VGND VGND VPWR VPWR _3076_ sky130_fd_sc_hd__mux2_1
X_9155_ clknet_leaf_73_CLK _0388_ VGND VGND VPWR VPWR RF.reg_arr\[9\]\[5\] sky130_fd_sc_hd__dfxtp_1
XFILLER_0_30_158 VGND VGND VPWR VPWR sky130_fd_sc_hd__fill_1
X_8106_ _2988_ net968 _4016_ VGND VGND VPWR VPWR _4026_ sky130_fd_sc_hd__mux2_1
XFILLER_0_101_569 VGND VGND VPWR VPWR sky130_fd_sc_hd__fill_2
XFILLER_0_11_372 VGND VGND VPWR VPWR sky130_fd_sc_hd__decap_4
X_5318_ _2105_ _2106_ _1864_ VGND VGND VPWR VPWR _2107_ sky130_fd_sc_hd__mux2_1
X_9086_ clknet_leaf_66_CLK _0319_ VGND VGND VPWR VPWR RF.reg_arr\[2\]\[0\] sky130_fd_sc_hd__dfxtp_1
X_6298_ net21 VGND VGND VPWR VPWR _3031_ sky130_fd_sc_hd__buf_2
X_8037_ _3989_ VGND VGND VPWR VPWR _0539_ sky130_fd_sc_hd__clkbuf_1
Xhold35 RF.reg_arr\[0\]\[20\] VGND VGND VPWR VPWR net117 sky130_fd_sc_hd__dlygate4sd3_1
Xhold24 RF.reg_arr\[0\]\[15\] VGND VGND VPWR VPWR net106 sky130_fd_sc_hd__dlygate4sd3_1
Xhold46 RF.reg_arr\[0\]\[9\] VGND VGND VPWR VPWR net128 sky130_fd_sc_hd__dlygate4sd3_1
X_5249_ net3 _2037_ VGND VGND VPWR VPWR _2038_ sky130_fd_sc_hd__or2_1
Xhold57 RF.reg_arr\[9\]\[26\] VGND VGND VPWR VPWR net139 sky130_fd_sc_hd__dlygate4sd3_1
Xhold68 RF.reg_arr\[7\]\[24\] VGND VGND VPWR VPWR net150 sky130_fd_sc_hd__dlygate4sd3_1
Xhold79 RF.reg_arr\[3\]\[29\] VGND VGND VPWR VPWR net161 sky130_fd_sc_hd__dlygate4sd3_1
XFILLER_0_97_103 VGND VGND VPWR VPWR sky130_fd_sc_hd__decap_8
XTAP_TAPCELL_ROW_3_287 VGND VPWR sky130_fd_sc_hd__tapvpwrvgnd_1
X_8939_ clknet_leaf_93_CLK _0172_ VGND VGND VPWR VPWR RF.reg_arr\[29\]\[13\] sky130_fd_sc_hd__dfxtp_1
XFILLER_0_78_394 VGND VGND VPWR VPWR sky130_fd_sc_hd__decap_3
XFILLER_0_108_113 VGND VGND VPWR VPWR sky130_fd_sc_hd__decap_4
XTAP_TAPCELL_ROW_104_1498 VGND VPWR sky130_fd_sc_hd__tapvpwrvgnd_1
XFILLER_0_66_589 VGND VGND VPWR VPWR sky130_fd_sc_hd__decap_8
XFILLER_0_104_363 VGND VGND VPWR VPWR sky130_fd_sc_hd__fill_1
XFILLER_0_67_19 VGND VGND VPWR VPWR sky130_fd_sc_hd__decap_6
XTAP_TAPCELL_ROW_72_1111 VGND VPWR sky130_fd_sc_hd__tapvpwrvgnd_1
XFILLER_0_16_23 VGND VGND VPWR VPWR sky130_fd_sc_hd__fill_2
XFILLER_0_97_670 VGND VGND VPWR VPWR sky130_fd_sc_hd__fill_2
XFILLER_0_84_331 VGND VGND VPWR VPWR sky130_fd_sc_hd__fill_1
XTAP_TAPCELL_ROW_83_1251 VGND VPWR sky130_fd_sc_hd__tapvpwrvgnd_1
XFILLER_0_29_225 VGND VGND VPWR VPWR sky130_fd_sc_hd__fill_1
X_4620_ _1407_ _1408_ _1059_ VGND VGND VPWR VPWR _1409_ sky130_fd_sc_hd__mux2_1
XFILLER_0_115_617 VPWR VGND VPWR VGND sky130_ef_sc_hd__decap_12
XFILLER_0_113_3 VPWR VGND VPWR VGND sky130_ef_sc_hd__decap_12
XFILLER_0_25_420 VGND VGND VPWR VPWR sky130_fd_sc_hd__fill_1
X_4551_ RF.reg_arr\[8\]\[20\] RF.reg_arr\[9\]\[20\] RF.reg_arr\[10\]\[20\] RF.reg_arr\[11\]\[20\]
+ _1186_ _1188_ VGND VGND VPWR VPWR _1340_ sky130_fd_sc_hd__mux4_1
X_7270_ _3103_ net789 _3580_ VGND VGND VPWR VPWR _3582_ sky130_fd_sc_hd__mux2_1
X_4482_ _1223_ _1270_ _1255_ _1239_ VGND VGND VPWR VPWR _1271_ sky130_fd_sc_hd__or4_4
Xhold516 RF.reg_arr\[16\]\[22\] VGND VGND VPWR VPWR net598 sky130_fd_sc_hd__dlygate4sd3_1
XFILLER_0_13_637 VGND VGND VPWR VPWR sky130_fd_sc_hd__decap_3
Xhold527 RF.reg_arr\[11\]\[12\] VGND VGND VPWR VPWR net609 sky130_fd_sc_hd__dlygate4sd3_1
Xhold505 RF.reg_arr\[2\]\[8\] VGND VGND VPWR VPWR net587 sky130_fd_sc_hd__dlygate4sd3_1
Xhold538 RF.reg_arr\[7\]\[31\] VGND VGND VPWR VPWR net620 sky130_fd_sc_hd__dlygate4sd3_1
X_6221_ _2977_ VGND VGND VPWR VPWR _2978_ sky130_fd_sc_hd__buf_6
Xhold549 RF.reg_arr\[16\]\[15\] VGND VGND VPWR VPWR net631 sky130_fd_sc_hd__dlygate4sd3_1
X_6152_ _1447_ _1581_ _2859_ VGND VGND VPWR VPWR _2913_ sky130_fd_sc_hd__and3b_1
XTAP_TAPCELL_ROW_94_1380 VGND VPWR sky130_fd_sc_hd__tapvpwrvgnd_1
X_5103_ _1649_ _1891_ VGND VGND VPWR VPWR _1892_ sky130_fd_sc_hd__or2_1
XFILLER_0_0_586 VGND VGND VPWR VPWR sky130_fd_sc_hd__fill_2
X_6083_ _1832_ _2588_ _2847_ _2445_ VGND VGND VPWR VPWR _2848_ sky130_fd_sc_hd__o211a_1
X_5034_ _1821_ _1822_ _1041_ VGND VGND VPWR VPWR _1823_ sky130_fd_sc_hd__mux2_1
XTAP_TAPCELL_ROW_56_919 VGND VPWR sky130_fd_sc_hd__tapvpwrvgnd_1
XFILLER_0_79_136 VGND VGND VPWR VPWR sky130_fd_sc_hd__fill_1
XTAP_TAPCELL_ROW_0_235 VGND VPWR sky130_fd_sc_hd__tapvpwrvgnd_1
XFILLER_0_18_3 VGND VGND VPWR VPWR sky130_fd_sc_hd__fill_2
XFILLER_0_94_106 VGND VGND VPWR VPWR sky130_fd_sc_hd__decap_4
XFILLER_0_88_681 VGND VGND VPWR VPWR sky130_fd_sc_hd__decap_4
XTAP_TAPCELL_ROW_0_246 VGND VPWR sky130_fd_sc_hd__tapvpwrvgnd_1
XTAP_TAPCELL_ROW_0_257 VGND VPWR sky130_fd_sc_hd__tapvpwrvgnd_1
X_6985_ _3427_ VGND VGND VPWR VPWR _0049_ sky130_fd_sc_hd__clkbuf_1
X_5936_ _2586_ _2557_ VGND VGND VPWR VPWR _2710_ sky130_fd_sc_hd__or2b_1
X_8724_ clknet_leaf_43_CLK _0981_ VGND VGND VPWR VPWR RF.reg_arr\[14\]\[22\] sky130_fd_sc_hd__dfxtp_1
XTAP_TAPCELL_ROW_36_687 VGND VPWR sky130_fd_sc_hd__tapvpwrvgnd_1
X_8655_ clknet_leaf_103_CLK _0912_ VGND VGND VPWR VPWR RF.reg_arr\[8\]\[17\] sky130_fd_sc_hd__dfxtp_1
X_5867_ _1499_ _2447_ _2643_ VGND VGND VPWR VPWR _2644_ sky130_fd_sc_hd__or3_1
X_7606_ net289 _3426_ _3752_ VGND VGND VPWR VPWR _3761_ sky130_fd_sc_hd__mux2_1
X_5798_ _2577_ _2578_ VGND VGND VPWR VPWR _2579_ sky130_fd_sc_hd__nand2_1
X_4818_ RF.reg_arr\[20\]\[31\] RF.reg_arr\[21\]\[31\] RF.reg_arr\[22\]\[31\] RF.reg_arr\[23\]\[31\]
+ _1593_ _1600_ VGND VGND VPWR VPWR _1607_ sky130_fd_sc_hd__mux4_1
XFILLER_0_7_163 VGND VGND VPWR VPWR sky130_fd_sc_hd__decap_4
X_8586_ clknet_leaf_89_CLK _0843_ VGND VGND VPWR VPWR RF.reg_arr\[0\]\[12\] sky130_fd_sc_hd__dfxtp_1
X_4749_ RF.reg_arr\[24\]\[15\] RF.reg_arr\[25\]\[15\] RF.reg_arr\[26\]\[15\] RF.reg_arr\[27\]\[15\]
+ _1134_ _1135_ VGND VGND VPWR VPWR _1538_ sky130_fd_sc_hd__mux4_1
X_7537_ _3724_ VGND VGND VPWR VPWR _0304_ sky130_fd_sc_hd__clkbuf_1
XFILLER_0_43_250 VGND VGND VPWR VPWR sky130_fd_sc_hd__decap_4
X_7468_ _3096_ net962 _3678_ VGND VGND VPWR VPWR _3687_ sky130_fd_sc_hd__mux2_1
X_6419_ net31 VGND VGND VPWR VPWR _3111_ sky130_fd_sc_hd__clkbuf_2
X_9207_ clknet_leaf_25_CLK _0440_ VGND VGND VPWR VPWR RF.reg_arr\[24\]\[25\] sky130_fd_sc_hd__dfxtp_1
Xoutput58 net58 VGND VGND VPWR VPWR result[18] sky130_fd_sc_hd__clkbuf_4
X_7399_ _3096_ net785 _3641_ VGND VGND VPWR VPWR _3650_ sky130_fd_sc_hd__mux2_1
Xoutput69 net69 VGND VGND VPWR VPWR result[28] sky130_fd_sc_hd__clkbuf_4
X_9138_ clknet_leaf_18_CLK _0371_ VGND VGND VPWR VPWR RF.reg_arr\[30\]\[20\] sky130_fd_sc_hd__dfxtp_1
XTAP_TAPCELL_ROW_8_346 VGND VPWR sky130_fd_sc_hd__tapvpwrvgnd_1
X_9069_ clknet_leaf_105_CLK _0302_ VGND VGND VPWR VPWR RF.reg_arr\[28\]\[15\] sky130_fd_sc_hd__dfxtp_1
XTAP_TAPCELL_ROW_106_1527 VGND VPWR sky130_fd_sc_hd__tapvpwrvgnd_1
XFILLER_0_98_467 VGND VGND VPWR VPWR sky130_fd_sc_hd__fill_2
XFILLER_0_109_411 VGND VGND VPWR VPWR sky130_fd_sc_hd__fill_1
XFILLER_0_94_640 VGND VGND VPWR VPWR sky130_fd_sc_hd__decap_4
XFILLER_0_89_445 VGND VGND VPWR VPWR sky130_fd_sc_hd__decap_3
X_6770_ _3115_ net729 _3292_ VGND VGND VPWR VPWR _3300_ sky130_fd_sc_hd__mux2_1
XFILLER_0_69_180 VGND VGND VPWR VPWR sky130_fd_sc_hd__fill_2
XFILLER_0_43_43 VGND VGND VPWR VPWR sky130_fd_sc_hd__fill_1
X_5721_ _1092_ VGND VGND VPWR VPWR _2505_ sky130_fd_sc_hd__inv_2
XFILLER_0_85_673 VGND VGND VPWR VPWR sky130_fd_sc_hd__fill_2
XTAP_TAPCELL_ROW_33_646 VGND VPWR sky130_fd_sc_hd__tapvpwrvgnd_1
XPHY_EDGE_ROW_99_Left_216 VGND VGND VPWR VPWR sky130_fd_sc_hd__decap_3
XTAP_TAPCELL_ROW_61_988 VGND VPWR sky130_fd_sc_hd__tapvpwrvgnd_1
X_8440_ net449 net32 _4196_ VGND VGND VPWR VPWR _4203_ sky130_fd_sc_hd__mux2_1
X_5652_ _2437_ _2438_ _2361_ VGND VGND VPWR VPWR _2439_ sky130_fd_sc_hd__mux2_1
XFILLER_0_72_356 VGND VGND VPWR VPWR sky130_fd_sc_hd__decap_4
XFILLER_0_5_612 VGND VGND VPWR VPWR sky130_fd_sc_hd__decap_4
X_5583_ _1895_ _1911_ _1792_ VGND VGND VPWR VPWR _2371_ sky130_fd_sc_hd__o21ai_1
X_8371_ _4166_ VGND VGND VPWR VPWR _0696_ sky130_fd_sc_hd__clkbuf_1
X_4603_ _1388_ _1391_ _1077_ VGND VGND VPWR VPWR _1392_ sky130_fd_sc_hd__mux2_1
Xhold302 RF.reg_arr\[2\]\[29\] VGND VGND VPWR VPWR net384 sky130_fd_sc_hd__dlygate4sd3_1
X_4534_ RF.reg_arr\[8\]\[23\] RF.reg_arr\[9\]\[23\] RF.reg_arr\[10\]\[23\] RF.reg_arr\[11\]\[23\]
+ _1316_ _1322_ VGND VGND VPWR VPWR _1323_ sky130_fd_sc_hd__mux4_1
XFILLER_0_13_434 VGND VGND VPWR VPWR sky130_fd_sc_hd__fill_1
XFILLER_0_4_155 VGND VGND VPWR VPWR sky130_fd_sc_hd__fill_1
X_7322_ _3609_ VGND VGND VPWR VPWR _0204_ sky130_fd_sc_hd__clkbuf_1
XFILLER_0_111_620 VGND VGND VPWR VPWR sky130_fd_sc_hd__decap_4
Xhold313 RF.reg_arr\[4\]\[21\] VGND VGND VPWR VPWR net395 sky130_fd_sc_hd__dlygate4sd3_1
Xhold335 RF.reg_arr\[13\]\[17\] VGND VGND VPWR VPWR net417 sky130_fd_sc_hd__dlygate4sd3_1
XFILLER_0_7_54 VGND VGND VPWR VPWR sky130_fd_sc_hd__fill_2
Xhold324 RF.reg_arr\[17\]\[18\] VGND VGND VPWR VPWR net406 sky130_fd_sc_hd__dlygate4sd3_1
Xhold346 RF.reg_arr\[1\]\[4\] VGND VGND VPWR VPWR net428 sky130_fd_sc_hd__dlygate4sd3_1
X_7253_ _3086_ net680 _3569_ VGND VGND VPWR VPWR _3573_ sky130_fd_sc_hd__mux2_1
Xhold368 RF.reg_arr\[4\]\[0\] VGND VGND VPWR VPWR net450 sky130_fd_sc_hd__dlygate4sd3_1
X_4465_ _1055_ _1253_ net8 VGND VGND VPWR VPWR _1254_ sky130_fd_sc_hd__a21o_1
Xhold357 RF.reg_arr\[29\]\[11\] VGND VGND VPWR VPWR net439 sky130_fd_sc_hd__dlygate4sd3_1
X_6204_ _1467_ _1646_ VGND VGND VPWR VPWR _2962_ sky130_fd_sc_hd__xor2_1
Xhold379 RF.reg_arr\[14\]\[20\] VGND VGND VPWR VPWR net461 sky130_fd_sc_hd__dlygate4sd3_1
X_4396_ _1163_ _1174_ _1184_ VGND VGND VPWR VPWR _1185_ sky130_fd_sc_hd__o21ai_4
XFILLER_0_0_350 VGND VGND VPWR VPWR sky130_fd_sc_hd__fill_2
X_7184_ net422 _3416_ _3532_ VGND VGND VPWR VPWR _3536_ sky130_fd_sc_hd__mux2_1
X_6135_ _2882_ _2886_ _2887_ _2897_ _2568_ VGND VGND VPWR VPWR net67 sky130_fd_sc_hd__o32a_1
XTAP_TAPCELL_ROW_5_316 VGND VPWR sky130_fd_sc_hd__tapvpwrvgnd_1
XFILLER_0_0_383 VGND VGND VPWR VPWR sky130_fd_sc_hd__decap_6
X_6066_ _1891_ _2829_ _2830_ VGND VGND VPWR VPWR _2832_ sky130_fd_sc_hd__and3b_1
Xhold1024 RF.reg_arr\[28\]\[31\] VGND VGND VPWR VPWR net1106 sky130_fd_sc_hd__dlygate4sd3_1
Xhold1002 RF.reg_arr\[26\]\[17\] VGND VGND VPWR VPWR net1084 sky130_fd_sc_hd__dlygate4sd3_1
Xhold1013 RF.reg_arr\[30\]\[4\] VGND VGND VPWR VPWR net1095 sky130_fd_sc_hd__dlygate4sd3_1
X_5017_ _1804_ _1805_ _1613_ VGND VGND VPWR VPWR _1806_ sky130_fd_sc_hd__mux2_1
Xhold1035 RF.reg_arr\[24\]\[12\] VGND VGND VPWR VPWR net1117 sky130_fd_sc_hd__dlygate4sd3_1
XFILLER_0_68_618 VGND VGND VPWR VPWR sky130_fd_sc_hd__fill_2
XFILLER_0_76_640 VGND VGND VPWR VPWR sky130_fd_sc_hd__fill_1
X_8707_ clknet_leaf_79_CLK _0964_ VGND VGND VPWR VPWR RF.reg_arr\[14\]\[5\] sky130_fd_sc_hd__dfxtp_1
X_6968_ net18 VGND VGND VPWR VPWR _3416_ sky130_fd_sc_hd__buf_2
X_5919_ _2648_ _2653_ VGND VGND VPWR VPWR _2694_ sky130_fd_sc_hd__nand2_1
XFILLER_0_75_161 VGND VGND VPWR VPWR sky130_fd_sc_hd__decap_4
XFILLER_0_75_150 VGND VGND VPWR VPWR sky130_fd_sc_hd__fill_2
X_6899_ _3369_ VGND VGND VPWR VPWR _0021_ sky130_fd_sc_hd__clkbuf_1
XFILLER_0_36_526 VGND VGND VPWR VPWR sky130_fd_sc_hd__decap_6
XFILLER_0_106_403 VGND VGND VPWR VPWR sky130_fd_sc_hd__decap_6
XTAP_TAPCELL_ROW_101_1468 VGND VPWR sky130_fd_sc_hd__tapvpwrvgnd_1
XFILLER_0_8_472 VGND VGND VPWR VPWR sky130_fd_sc_hd__fill_1
X_8638_ clknet_leaf_72_CLK _0895_ VGND VGND VPWR VPWR RF.reg_arr\[8\]\[0\] sky130_fd_sc_hd__dfxtp_1
X_8569_ clknet_leaf_35_CLK _0826_ VGND VGND VPWR VPWR RF.reg_arr\[23\]\[27\] sky130_fd_sc_hd__dfxtp_1
XFILLER_0_23_209 VGND VGND VPWR VPWR sky130_fd_sc_hd__fill_1
XFILLER_0_106_469 VGND VGND VPWR VPWR sky130_fd_sc_hd__decap_6
XFILLER_0_44_581 VGND VGND VPWR VPWR sky130_fd_sc_hd__decap_6
Xhold891 RF.reg_arr\[21\]\[1\] VGND VGND VPWR VPWR net973 sky130_fd_sc_hd__dlygate4sd3_1
XFILLER_0_7_3 VPWR VGND VPWR VGND sky130_ef_sc_hd__decap_12
Xhold880 RF.reg_arr\[26\]\[18\] VGND VGND VPWR VPWR net962 sky130_fd_sc_hd__dlygate4sd3_1
XTAP_TAPCELL_ROW_112_1597 VGND VPWR sky130_fd_sc_hd__tapvpwrvgnd_1
XTAP_TAPCELL_ROW_67_1054 VGND VPWR sky130_fd_sc_hd__tapvpwrvgnd_1
XFILLER_0_104_15 VPWR VGND VPWR VGND sky130_ef_sc_hd__decap_12
XTAP_TAPCELL_ROW_80_1210 VGND VPWR sky130_fd_sc_hd__tapvpwrvgnd_1
XFILLER_0_13_57 VGND VGND VPWR VPWR sky130_fd_sc_hd__fill_2
XTAP_TAPCELL_ROW_30_616 VGND VPWR sky130_fd_sc_hd__tapvpwrvgnd_1
XFILLER_0_14_209 VGND VGND VPWR VPWR sky130_fd_sc_hd__fill_2
XTAP_TAPCELL_ROW_10_373 VGND VPWR sky130_fd_sc_hd__tapvpwrvgnd_1
XFILLER_0_2_637 VGND VGND VPWR VPWR sky130_fd_sc_hd__decap_6
XFILLER_0_22_253 VGND VGND VPWR VPWR sky130_fd_sc_hd__fill_1
XTAP_TAPCELL_ROW_78_1183 VGND VPWR sky130_fd_sc_hd__tapvpwrvgnd_1
XFILLER_0_22_275 VGND VGND VPWR VPWR sky130_fd_sc_hd__fill_2
XFILLER_0_10_459 VGND VGND VPWR VPWR sky130_fd_sc_hd__fill_1
XFILLER_0_1_169 VGND VGND VPWR VPWR sky130_fd_sc_hd__fill_1
X_4250_ net7 VGND VGND VPWR VPWR _1039_ sky130_fd_sc_hd__clkbuf_8
X_7940_ _3938_ VGND VGND VPWR VPWR _0493_ sky130_fd_sc_hd__clkbuf_1
XTAP_TAPCELL_ROW_38_705 VGND VPWR sky130_fd_sc_hd__tapvpwrvgnd_1
X_7871_ _3088_ net1038 _3897_ VGND VGND VPWR VPWR _3902_ sky130_fd_sc_hd__mux2_1
X_6822_ net581 _3037_ _3318_ VGND VGND VPWR VPWR _3328_ sky130_fd_sc_hd__mux2_1
XFILLER_0_49_128 VGND VGND VPWR VPWR sky130_fd_sc_hd__fill_2
XFILLER_0_58_651 VGND VGND VPWR VPWR sky130_fd_sc_hd__decap_4
XTAP_TAPCELL_ROW_18_462 VGND VPWR sky130_fd_sc_hd__tapvpwrvgnd_1
XTAP_TAPCELL_ROW_18_473 VGND VPWR sky130_fd_sc_hd__tapvpwrvgnd_1
XFILLER_0_73_610 VGND VGND VPWR VPWR sky130_fd_sc_hd__decap_6
X_6753_ _3098_ net1120 _3281_ VGND VGND VPWR VPWR _3291_ sky130_fd_sc_hd__mux2_1
X_5704_ _2049_ _1830_ VGND VGND VPWR VPWR _2489_ sky130_fd_sc_hd__nand2_2
X_9472_ clknet_leaf_61_CLK _0705_ VGND VGND VPWR VPWR RF.reg_arr\[11\]\[2\] sky130_fd_sc_hd__dfxtp_1
XFILLER_0_45_323 VGND VGND VPWR VPWR sky130_fd_sc_hd__fill_1
XFILLER_0_45_345 VPWR VGND VPWR VGND sky130_ef_sc_hd__decap_12
X_6684_ _3253_ VGND VGND VPWR VPWR _0946_ sky130_fd_sc_hd__clkbuf_1
XFILLER_0_115_222 VGND VGND VPWR VPWR sky130_fd_sc_hd__fill_2
X_5635_ _2276_ _2237_ _2419_ _2421_ VGND VGND VPWR VPWR _2422_ sky130_fd_sc_hd__o211a_1
X_8423_ net527 _3426_ _4185_ VGND VGND VPWR VPWR _4194_ sky130_fd_sc_hd__mux2_1
XFILLER_0_72_197 VGND VGND VPWR VPWR sky130_fd_sc_hd__fill_1
X_5566_ net97 _1717_ VGND VGND VPWR VPWR _2354_ sky130_fd_sc_hd__and2_1
Xhold110 RF.reg_arr\[4\]\[1\] VGND VGND VPWR VPWR net192 sky130_fd_sc_hd__dlygate4sd3_1
X_8354_ _4157_ VGND VGND VPWR VPWR _0688_ sky130_fd_sc_hd__clkbuf_1
Xhold143 RF.reg_arr\[17\]\[24\] VGND VGND VPWR VPWR net225 sky130_fd_sc_hd__dlygate4sd3_1
Xhold132 RF.reg_arr\[2\]\[24\] VGND VGND VPWR VPWR net214 sky130_fd_sc_hd__dlygate4sd3_1
X_4517_ RF.reg_arr\[8\]\[29\] RF.reg_arr\[9\]\[29\] RF.reg_arr\[10\]\[29\] RF.reg_arr\[11\]\[29\]
+ _1303_ _1305_ VGND VGND VPWR VPWR _1306_ sky130_fd_sc_hd__mux4_1
Xhold121 RF.reg_arr\[9\]\[2\] VGND VGND VPWR VPWR net203 sky130_fd_sc_hd__dlygate4sd3_1
X_8285_ net446 _3424_ _4113_ VGND VGND VPWR VPWR _4121_ sky130_fd_sc_hd__mux2_1
X_7305_ _3600_ VGND VGND VPWR VPWR _0196_ sky130_fd_sc_hd__clkbuf_1
X_5497_ _2284_ _2285_ net3 VGND VGND VPWR VPWR _2286_ sky130_fd_sc_hd__mux2_1
Xhold165 RF.reg_arr\[6\]\[24\] VGND VGND VPWR VPWR net247 sky130_fd_sc_hd__dlygate4sd3_1
Xhold176 RF.reg_arr\[17\]\[14\] VGND VGND VPWR VPWR net258 sky130_fd_sc_hd__dlygate4sd3_1
X_7236_ _3069_ net719 _3558_ VGND VGND VPWR VPWR _3564_ sky130_fd_sc_hd__mux2_1
X_4448_ _1235_ _1236_ _1033_ VGND VGND VPWR VPWR _1237_ sky130_fd_sc_hd__mux2_1
Xhold154 RF.reg_arr\[9\]\[13\] VGND VGND VPWR VPWR net236 sky130_fd_sc_hd__dlygate4sd3_1
Xhold187 RF.reg_arr\[11\]\[23\] VGND VGND VPWR VPWR net269 sky130_fd_sc_hd__dlygate4sd3_1
XFILLER_0_0_180 VGND VGND VPWR VPWR sky130_fd_sc_hd__fill_2
Xhold198 RF.reg_arr\[9\]\[18\] VGND VGND VPWR VPWR net280 sky130_fd_sc_hd__dlygate4sd3_1
X_4379_ _1121_ VGND VGND VPWR VPWR _1168_ sky130_fd_sc_hd__clkbuf_8
X_7167_ net649 _3399_ _3521_ VGND VGND VPWR VPWR _3527_ sky130_fd_sc_hd__mux2_1
X_6118_ _2568_ _2876_ _2881_ VGND VGND VPWR VPWR net66 sky130_fd_sc_hd__o21ai_1
X_7098_ _3490_ VGND VGND VPWR VPWR _0099_ sky130_fd_sc_hd__clkbuf_1
X_6049_ _1926_ _2801_ VGND VGND VPWR VPWR _2816_ sky130_fd_sc_hd__and2b_1
XFILLER_0_95_223 VGND VGND VPWR VPWR sky130_fd_sc_hd__fill_1
XFILLER_0_48_150 VGND VGND VPWR VPWR sky130_fd_sc_hd__decap_6
XFILLER_0_76_481 VGND VGND VPWR VPWR sky130_fd_sc_hd__fill_2
XFILLER_0_48_194 VGND VGND VPWR VPWR sky130_fd_sc_hd__fill_2
XFILLER_0_8_280 VGND VGND VPWR VPWR sky130_fd_sc_hd__fill_1
XTAP_TAPCELL_ROW_114_1615 VGND VPWR sky130_fd_sc_hd__tapvpwrvgnd_1
XFILLER_0_115_69 VPWR VGND VPWR VGND sky130_ef_sc_hd__decap_12
XFILLER_0_74_429 VGND VGND VPWR VPWR sky130_fd_sc_hd__decap_4
XTAP_TAPCELL_ROW_15_432 VGND VPWR sky130_fd_sc_hd__tapvpwrvgnd_1
XFILLER_0_55_610 VGND VGND VPWR VPWR sky130_fd_sc_hd__decap_3
XTAP_TAPCELL_ROW_43_763 VGND VPWR sky130_fd_sc_hd__tapvpwrvgnd_1
XFILLER_0_40_22 VGND VGND VPWR VPWR sky130_fd_sc_hd__decap_6
XFILLER_0_40_44 VGND VGND VPWR VPWR sky130_fd_sc_hd__fill_2
XFILLER_0_54_164 VGND VGND VPWR VPWR sky130_fd_sc_hd__fill_1
XFILLER_0_42_337 VGND VGND VPWR VPWR sky130_fd_sc_hd__decap_4
XFILLER_0_54_186 VGND VGND VPWR VPWR sky130_fd_sc_hd__fill_2
XFILLER_0_112_214 VGND VGND VPWR VPWR sky130_fd_sc_hd__fill_2
X_5420_ RF.reg_arr\[12\]\[4\] RF.reg_arr\[13\]\[4\] RF.reg_arr\[14\]\[4\] RF.reg_arr\[15\]\[4\]
+ _1589_ _1834_ VGND VGND VPWR VPWR _2209_ sky130_fd_sc_hd__mux4_1
XFILLER_0_23_573 VGND VGND VPWR VPWR sky130_fd_sc_hd__fill_2
X_5351_ _1642_ _2131_ _2139_ VGND VGND VPWR VPWR _2140_ sky130_fd_sc_hd__o21ai_4
X_4302_ _1067_ _1090_ VGND VGND VPWR VPWR _1091_ sky130_fd_sc_hd__or2_1
XFILLER_0_2_467 VGND VGND VPWR VPWR sky130_fd_sc_hd__fill_2
X_8070_ _4007_ VGND VGND VPWR VPWR _0554_ sky130_fd_sc_hd__clkbuf_1
X_5282_ RF.reg_arr\[16\]\[11\] RF.reg_arr\[17\]\[11\] RF.reg_arr\[18\]\[11\] RF.reg_arr\[19\]\[11\]
+ _1591_ _1878_ VGND VGND VPWR VPWR _2071_ sky130_fd_sc_hd__mux4_1
X_7021_ net565 _3387_ _3449_ VGND VGND VPWR VPWR _3450_ sky130_fd_sc_hd__mux2_1
XFILLER_0_57_7 VGND VGND VPWR VPWR sky130_fd_sc_hd__fill_2
X_8972_ clknet_leaf_101_CLK _0205_ VGND VGND VPWR VPWR RF.reg_arr\[31\]\[14\] sky130_fd_sc_hd__dfxtp_1
X_7923_ _3929_ VGND VGND VPWR VPWR _0485_ sky130_fd_sc_hd__clkbuf_1
XFILLER_0_77_234 VGND VGND VPWR VPWR sky130_fd_sc_hd__decap_3
X_7854_ _3071_ net974 _3886_ VGND VGND VPWR VPWR _3893_ sky130_fd_sc_hd__mux2_1
X_7785_ _3071_ net1056 _3849_ VGND VGND VPWR VPWR _3856_ sky130_fd_sc_hd__mux2_1
X_6805_ _3319_ VGND VGND VPWR VPWR _1001_ sky130_fd_sc_hd__clkbuf_1
X_4997_ RF.reg_arr\[0\]\[24\] RF.reg_arr\[1\]\[24\] RF.reg_arr\[2\]\[24\] RF.reg_arr\[3\]\[24\]
+ _1626_ _1628_ VGND VGND VPWR VPWR _1786_ sky130_fd_sc_hd__mux4_1
X_9524_ clknet_leaf_43_CLK _0757_ VGND VGND VPWR VPWR RF.reg_arr\[10\]\[22\] sky130_fd_sc_hd__dfxtp_1
X_6736_ _3282_ VGND VGND VPWR VPWR _0969_ sky130_fd_sc_hd__clkbuf_1
XFILLER_0_73_473 VGND VGND VPWR VPWR sky130_fd_sc_hd__decap_6
X_9455_ clknet_leaf_103_CLK _0688_ VGND VGND VPWR VPWR RF.reg_arr\[12\]\[17\] sky130_fd_sc_hd__dfxtp_1
XFILLER_0_33_337 VGND VGND VPWR VPWR sky130_fd_sc_hd__fill_1
XFILLER_0_45_164 VGND VGND VPWR VPWR sky130_fd_sc_hd__decap_4
X_6667_ _3082_ net1107 _3243_ VGND VGND VPWR VPWR _3245_ sky130_fd_sc_hd__mux2_1
X_5618_ _1114_ _2235_ VGND VGND VPWR VPWR _2406_ sky130_fd_sc_hd__nand2_1
X_9386_ clknet_leaf_98_CLK _0619_ VGND VGND VPWR VPWR RF.reg_arr\[13\]\[12\] sky130_fd_sc_hd__dfxtp_1
X_6598_ _3208_ VGND VGND VPWR VPWR _0905_ sky130_fd_sc_hd__clkbuf_1
X_8406_ _4173_ VGND VGND VPWR VPWR _4185_ sky130_fd_sc_hd__buf_4
XFILLER_0_103_225 VGND VGND VPWR VPWR sky130_fd_sc_hd__decap_3
X_5549_ _1115_ _2044_ VGND VGND VPWR VPWR _2338_ sky130_fd_sc_hd__and2_1
XFILLER_0_60_178 VGND VGND VPWR VPWR sky130_fd_sc_hd__fill_2
XFILLER_0_60_167 VGND VGND VPWR VPWR sky130_fd_sc_hd__fill_2
XFILLER_0_5_294 VGND VGND VPWR VPWR sky130_fd_sc_hd__fill_1
XFILLER_0_41_370 VGND VGND VPWR VPWR sky130_fd_sc_hd__fill_2
X_8337_ _4148_ VGND VGND VPWR VPWR _0680_ sky130_fd_sc_hd__clkbuf_1
X_8268_ net576 _3407_ _4102_ VGND VGND VPWR VPWR _4112_ sky130_fd_sc_hd__mux2_1
X_7219_ net468 _3383_ _3520_ VGND VGND VPWR VPWR _3554_ sky130_fd_sc_hd__mux2_1
X_8199_ _4075_ VGND VGND VPWR VPWR _0615_ sky130_fd_sc_hd__clkbuf_1
XFILLER_0_96_554 VGND VGND VPWR VPWR sky130_fd_sc_hd__fill_1
XTAP_TAPCELL_ROW_64_1024 VGND VPWR sky130_fd_sc_hd__tapvpwrvgnd_1
XFILLER_0_37_665 VGND VGND VPWR VPWR sky130_fd_sc_hd__decap_6
XTAP_TAPCELL_ROW_40_733 VGND VPWR sky130_fd_sc_hd__tapvpwrvgnd_1
XFILLER_0_24_359 VGND VGND VPWR VPWR sky130_fd_sc_hd__decap_4
XTAP_TAPCELL_ROW_20_490 VGND VPWR sky130_fd_sc_hd__tapvpwrvgnd_1
XFILLER_0_20_510 VGND VGND VPWR VPWR sky130_fd_sc_hd__fill_1
XFILLER_0_86_29 VGND VGND VPWR VPWR sky130_fd_sc_hd__decap_6
XTAP_TAPCELL_ROW_75_1153 VGND VPWR sky130_fd_sc_hd__tapvpwrvgnd_1
XFILLER_0_60_690 VGND VGND VPWR VPWR sky130_fd_sc_hd__fill_2
XFILLER_0_20_587 VGND VGND VPWR VPWR sky130_fd_sc_hd__fill_1
XFILLER_0_20_598 VGND VGND VPWR VPWR sky130_fd_sc_hd__fill_2
XTAP_TAPCELL_ROW_48_822 VGND VPWR sky130_fd_sc_hd__tapvpwrvgnd_1
XTAP_TAPCELL_ROW_48_833 VGND VPWR sky130_fd_sc_hd__tapvpwrvgnd_1
X_4920_ RF.reg_arr\[12\]\[28\] RF.reg_arr\[13\]\[28\] RF.reg_arr\[14\]\[28\] RF.reg_arr\[15\]\[28\]
+ _1678_ _1684_ VGND VGND VPWR VPWR _1709_ sky130_fd_sc_hd__mux4_1
XFILLER_0_87_554 VGND VGND VPWR VPWR sky130_fd_sc_hd__decap_6
XTAP_TAPCELL_ROW_86_1282 VGND VPWR sky130_fd_sc_hd__tapvpwrvgnd_1
X_4851_ _1638_ _1639_ _1614_ VGND VGND VPWR VPWR _1640_ sky130_fd_sc_hd__mux2_1
XFILLER_0_19_109 VGND VGND VPWR VPWR sky130_fd_sc_hd__decap_3
XTAP_TAPCELL_ROW_28_590 VGND VPWR sky130_fd_sc_hd__tapvpwrvgnd_1
XFILLER_0_74_237 VGND VGND VPWR VPWR sky130_fd_sc_hd__fill_2
XFILLER_0_74_226 VGND VGND VPWR VPWR sky130_fd_sc_hd__fill_2
XFILLER_0_28_621 VGND VGND VPWR VPWR sky130_fd_sc_hd__decap_3
X_4782_ _1567_ _1570_ _1284_ VGND VGND VPWR VPWR _1571_ sky130_fd_sc_hd__mux2_1
XPHY_EDGE_ROW_72_Left_189 VGND VGND VPWR VPWR sky130_fd_sc_hd__decap_3
X_7570_ _3742_ VGND VGND VPWR VPWR _0319_ sky130_fd_sc_hd__clkbuf_1
XFILLER_0_51_87 VGND VGND VPWR VPWR sky130_fd_sc_hd__fill_2
X_6521_ _3167_ VGND VGND VPWR VPWR _0869_ sky130_fd_sc_hd__clkbuf_1
XFILLER_0_7_559 VGND VGND VPWR VPWR sky130_fd_sc_hd__fill_1
XFILLER_0_43_613 VGND VGND VPWR VPWR sky130_fd_sc_hd__decap_3
X_9240_ clknet_leaf_35_CLK _0473_ VGND VGND VPWR VPWR RF.reg_arr\[22\]\[26\] sky130_fd_sc_hd__dfxtp_1
X_6452_ net115 VGND VGND VPWR VPWR _3131_ sky130_fd_sc_hd__clkbuf_1
Xclkload52 clknet_leaf_41_CLK VGND VGND VPWR VPWR clkload52/Y sky130_fd_sc_hd__bufinv_16
X_9171_ clknet_leaf_45_CLK _0404_ VGND VGND VPWR VPWR RF.reg_arr\[9\]\[21\] sky130_fd_sc_hd__dfxtp_1
Xclkload41 clknet_leaf_14_CLK VGND VGND VPWR VPWR clkload41/Y sky130_fd_sc_hd__bufinv_16
Xclkload30 clknet_leaf_105_CLK VGND VGND VPWR VPWR clkload30/Y sky130_fd_sc_hd__clkinvlp_4
XFILLER_0_30_307 VGND VGND VPWR VPWR sky130_fd_sc_hd__fill_1
X_5403_ _1642_ _2183_ _2191_ VGND VGND VPWR VPWR _2192_ sky130_fd_sc_hd__o21a_2
Xclkload85 clknet_leaf_47_CLK VGND VGND VPWR VPWR clkload85/Y sky130_fd_sc_hd__clkinv_4
Xclkload96 clknet_leaf_56_CLK VGND VGND VPWR VPWR clkload96/Y sky130_fd_sc_hd__clkinvlp_2
Xclkload74 clknet_leaf_76_CLK VGND VGND VPWR VPWR clkload74/Y sky130_fd_sc_hd__inv_6
XFILLER_0_11_521 VGND VGND VPWR VPWR sky130_fd_sc_hd__fill_1
X_8122_ net418 _3397_ _4030_ VGND VGND VPWR VPWR _4035_ sky130_fd_sc_hd__mux2_1
XFILLER_0_2_253 VGND VGND VPWR VPWR sky130_fd_sc_hd__decap_3
Xclkload63 clknet_leaf_93_CLK VGND VGND VPWR VPWR clkload63/Y sky130_fd_sc_hd__clkinv_4
X_6383_ _3086_ net1114 _3080_ VGND VGND VPWR VPWR _3087_ sky130_fd_sc_hd__mux2_1
X_5334_ _1792_ _2104_ _2122_ VGND VGND VPWR VPWR _2123_ sky130_fd_sc_hd__o21ba_1
XPHY_EDGE_ROW_81_Left_198 VGND VGND VPWR VPWR sky130_fd_sc_hd__decap_3
X_5265_ _2052_ _2053_ _1942_ VGND VGND VPWR VPWR _2054_ sky130_fd_sc_hd__mux2_1
X_8053_ _3998_ VGND VGND VPWR VPWR _0546_ sky130_fd_sc_hd__clkbuf_1
X_7004_ net376 _3373_ _3431_ VGND VGND VPWR VPWR _3440_ sky130_fd_sc_hd__mux2_1
X_5196_ RF.reg_arr\[20\]\[17\] RF.reg_arr\[21\]\[17\] RF.reg_arr\[22\]\[17\] RF.reg_arr\[23\]\[17\]
+ _1883_ _1885_ VGND VGND VPWR VPWR _1985_ sky130_fd_sc_hd__mux4_1
XFILLER_0_48_3 VGND VGND VPWR VPWR sky130_fd_sc_hd__fill_2
X_8955_ clknet_leaf_30_CLK _0188_ VGND VGND VPWR VPWR RF.reg_arr\[29\]\[29\] sky130_fd_sc_hd__dfxtp_1
XFILLER_0_92_50 VGND VGND VPWR VPWR sky130_fd_sc_hd__decap_3
X_8886_ clknet_leaf_54_CLK _0119_ VGND VGND VPWR VPWR RF.reg_arr\[3\]\[24\] sky130_fd_sc_hd__dfxtp_1
X_7906_ _3123_ net717 _3885_ VGND VGND VPWR VPWR _3920_ sky130_fd_sc_hd__mux2_1
XFILLER_0_78_598 VGND VGND VPWR VPWR sky130_fd_sc_hd__fill_1
X_7837_ _3123_ net1046 _3848_ VGND VGND VPWR VPWR _3883_ sky130_fd_sc_hd__mux2_1
X_7768_ _3846_ VGND VGND VPWR VPWR _0413_ sky130_fd_sc_hd__clkbuf_1
XFILLER_0_19_654 VGND VGND VPWR VPWR sky130_fd_sc_hd__fill_1
Xclkload2 clknet_3_2__leaf_CLK VGND VGND VPWR VPWR clkload2/Y sky130_fd_sc_hd__inv_8
XFILLER_0_73_281 VGND VGND VPWR VPWR sky130_fd_sc_hd__decap_4
X_7699_ _3121_ net1086 _3776_ VGND VGND VPWR VPWR _3810_ sky130_fd_sc_hd__mux2_1
X_9507_ clknet_leaf_80_CLK _0740_ VGND VGND VPWR VPWR RF.reg_arr\[10\]\[5\] sky130_fd_sc_hd__dfxtp_1
X_6719_ _3273_ VGND VGND VPWR VPWR _0961_ sky130_fd_sc_hd__clkbuf_1
X_9438_ clknet_leaf_71_CLK _0671_ VGND VGND VPWR VPWR RF.reg_arr\[12\]\[0\] sky130_fd_sc_hd__dfxtp_1
XFILLER_0_6_592 VGND VGND VPWR VPWR sky130_fd_sc_hd__fill_1
XFILLER_0_104_589 VGND VGND VPWR VPWR sky130_fd_sc_hd__decap_8
XFILLER_0_104_567 VGND VGND VPWR VPWR sky130_fd_sc_hd__decap_6
X_9369_ clknet_leaf_39_CLK _0602_ VGND VGND VPWR VPWR RF.reg_arr\[18\]\[27\] sky130_fd_sc_hd__dfxtp_1
XFILLER_0_88_307 VGND VGND VPWR VPWR sky130_fd_sc_hd__fill_1
XTAP_TAPCELL_ROW_70_1094 VGND VPWR sky130_fd_sc_hd__tapvpwrvgnd_1
XTAP_TAPCELL_ROW_109_1558 VGND VPWR sky130_fd_sc_hd__tapvpwrvgnd_1
XFILLER_0_84_513 VPWR VGND VPWR VGND sky130_ef_sc_hd__decap_12
XFILLER_0_112_15 VPWR VGND VPWR VGND sky130_ef_sc_hd__decap_12
XTAP_TAPCELL_ROW_53_891 VGND VPWR sky130_fd_sc_hd__tapvpwrvgnd_1
XFILLER_0_52_421 VGND VGND VPWR VPWR sky130_fd_sc_hd__decap_3
XFILLER_0_114_309 VGND VGND VPWR VPWR sky130_fd_sc_hd__decap_4
Xhold709 RF.reg_arr\[14\]\[24\] VGND VGND VPWR VPWR net791 sky130_fd_sc_hd__dlygate4sd3_1
XFILLER_0_108_6 VPWR VGND VPWR VGND sky130_ef_sc_hd__decap_12
XFILLER_0_97_28 VGND VGND VPWR VPWR sky130_fd_sc_hd__decap_3
XFILLER_0_12_329 VGND VGND VPWR VPWR sky130_fd_sc_hd__decap_4
XFILLER_0_33_690 VGND VGND VPWR VPWR sky130_fd_sc_hd__fill_2
XFILLER_0_40_638 VGND VGND VPWR VPWR sky130_fd_sc_hd__fill_1
X_5050_ RF.reg_arr\[20\]\[22\] RF.reg_arr\[21\]\[22\] RF.reg_arr\[22\]\[22\] RF.reg_arr\[23\]\[22\]
+ _1590_ _1835_ VGND VGND VPWR VPWR _1839_ sky130_fd_sc_hd__mux4_1
XTAP_TAPCELL_ROW_88_1311 VGND VPWR sky130_fd_sc_hd__tapvpwrvgnd_1
XFILLER_0_46_98 VGND VGND VPWR VPWR sky130_fd_sc_hd__fill_2
X_5952_ _1550_ net1123 _2447_ VGND VGND VPWR VPWR _2725_ sky130_fd_sc_hd__a21o_1
XFILLER_0_87_340 VGND VGND VPWR VPWR sky130_fd_sc_hd__fill_1
X_8740_ clknet_leaf_85_CLK _0997_ VGND VGND VPWR VPWR RF.reg_arr\[6\]\[6\] sky130_fd_sc_hd__dfxtp_1
X_4903_ RF.reg_arr\[4\]\[29\] RF.reg_arr\[5\]\[29\] RF.reg_arr\[6\]\[29\] RF.reg_arr\[7\]\[29\]
+ _1627_ _1629_ VGND VGND VPWR VPWR _1692_ sky130_fd_sc_hd__mux4_1
X_5883_ _2656_ _2659_ _1831_ VGND VGND VPWR VPWR _2660_ sky130_fd_sc_hd__mux2_1
X_8671_ clknet_leaf_68_CLK _0928_ VGND VGND VPWR VPWR RF.reg_arr\[15\]\[1\] sky130_fd_sc_hd__dfxtp_1
X_7622_ _3769_ VGND VGND VPWR VPWR _0344_ sky130_fd_sc_hd__clkbuf_1
X_4834_ _1622_ VGND VGND VPWR VPWR _1623_ sky130_fd_sc_hd__buf_4
X_7553_ net693 _3373_ _3727_ VGND VGND VPWR VPWR _3733_ sky130_fd_sc_hd__mux2_1
X_4765_ RF.reg_arr\[24\]\[25\] RF.reg_arr\[25\]\[25\] RF.reg_arr\[26\]\[25\] RF.reg_arr\[27\]\[25\]
+ _1450_ _1451_ VGND VGND VPWR VPWR _1554_ sky130_fd_sc_hd__mux4_1
XTAP_TAPCELL_ROW_99_1440 VGND VPWR sky130_fd_sc_hd__tapvpwrvgnd_1
X_6504_ net10 net9 VGND VGND VPWR VPWR _3157_ sky130_fd_sc_hd__or2_2
XFILLER_0_15_134 VGND VGND VPWR VPWR sky130_fd_sc_hd__decap_6
XFILLER_0_55_281 VGND VGND VPWR VPWR sky130_fd_sc_hd__decap_3
XFILLER_0_102_70 VGND VGND VPWR VPWR sky130_fd_sc_hd__fill_1
X_7484_ _3695_ VGND VGND VPWR VPWR _0280_ sky130_fd_sc_hd__clkbuf_1
XFILLER_0_70_240 VGND VGND VPWR VPWR sky130_fd_sc_hd__fill_1
X_9223_ clknet_leaf_78_CLK _0456_ VGND VGND VPWR VPWR RF.reg_arr\[22\]\[9\] sky130_fd_sc_hd__dfxtp_1
X_4696_ RF.reg_arr\[16\]\[12\] RF.reg_arr\[17\]\[12\] RF.reg_arr\[18\]\[12\] RF.reg_arr\[19\]\[12\]
+ _1051_ _1053_ VGND VGND VPWR VPWR _1485_ sky130_fd_sc_hd__mux4_1
XFILLER_0_15_178 VGND VGND VPWR VPWR sky130_fd_sc_hd__fill_1
X_6435_ _3121_ net828 _3058_ VGND VGND VPWR VPWR _3122_ sky130_fd_sc_hd__mux2_1
XFILLER_0_31_649 VGND VGND VPWR VPWR sky130_fd_sc_hd__decap_3
X_6366_ net44 VGND VGND VPWR VPWR _3075_ sky130_fd_sc_hd__clkbuf_2
X_9154_ clknet_leaf_72_CLK _0387_ VGND VGND VPWR VPWR RF.reg_arr\[9\]\[4\] sky130_fd_sc_hd__dfxtp_1
X_8105_ _4025_ VGND VGND VPWR VPWR _0571_ sky130_fd_sc_hd__clkbuf_1
XFILLER_0_101_559 VGND VGND VPWR VPWR sky130_fd_sc_hd__fill_1
X_9085_ clknet_leaf_20_CLK _0318_ VGND VGND VPWR VPWR RF.reg_arr\[28\]\[31\] sky130_fd_sc_hd__dfxtp_1
X_5317_ RF.reg_arr\[16\]\[9\] RF.reg_arr\[17\]\[9\] RF.reg_arr\[18\]\[9\] RF.reg_arr\[19\]\[9\]
+ _1623_ _1596_ VGND VGND VPWR VPWR _2106_ sky130_fd_sc_hd__mux4_1
X_8036_ _2986_ net525 _3980_ VGND VGND VPWR VPWR _3989_ sky130_fd_sc_hd__mux2_1
X_6297_ _3030_ VGND VGND VPWR VPWR _0782_ sky130_fd_sc_hd__clkbuf_1
Xhold25 RF.reg_arr\[0\]\[12\] VGND VGND VPWR VPWR net107 sky130_fd_sc_hd__dlygate4sd3_1
X_5248_ RF.reg_arr\[0\]\[0\] RF.reg_arr\[1\]\[0\] RF.reg_arr\[2\]\[0\] RF.reg_arr\[3\]\[0\]
+ _1588_ _1594_ VGND VGND VPWR VPWR _2037_ sky130_fd_sc_hd__mux4_1
Xhold47 RF.reg_arr\[0\]\[16\] VGND VGND VPWR VPWR net129 sky130_fd_sc_hd__dlygate4sd3_1
Xhold36 RF.reg_arr\[0\]\[19\] VGND VGND VPWR VPWR net118 sky130_fd_sc_hd__dlygate4sd3_1
Xhold69 RF.reg_arr\[17\]\[22\] VGND VGND VPWR VPWR net151 sky130_fd_sc_hd__dlygate4sd3_1
Xhold58 RF.reg_arr\[28\]\[11\] VGND VGND VPWR VPWR net140 sky130_fd_sc_hd__dlygate4sd3_1
X_5179_ RF.reg_arr\[16\]\[16\] RF.reg_arr\[17\]\[16\] RF.reg_arr\[18\]\[16\] RF.reg_arr\[19\]\[16\]
+ _1676_ _1682_ VGND VGND VPWR VPWR _1968_ sky130_fd_sc_hd__mux4_1
XFILLER_0_97_159 VGND VGND VPWR VPWR sky130_fd_sc_hd__decap_3
X_8938_ clknet_leaf_99_CLK _0171_ VGND VGND VPWR VPWR RF.reg_arr\[29\]\[12\] sky130_fd_sc_hd__dfxtp_1
XTAP_TAPCELL_ROW_3_288 VGND VPWR sky130_fd_sc_hd__tapvpwrvgnd_1
X_8869_ clknet_leaf_88_CLK _0102_ VGND VGND VPWR VPWR RF.reg_arr\[3\]\[7\] sky130_fd_sc_hd__dfxtp_1
XTAP_TAPCELL_ROW_104_1499 VGND VPWR sky130_fd_sc_hd__tapvpwrvgnd_1
XFILLER_0_93_365 VGND VGND VPWR VPWR sky130_fd_sc_hd__fill_2
XTAP_TAPCELL_ROW_50_850 VGND VPWR sky130_fd_sc_hd__tapvpwrvgnd_1
XFILLER_0_53_229 VGND VGND VPWR VPWR sky130_fd_sc_hd__fill_1
XFILLER_0_15_690 VGND VGND VPWR VPWR sky130_fd_sc_hd__fill_2
XFILLER_0_22_638 VGND VGND VPWR VPWR sky130_fd_sc_hd__decap_3
XTAP_TAPCELL_ROW_72_1112 VGND VPWR sky130_fd_sc_hd__tapvpwrvgnd_1
XFILLER_0_107_15 VGND VGND VPWR VPWR sky130_fd_sc_hd__decap_8
XFILLER_0_89_649 VGND VGND VPWR VPWR sky130_fd_sc_hd__fill_2
XTAP_TAPCELL_ROW_58_950 VGND VPWR sky130_fd_sc_hd__tapvpwrvgnd_1
XFILLER_0_57_513 VGND VGND VPWR VPWR sky130_fd_sc_hd__fill_1
XFILLER_0_57_502 VGND VGND VPWR VPWR sky130_fd_sc_hd__fill_2
XTAP_TAPCELL_ROW_83_1252 VGND VPWR sky130_fd_sc_hd__tapvpwrvgnd_1
XFILLER_0_115_629 VPWR VGND VPWR VGND sky130_ef_sc_hd__decap_12
XFILLER_0_106_3 VPWR VGND VPWR VGND sky130_ef_sc_hd__decap_12
X_4550_ RF.reg_arr\[12\]\[20\] RF.reg_arr\[13\]\[20\] RF.reg_arr\[14\]\[20\] RF.reg_arr\[15\]\[20\]
+ _1186_ _1188_ VGND VGND VPWR VPWR _1339_ sky130_fd_sc_hd__mux4_1
XFILLER_0_25_476 VGND VGND VPWR VPWR sky130_fd_sc_hd__decap_8
Xhold517 RF.reg_arr\[19\]\[2\] VGND VGND VPWR VPWR net599 sky130_fd_sc_hd__dlygate4sd3_1
Xhold506 RF.reg_arr\[8\]\[22\] VGND VGND VPWR VPWR net588 sky130_fd_sc_hd__dlygate4sd3_1
XFILLER_0_13_649 VGND VGND VPWR VPWR sky130_fd_sc_hd__fill_2
XFILLER_0_25_487 VGND VGND VPWR VPWR sky130_fd_sc_hd__decap_8
X_4481_ _1260_ _1025_ _1265_ _1269_ VGND VGND VPWR VPWR _1270_ sky130_fd_sc_hd__o22a_4
XFILLER_0_110_301 VGND VGND VPWR VPWR sky130_fd_sc_hd__fill_2
X_6220_ _2971_ _2976_ VGND VGND VPWR VPWR _2977_ sky130_fd_sc_hd__nor2_4
Xhold528 RF.reg_arr\[28\]\[6\] VGND VGND VPWR VPWR net610 sky130_fd_sc_hd__dlygate4sd3_1
Xhold539 RF.reg_arr\[1\]\[10\] VGND VGND VPWR VPWR net621 sky130_fd_sc_hd__dlygate4sd3_1
X_6151_ _2568_ _2905_ _2912_ VGND VGND VPWR VPWR net68 sky130_fd_sc_hd__o21ai_1
XTAP_TAPCELL_ROW_94_1381 VGND VPWR sky130_fd_sc_hd__tapvpwrvgnd_1
XFILLER_0_21_671 VGND VGND VPWR VPWR sky130_fd_sc_hd__fill_1
X_5102_ _1644_ _1877_ _1890_ VGND VGND VPWR VPWR _1891_ sky130_fd_sc_hd__o21ai_4
XFILLER_0_0_576 VGND VGND VPWR VPWR sky130_fd_sc_hd__fill_1
X_6082_ _2051_ _2722_ _2846_ _2026_ VGND VGND VPWR VPWR _2847_ sky130_fd_sc_hd__a211o_1
X_5033_ RF.reg_arr\[0\]\[2\] RF.reg_arr\[1\]\[2\] RF.reg_arr\[2\]\[2\] RF.reg_arr\[3\]\[2\]
+ _1050_ _1052_ VGND VGND VPWR VPWR _1822_ sky130_fd_sc_hd__mux4_1
XTAP_TAPCELL_ROW_0_236 VGND VPWR sky130_fd_sc_hd__tapvpwrvgnd_1
XTAP_TAPCELL_ROW_0_247 VGND VPWR sky130_fd_sc_hd__tapvpwrvgnd_1
X_6984_ net557 _3426_ _3410_ VGND VGND VPWR VPWR _3427_ sky130_fd_sc_hd__mux2_1
X_5935_ _2051_ _2562_ _2708_ VGND VGND VPWR VPWR _2709_ sky130_fd_sc_hd__a21oi_1
X_8723_ clknet_leaf_42_CLK _0980_ VGND VGND VPWR VPWR RF.reg_arr\[14\]\[21\] sky130_fd_sc_hd__dfxtp_1
XFILLER_0_75_310 VGND VGND VPWR VPWR sky130_fd_sc_hd__fill_1
X_5866_ _1416_ net1125 net92 _2534_ VGND VGND VPWR VPWR _2643_ sky130_fd_sc_hd__nor4_4
XTAP_TAPCELL_ROW_36_688 VGND VPWR sky130_fd_sc_hd__tapvpwrvgnd_1
X_8654_ clknet_leaf_9_CLK _0911_ VGND VGND VPWR VPWR RF.reg_arr\[8\]\[16\] sky130_fd_sc_hd__dfxtp_1
X_4817_ _1601_ _1602_ _1605_ VGND VGND VPWR VPWR _1606_ sky130_fd_sc_hd__mux2_1
XFILLER_0_8_643 VGND VGND VPWR VPWR sky130_fd_sc_hd__fill_1
X_7605_ _3760_ VGND VGND VPWR VPWR _0336_ sky130_fd_sc_hd__clkbuf_1
XFILLER_0_113_91 VGND VGND VPWR VPWR sky130_fd_sc_hd__decap_4
XFILLER_0_106_618 VGND VGND VPWR VPWR sky130_fd_sc_hd__decap_4
X_5797_ _2538_ _2551_ _2550_ VGND VGND VPWR VPWR _2578_ sky130_fd_sc_hd__o21a_1
XFILLER_0_8_676 VGND VGND VPWR VPWR sky130_fd_sc_hd__decap_8
XFILLER_0_16_421 VGND VGND VPWR VPWR sky130_fd_sc_hd__fill_2
XFILLER_0_28_281 VGND VGND VPWR VPWR sky130_fd_sc_hd__fill_1
X_8585_ clknet_leaf_63_CLK _0842_ VGND VGND VPWR VPWR RF.reg_arr\[0\]\[11\] sky130_fd_sc_hd__dfxtp_1
X_4748_ RF.reg_arr\[28\]\[15\] RF.reg_arr\[29\]\[15\] RF.reg_arr\[30\]\[15\] RF.reg_arr\[31\]\[15\]
+ _1134_ _1135_ VGND VGND VPWR VPWR _1537_ sky130_fd_sc_hd__mux4_1
X_7536_ net885 _3424_ _3716_ VGND VGND VPWR VPWR _3724_ sky130_fd_sc_hd__mux2_1
X_4679_ RF.reg_arr\[24\]\[30\] RF.reg_arr\[25\]\[30\] RF.reg_arr\[26\]\[30\] RF.reg_arr\[27\]\[30\]
+ _1450_ _1451_ VGND VGND VPWR VPWR _1468_ sky130_fd_sc_hd__mux4_1
X_7467_ _3686_ VGND VGND VPWR VPWR _0272_ sky130_fd_sc_hd__clkbuf_1
XFILLER_0_16_498 VGND VGND VPWR VPWR sky130_fd_sc_hd__decap_3
X_6418_ _3110_ VGND VGND VPWR VPWR _0823_ sky130_fd_sc_hd__clkbuf_1
X_9206_ clknet_leaf_52_CLK _0439_ VGND VGND VPWR VPWR RF.reg_arr\[24\]\[24\] sky130_fd_sc_hd__dfxtp_1
XFILLER_0_98_82 VGND VGND VPWR VPWR sky130_fd_sc_hd__fill_2
XPHY_EDGE_ROW_1_Right_1 VGND VGND VPWR VPWR sky130_fd_sc_hd__decap_3
X_7398_ _3649_ VGND VGND VPWR VPWR _0240_ sky130_fd_sc_hd__clkbuf_1
X_9137_ clknet_leaf_4_CLK _0370_ VGND VGND VPWR VPWR RF.reg_arr\[30\]\[19\] sky130_fd_sc_hd__dfxtp_1
Xoutput59 net59 VGND VGND VPWR VPWR result[19] sky130_fd_sc_hd__clkbuf_4
X_6349_ _3063_ net548 _3059_ VGND VGND VPWR VPWR _3064_ sky130_fd_sc_hd__mux2_1
XFILLER_0_11_181 VGND VGND VPWR VPWR sky130_fd_sc_hd__decap_4
XTAP_TAPCELL_ROW_8_347 VGND VPWR sky130_fd_sc_hd__tapvpwrvgnd_1
X_9068_ clknet_leaf_100_CLK _0301_ VGND VGND VPWR VPWR RF.reg_arr\[28\]\[14\] sky130_fd_sc_hd__dfxtp_1
X_8019_ _3957_ VGND VGND VPWR VPWR _3980_ sky130_fd_sc_hd__clkbuf_8
XTAP_TAPCELL_ROW_106_1528 VGND VPWR sky130_fd_sc_hd__tapvpwrvgnd_1
XFILLER_0_79_671 VGND VGND VPWR VPWR sky130_fd_sc_hd__fill_1
XFILLER_0_39_557 VGND VGND VPWR VPWR sky130_fd_sc_hd__decap_3
XFILLER_0_93_151 VGND VGND VPWR VPWR sky130_fd_sc_hd__decap_3
XFILLER_0_66_387 VGND VGND VPWR VPWR sky130_fd_sc_hd__decap_4
XFILLER_0_66_365 VGND VGND VPWR VPWR sky130_fd_sc_hd__decap_4
XFILLER_0_62_560 VGND VGND VPWR VPWR sky130_fd_sc_hd__decap_3
XFILLER_0_105_673 VGND VGND VPWR VPWR sky130_fd_sc_hd__fill_1
XFILLER_0_76_107 VGND VGND VPWR VPWR sky130_fd_sc_hd__fill_2
XFILLER_0_97_490 VPWR VGND VPWR VGND sky130_ef_sc_hd__decap_12
XFILLER_0_43_55 VGND VGND VPWR VPWR sky130_fd_sc_hd__fill_1
X_5720_ _2488_ _2496_ _2446_ _2504_ VGND VGND VPWR VPWR net75 sky130_fd_sc_hd__o2bb2a_1
XFILLER_0_85_663 VGND VGND VPWR VPWR sky130_fd_sc_hd__decap_8
XTAP_TAPCELL_ROW_61_978 VGND VPWR sky130_fd_sc_hd__tapvpwrvgnd_1
XFILLER_0_17_218 VGND VGND VPWR VPWR sky130_fd_sc_hd__fill_2
XTAP_TAPCELL_ROW_33_647 VGND VPWR sky130_fd_sc_hd__tapvpwrvgnd_1
XFILLER_0_115_404 VGND VGND VPWR VPWR sky130_fd_sc_hd__fill_1
X_5651_ _1929_ _1966_ _2434_ VGND VGND VPWR VPWR _2438_ sky130_fd_sc_hd__mux2_1
XFILLER_0_84_195 VGND VGND VPWR VPWR sky130_fd_sc_hd__fill_1
XTAP_TAPCELL_ROW_61_989 VGND VPWR sky130_fd_sc_hd__tapvpwrvgnd_1
X_5582_ _1895_ _1964_ _1115_ VGND VGND VPWR VPWR _2370_ sky130_fd_sc_hd__o21ai_1
X_8370_ _2980_ net642 _4160_ VGND VGND VPWR VPWR _4166_ sky130_fd_sc_hd__mux2_1
X_4602_ _1389_ _1390_ _1075_ VGND VGND VPWR VPWR _1391_ sky130_fd_sc_hd__mux2_1
X_4533_ _1176_ VGND VGND VPWR VPWR _1322_ sky130_fd_sc_hd__clkbuf_4
XFILLER_0_25_262 VGND VGND VPWR VPWR sky130_fd_sc_hd__decap_3
XFILLER_0_25_295 VGND VGND VPWR VPWR sky130_fd_sc_hd__decap_3
X_7321_ _3086_ net755 _3605_ VGND VGND VPWR VPWR _3609_ sky130_fd_sc_hd__mux2_1
XFILLER_0_102_109 VGND VGND VPWR VPWR sky130_fd_sc_hd__fill_1
Xhold303 RF.reg_arr\[10\]\[22\] VGND VGND VPWR VPWR net385 sky130_fd_sc_hd__dlygate4sd3_1
X_7252_ _3572_ VGND VGND VPWR VPWR _0171_ sky130_fd_sc_hd__clkbuf_1
Xhold325 RF.reg_arr\[23\]\[3\] VGND VGND VPWR VPWR net407 sky130_fd_sc_hd__dlygate4sd3_1
Xhold314 RF.reg_arr\[15\]\[1\] VGND VGND VPWR VPWR net396 sky130_fd_sc_hd__dlygate4sd3_1
X_6203_ _1483_ _2953_ _2759_ VGND VGND VPWR VPWR _2961_ sky130_fd_sc_hd__a21o_1
Xhold369 RF.reg_arr\[7\]\[2\] VGND VGND VPWR VPWR net451 sky130_fd_sc_hd__dlygate4sd3_1
Xhold347 RF.reg_arr\[23\]\[15\] VGND VGND VPWR VPWR net429 sky130_fd_sc_hd__dlygate4sd3_1
Xhold336 RF.reg_arr\[18\]\[4\] VGND VGND VPWR VPWR net418 sky130_fd_sc_hd__dlygate4sd3_1
Xhold358 RF.reg_arr\[10\]\[8\] VGND VGND VPWR VPWR net440 sky130_fd_sc_hd__dlygate4sd3_1
XFILLER_0_40_287 VPWR VGND VPWR VGND sky130_ef_sc_hd__decap_12
X_4464_ _1251_ _1252_ _1033_ VGND VGND VPWR VPWR _1253_ sky130_fd_sc_hd__mux2_1
XFILLER_0_111_665 VGND VGND VPWR VPWR sky130_fd_sc_hd__fill_1
XFILLER_0_68_85 VGND VGND VPWR VPWR sky130_fd_sc_hd__decap_4
X_7183_ _3535_ VGND VGND VPWR VPWR _0139_ sky130_fd_sc_hd__clkbuf_1
X_4395_ _1178_ _1180_ _1183_ _1173_ _1159_ VGND VGND VPWR VPWR _1184_ sky130_fd_sc_hd__a221o_1
X_6134_ _2895_ _2896_ VGND VGND VPWR VPWR _2897_ sky130_fd_sc_hd__nor2_1
XFILLER_0_110_175 VGND VGND VPWR VPWR sky130_fd_sc_hd__decap_3
XTAP_TAPCELL_ROW_5_317 VGND VPWR sky130_fd_sc_hd__tapvpwrvgnd_1
XTAP_TAPCELL_ROW_5_306 VGND VPWR sky130_fd_sc_hd__tapvpwrvgnd_1
X_6065_ _2829_ _2830_ _1891_ VGND VGND VPWR VPWR _2831_ sky130_fd_sc_hd__a21boi_2
Xhold1014 RF.reg_arr\[15\]\[23\] VGND VGND VPWR VPWR net1096 sky130_fd_sc_hd__dlygate4sd3_1
Xhold1003 RF.reg_arr\[12\]\[12\] VGND VGND VPWR VPWR net1085 sky130_fd_sc_hd__dlygate4sd3_1
X_5016_ RF.reg_arr\[0\]\[25\] RF.reg_arr\[1\]\[25\] RF.reg_arr\[2\]\[25\] RF.reg_arr\[3\]\[25\]
+ _1677_ _1683_ VGND VGND VPWR VPWR _1805_ sky130_fd_sc_hd__mux4_1
XFILLER_0_84_62 VGND VGND VPWR VPWR sky130_fd_sc_hd__decap_4
Xhold1036 RF.reg_arr\[22\]\[19\] VGND VGND VPWR VPWR net1118 sky130_fd_sc_hd__dlygate4sd3_1
Xhold1025 RF.reg_arr\[15\]\[11\] VGND VGND VPWR VPWR net1107 sky130_fd_sc_hd__dlygate4sd3_1
X_6967_ _3415_ VGND VGND VPWR VPWR _0043_ sky130_fd_sc_hd__clkbuf_1
X_5918_ _2140_ _2692_ VGND VGND VPWR VPWR _2693_ sky130_fd_sc_hd__xnor2_2
X_8706_ clknet_leaf_72_CLK _0963_ VGND VGND VPWR VPWR RF.reg_arr\[14\]\[4\] sky130_fd_sc_hd__dfxtp_1
XFILLER_0_48_343 VGND VGND VPWR VPWR sky130_fd_sc_hd__decap_4
X_6898_ net507 _3044_ _3366_ VGND VGND VPWR VPWR _3369_ sky130_fd_sc_hd__mux2_1
XFILLER_0_48_365 VGND VGND VPWR VPWR sky130_fd_sc_hd__decap_6
XTAP_TAPCELL_ROW_101_1469 VGND VPWR sky130_fd_sc_hd__tapvpwrvgnd_1
XTAP_TAPCELL_ROW_101_1458 VGND VPWR sky130_fd_sc_hd__tapvpwrvgnd_1
X_5849_ _2615_ _2620_ _2627_ _2446_ VGND VGND VPWR VPWR net50 sky130_fd_sc_hd__o2bb2a_1
XFILLER_0_90_121 VGND VGND VPWR VPWR sky130_fd_sc_hd__fill_1
X_8637_ clknet_leaf_18_CLK _0894_ VGND VGND VPWR VPWR RF.reg_arr\[16\]\[31\] sky130_fd_sc_hd__dfxtp_1
X_8568_ clknet_leaf_35_CLK _0825_ VGND VGND VPWR VPWR RF.reg_arr\[23\]\[26\] sky130_fd_sc_hd__dfxtp_1
XFILLER_0_106_448 VGND VGND VPWR VPWR sky130_fd_sc_hd__fill_2
XFILLER_0_51_519 VGND VGND VPWR VPWR sky130_fd_sc_hd__decap_8
X_7519_ net728 _3407_ _3705_ VGND VGND VPWR VPWR _3715_ sky130_fd_sc_hd__mux2_1
X_8499_ _4233_ VGND VGND VPWR VPWR _0757_ sky130_fd_sc_hd__clkbuf_1
XFILLER_0_102_643 VGND VGND VPWR VPWR sky130_fd_sc_hd__fill_1
Xhold881 RF.reg_arr\[21\]\[22\] VGND VGND VPWR VPWR net963 sky130_fd_sc_hd__dlygate4sd3_1
Xhold870 RF.reg_arr\[14\]\[5\] VGND VGND VPWR VPWR net952 sky130_fd_sc_hd__dlygate4sd3_1
Xhold892 RF.reg_arr\[22\]\[6\] VGND VGND VPWR VPWR net974 sky130_fd_sc_hd__dlygate4sd3_1
XTAP_TAPCELL_ROW_112_1598 VGND VPWR sky130_fd_sc_hd__tapvpwrvgnd_1
XFILLER_0_86_438 VGND VGND VPWR VPWR sky130_fd_sc_hd__decap_8
XTAP_TAPCELL_ROW_67_1055 VGND VPWR sky130_fd_sc_hd__tapvpwrvgnd_1
XFILLER_0_104_27 VGND VGND VPWR VPWR sky130_fd_sc_hd__fill_1
XTAP_TAPCELL_ROW_80_1211 VGND VPWR sky130_fd_sc_hd__tapvpwrvgnd_1
XFILLER_0_104_38 VGND VGND VPWR VPWR sky130_fd_sc_hd__decap_3
XFILLER_0_82_611 VGND VGND VPWR VPWR sky130_fd_sc_hd__fill_1
XFILLER_0_82_633 VGND VGND VPWR VPWR sky130_fd_sc_hd__decap_4
XTAP_TAPCELL_ROW_30_606 VGND VPWR sky130_fd_sc_hd__tapvpwrvgnd_1
XTAP_TAPCELL_ROW_30_617 VGND VPWR sky130_fd_sc_hd__tapvpwrvgnd_1
XFILLER_0_109_275 VGND VGND VPWR VPWR sky130_fd_sc_hd__fill_2
XFILLER_0_112_418 VGND VGND VPWR VPWR sky130_fd_sc_hd__fill_2
XTAP_TAPCELL_ROW_10_374 VGND VPWR sky130_fd_sc_hd__tapvpwrvgnd_1
XFILLER_0_105_481 VGND VGND VPWR VPWR sky130_fd_sc_hd__fill_2
XTAP_TAPCELL_ROW_78_1184 VGND VPWR sky130_fd_sc_hd__tapvpwrvgnd_1
XTAP_TAPCELL_ROW_91_1340 VGND VPWR sky130_fd_sc_hd__tapvpwrvgnd_1
XFILLER_0_22_298 VGND VGND VPWR VPWR sky130_fd_sc_hd__fill_1
XFILLER_0_38_99 VGND VGND VPWR VPWR sky130_fd_sc_hd__decap_3
XTAP_TAPCELL_ROW_38_706 VGND VPWR sky130_fd_sc_hd__tapvpwrvgnd_1
X_7870_ _3901_ VGND VGND VPWR VPWR _0460_ sky130_fd_sc_hd__clkbuf_1
X_6821_ _3327_ VGND VGND VPWR VPWR _1009_ sky130_fd_sc_hd__clkbuf_1
XTAP_TAPCELL_ROW_18_463 VGND VPWR sky130_fd_sc_hd__tapvpwrvgnd_1
XFILLER_0_9_259 VGND VGND VPWR VPWR sky130_fd_sc_hd__fill_1
X_6752_ _3290_ VGND VGND VPWR VPWR _0977_ sky130_fd_sc_hd__clkbuf_1
X_5703_ _2485_ _2486_ _2487_ _2418_ VGND VGND VPWR VPWR _2488_ sky130_fd_sc_hd__a211o_1
X_9471_ clknet_leaf_57_CLK _0704_ VGND VGND VPWR VPWR RF.reg_arr\[11\]\[1\] sky130_fd_sc_hd__dfxtp_1
XFILLER_0_45_335 VGND VGND VPWR VPWR sky130_fd_sc_hd__fill_1
X_6683_ _3098_ net1091 _3243_ VGND VGND VPWR VPWR _3253_ sky130_fd_sc_hd__mux2_1
X_5634_ _2420_ VGND VGND VPWR VPWR _2421_ sky130_fd_sc_hd__buf_2
XFILLER_0_70_97 VGND VGND VPWR VPWR sky130_fd_sc_hd__fill_1
X_8422_ _4193_ VGND VGND VPWR VPWR _0720_ sky130_fd_sc_hd__clkbuf_1
XFILLER_0_33_508 VGND VGND VPWR VPWR sky130_fd_sc_hd__fill_1
XFILLER_0_45_357 VGND VGND VPWR VPWR sky130_fd_sc_hd__fill_2
X_8353_ _3033_ net958 _4149_ VGND VGND VPWR VPWR _4157_ sky130_fd_sc_hd__mux2_1
X_5565_ _2349_ _2352_ _2000_ VGND VGND VPWR VPWR _2353_ sky130_fd_sc_hd__mux2_1
XFILLER_0_103_429 VGND VGND VPWR VPWR sky130_fd_sc_hd__decap_6
Xhold100 RF.reg_arr\[7\]\[27\] VGND VGND VPWR VPWR net182 sky130_fd_sc_hd__dlygate4sd3_1
X_7304_ _3069_ net1050 _3594_ VGND VGND VPWR VPWR _3600_ sky130_fd_sc_hd__mux2_1
XFILLER_0_53_390 VGND VGND VPWR VPWR sky130_fd_sc_hd__fill_2
Xhold122 RF.reg_arr\[6\]\[29\] VGND VGND VPWR VPWR net204 sky130_fd_sc_hd__dlygate4sd3_1
X_4516_ _1304_ VGND VGND VPWR VPWR _1305_ sky130_fd_sc_hd__clkbuf_4
Xhold133 RF.reg_arr\[19\]\[23\] VGND VGND VPWR VPWR net215 sky130_fd_sc_hd__dlygate4sd3_1
X_8284_ _4120_ VGND VGND VPWR VPWR _0655_ sky130_fd_sc_hd__clkbuf_1
Xhold111 RF.reg_arr\[18\]\[15\] VGND VGND VPWR VPWR net193 sky130_fd_sc_hd__dlygate4sd3_1
Xhold144 RF.reg_arr\[9\]\[15\] VGND VGND VPWR VPWR net226 sky130_fd_sc_hd__dlygate4sd3_1
X_5496_ RF.reg_arr\[12\]\[3\] RF.reg_arr\[13\]\[3\] RF.reg_arr\[14\]\[3\] RF.reg_arr\[15\]\[3\]
+ _1674_ _1680_ VGND VGND VPWR VPWR _2285_ sky130_fd_sc_hd__mux4_1
Xhold166 RF.reg_arr\[19\]\[24\] VGND VGND VPWR VPWR net248 sky130_fd_sc_hd__dlygate4sd3_1
Xhold155 RF.reg_arr\[6\]\[30\] VGND VGND VPWR VPWR net237 sky130_fd_sc_hd__dlygate4sd3_1
X_7235_ _3563_ VGND VGND VPWR VPWR _0163_ sky130_fd_sc_hd__clkbuf_1
XFILLER_0_1_671 VGND VGND VPWR VPWR sky130_fd_sc_hd__fill_1
Xhold177 RF.reg_arr\[4\]\[14\] VGND VGND VPWR VPWR net259 sky130_fd_sc_hd__dlygate4sd3_1
X_4447_ RF.reg_arr\[0\]\[9\] RF.reg_arr\[1\]\[9\] RF.reg_arr\[2\]\[9\] RF.reg_arr\[3\]\[9\]
+ _1229_ _1230_ VGND VGND VPWR VPWR _1236_ sky130_fd_sc_hd__mux4_1
XFILLER_0_111_495 VGND VGND VPWR VPWR sky130_fd_sc_hd__decap_8
Xhold188 RF.reg_arr\[1\]\[26\] VGND VGND VPWR VPWR net270 sky130_fd_sc_hd__dlygate4sd3_1
Xhold199 RF.reg_arr\[16\]\[30\] VGND VGND VPWR VPWR net281 sky130_fd_sc_hd__dlygate4sd3_1
X_7166_ _3526_ VGND VGND VPWR VPWR _0131_ sky130_fd_sc_hd__clkbuf_1
X_6117_ _2362_ _2588_ _2602_ _2714_ _2880_ VGND VGND VPWR VPWR _2881_ sky130_fd_sc_hd__o221a_1
X_4378_ RF.reg_arr\[16\]\[19\] RF.reg_arr\[17\]\[19\] RF.reg_arr\[18\]\[19\] RF.reg_arr\[19\]\[19\]
+ _1164_ _1165_ VGND VGND VPWR VPWR _1167_ sky130_fd_sc_hd__mux4_1
X_7097_ net607 _3397_ _3485_ VGND VGND VPWR VPWR _3490_ sky130_fd_sc_hd__mux2_1
X_6048_ _2801_ _1926_ VGND VGND VPWR VPWR _2815_ sky130_fd_sc_hd__or2b_1
XFILLER_0_68_405 VGND VGND VPWR VPWR sky130_fd_sc_hd__decap_6
X_7999_ _3018_ net975 _3969_ VGND VGND VPWR VPWR _3970_ sky130_fd_sc_hd__mux2_1
XFILLER_0_64_688 VGND VGND VPWR VPWR sky130_fd_sc_hd__fill_1
XFILLER_0_106_234 VGND VGND VPWR VPWR sky130_fd_sc_hd__decap_4
XFILLER_0_32_530 VGND VGND VPWR VPWR sky130_fd_sc_hd__fill_2
XFILLER_0_44_390 VGND VGND VPWR VPWR sky130_fd_sc_hd__decap_6
XTAP_TAPCELL_ROW_114_1616 VGND VPWR sky130_fd_sc_hd__tapvpwrvgnd_1
XFILLER_0_102_473 VGND VGND VPWR VPWR sky130_fd_sc_hd__decap_3
XFILLER_0_99_541 VGND VGND VPWR VPWR sky130_fd_sc_hd__decap_4
XFILLER_0_115_15 VPWR VGND VPWR VGND sky130_ef_sc_hd__decap_12
XFILLER_0_99_596 VGND VGND VPWR VPWR sky130_fd_sc_hd__fill_1
XFILLER_0_59_427 VPWR VGND VPWR VGND sky130_ef_sc_hd__decap_12
XFILLER_0_59_449 VGND VGND VPWR VPWR sky130_fd_sc_hd__decap_6
XTAP_TAPCELL_ROW_15_433 VGND VPWR sky130_fd_sc_hd__tapvpwrvgnd_1
XTAP_TAPCELL_ROW_43_764 VGND VPWR sky130_fd_sc_hd__tapvpwrvgnd_1
XFILLER_0_55_633 VGND VGND VPWR VPWR sky130_fd_sc_hd__fill_1
XFILLER_0_70_603 VGND VGND VPWR VPWR sky130_fd_sc_hd__decap_3
X_5350_ _2133_ _2135_ _2138_ _1842_ _1585_ VGND VGND VPWR VPWR _2139_ sky130_fd_sc_hd__a221o_1
XFILLER_0_112_259 VGND VGND VPWR VPWR sky130_fd_sc_hd__decap_6
XFILLER_0_10_235 VPWR VGND VPWR VGND sky130_ef_sc_hd__decap_12
XFILLER_0_10_213 VGND VGND VPWR VPWR sky130_fd_sc_hd__fill_1
XFILLER_0_23_596 VGND VGND VPWR VPWR sky130_fd_sc_hd__decap_8
X_4301_ _1025_ _1078_ _1089_ VGND VGND VPWR VPWR _1090_ sky130_fd_sc_hd__o21ai_4
X_5281_ RF.reg_arr\[20\]\[11\] RF.reg_arr\[21\]\[11\] RF.reg_arr\[22\]\[11\] RF.reg_arr\[23\]\[11\]
+ _1625_ _1598_ VGND VGND VPWR VPWR _2070_ sky130_fd_sc_hd__mux4_1
X_7020_ _3448_ VGND VGND VPWR VPWR _3449_ sky130_fd_sc_hd__buf_6
X_8971_ clknet_leaf_94_CLK _0204_ VGND VGND VPWR VPWR RF.reg_arr\[31\]\[13\] sky130_fd_sc_hd__dfxtp_1
X_7922_ _3010_ net839 _3922_ VGND VGND VPWR VPWR _3929_ sky130_fd_sc_hd__mux2_1
XFILLER_0_81_41 VGND VGND VPWR VPWR sky130_fd_sc_hd__decap_6
X_7853_ _3892_ VGND VGND VPWR VPWR _0452_ sky130_fd_sc_hd__clkbuf_1
X_4996_ RF.reg_arr\[4\]\[24\] RF.reg_arr\[5\]\[24\] RF.reg_arr\[6\]\[24\] RF.reg_arr\[7\]\[24\]
+ _1626_ _1628_ VGND VGND VPWR VPWR _1785_ sky130_fd_sc_hd__mux4_1
XFILLER_0_92_205 VGND VGND VPWR VPWR sky130_fd_sc_hd__decap_6
X_7784_ _3855_ VGND VGND VPWR VPWR _0420_ sky130_fd_sc_hd__clkbuf_1
X_6804_ net363 _3018_ _3318_ VGND VGND VPWR VPWR _3319_ sky130_fd_sc_hd__mux2_1
X_9523_ clknet_leaf_42_CLK _0756_ VGND VGND VPWR VPWR RF.reg_arr\[10\]\[21\] sky130_fd_sc_hd__dfxtp_1
X_6735_ _3079_ net1061 _3281_ VGND VGND VPWR VPWR _3282_ sky130_fd_sc_hd__mux2_1
XFILLER_0_73_463 VGND VGND VPWR VPWR sky130_fd_sc_hd__fill_1
X_9454_ clknet_leaf_9_CLK _0687_ VGND VGND VPWR VPWR RF.reg_arr\[12\]\[16\] sky130_fd_sc_hd__dfxtp_1
XFILLER_0_45_187 VGND VGND VPWR VPWR sky130_fd_sc_hd__fill_2
X_6666_ _3244_ VGND VGND VPWR VPWR _0937_ sky130_fd_sc_hd__clkbuf_1
X_5617_ _1756_ _2272_ VGND VGND VPWR VPWR _2405_ sky130_fd_sc_hd__nand2_1
XFILLER_0_45_198 VGND VGND VPWR VPWR sky130_fd_sc_hd__decap_4
X_9385_ clknet_leaf_91_CLK _0618_ VGND VGND VPWR VPWR RF.reg_arr\[13\]\[11\] sky130_fd_sc_hd__dfxtp_1
X_6597_ net448 _3018_ _3207_ VGND VGND VPWR VPWR _3208_ sky130_fd_sc_hd__mux2_1
X_8405_ _4184_ VGND VGND VPWR VPWR _0712_ sky130_fd_sc_hd__clkbuf_1
X_5548_ _1113_ _2044_ VGND VGND VPWR VPWR _2337_ sky130_fd_sc_hd__nor2_1
XFILLER_0_14_563 VGND VGND VPWR VPWR sky130_fd_sc_hd__fill_1
X_8336_ _3016_ net1037 _4138_ VGND VGND VPWR VPWR _4148_ sky130_fd_sc_hd__mux2_1
X_8267_ _4111_ VGND VGND VPWR VPWR _0647_ sky130_fd_sc_hd__clkbuf_1
XFILLER_0_111_281 VGND VGND VPWR VPWR sky130_fd_sc_hd__fill_2
X_7218_ _3553_ VGND VGND VPWR VPWR _0156_ sky130_fd_sc_hd__clkbuf_1
X_5479_ RF.reg_arr\[0\]\[6\] RF.reg_arr\[1\]\[6\] RF.reg_arr\[2\]\[6\] RF.reg_arr\[3\]\[6\]
+ _1624_ _1597_ VGND VGND VPWR VPWR _2268_ sky130_fd_sc_hd__mux4_1
X_8198_ _3014_ net940 _4066_ VGND VGND VPWR VPWR _4075_ sky130_fd_sc_hd__mux2_1
X_7149_ net161 _3381_ _3507_ VGND VGND VPWR VPWR _3517_ sky130_fd_sc_hd__mux2_1
XPHY_EDGE_ROW_100_Left_217 VGND VGND VPWR VPWR sky130_fd_sc_hd__decap_3
XFILLER_0_68_235 VGND VGND VPWR VPWR sky130_fd_sc_hd__fill_1
XTAP_TAPCELL_ROW_64_1014 VGND VPWR sky130_fd_sc_hd__tapvpwrvgnd_1
XFILLER_0_96_566 VGND VGND VPWR VPWR sky130_fd_sc_hd__decap_3
XTAP_TAPCELL_ROW_64_1025 VGND VPWR sky130_fd_sc_hd__tapvpwrvgnd_1
XFILLER_0_37_655 VGND VGND VPWR VPWR sky130_fd_sc_hd__fill_1
XTAP_TAPCELL_ROW_40_734 VGND VPWR sky130_fd_sc_hd__tapvpwrvgnd_1
XFILLER_0_64_474 VGND VGND VPWR VPWR sky130_fd_sc_hd__fill_2
XFILLER_0_51_113 VGND VGND VPWR VPWR sky130_fd_sc_hd__fill_1
XFILLER_0_10_15 VGND VGND VPWR VPWR sky130_fd_sc_hd__decap_8
XFILLER_0_17_390 VGND VGND VPWR VPWR sky130_fd_sc_hd__fill_2
XTAP_TAPCELL_ROW_20_491 VGND VPWR sky130_fd_sc_hd__tapvpwrvgnd_1
XTAP_TAPCELL_ROW_75_1154 VGND VPWR sky130_fd_sc_hd__tapvpwrvgnd_1
XFILLER_0_19_35 VPWR VGND VPWR VGND sky130_ef_sc_hd__decap_12
XFILLER_0_19_57 VGND VGND VPWR VPWR sky130_fd_sc_hd__fill_2
XFILLER_0_19_68 VGND VGND VPWR VPWR sky130_fd_sc_hd__fill_1
XFILLER_0_35_34 VGND VGND VPWR VPWR sky130_fd_sc_hd__fill_1
XTAP_TAPCELL_ROW_48_823 VGND VPWR sky130_fd_sc_hd__tapvpwrvgnd_1
XFILLER_0_99_393 VGND VGND VPWR VPWR sky130_fd_sc_hd__decap_3
X_4850_ RF.reg_arr\[0\]\[31\] RF.reg_arr\[1\]\[31\] RF.reg_arr\[2\]\[31\] RF.reg_arr\[3\]\[31\]
+ _1627_ _1629_ VGND VGND VPWR VPWR _1639_ sky130_fd_sc_hd__mux4_1
XTAP_TAPCELL_ROW_86_1283 VGND VPWR sky130_fd_sc_hd__tapvpwrvgnd_1
XTAP_TAPCELL_ROW_28_591 VGND VPWR sky130_fd_sc_hd__tapvpwrvgnd_1
XFILLER_0_7_505 VGND VGND VPWR VPWR sky130_fd_sc_hd__decap_4
X_4781_ _1568_ _1569_ _1168_ VGND VGND VPWR VPWR _1570_ sky130_fd_sc_hd__mux2_1
X_6520_ net698 _3010_ _3160_ VGND VGND VPWR VPWR _3167_ sky130_fd_sc_hd__mux2_1
XFILLER_0_55_452 VGND VGND VPWR VPWR sky130_fd_sc_hd__decap_8
X_6451_ _3130_ VGND VGND VPWR VPWR _0836_ sky130_fd_sc_hd__clkbuf_1
Xclkload20 clknet_leaf_10_CLK VGND VGND VPWR VPWR clkload20/Y sky130_fd_sc_hd__clkinv_1
Xclkload53 clknet_leaf_42_CLK VGND VGND VPWR VPWR clkload53/X sky130_fd_sc_hd__clkbuf_4
Xclkload31 clknet_leaf_17_CLK VGND VGND VPWR VPWR clkload31/Y sky130_fd_sc_hd__clkinv_4
X_9170_ clknet_leaf_14_CLK _0403_ VGND VGND VPWR VPWR RF.reg_arr\[9\]\[20\] sky130_fd_sc_hd__dfxtp_1
Xclkload42 clknet_leaf_15_CLK VGND VGND VPWR VPWR clkload42/Y sky130_fd_sc_hd__clkinv_1
XFILLER_0_30_319 VGND VGND VPWR VPWR sky130_fd_sc_hd__decap_4
X_6382_ net18 VGND VGND VPWR VPWR _3086_ sky130_fd_sc_hd__clkbuf_2
X_5402_ _2185_ _2187_ _2190_ _1617_ net5 VGND VGND VPWR VPWR _2191_ sky130_fd_sc_hd__a221o_1
Xclkload86 clknet_leaf_49_CLK VGND VGND VPWR VPWR clkload86/Y sky130_fd_sc_hd__clkinv_4
X_5333_ _1648_ _2121_ VGND VGND VPWR VPWR _2122_ sky130_fd_sc_hd__nor2_1
Xclkload75 clknet_leaf_77_CLK VGND VGND VPWR VPWR clkload75/Y sky130_fd_sc_hd__clkinvlp_4
XFILLER_0_2_265 VGND VGND VPWR VPWR sky130_fd_sc_hd__decap_4
Xclkload64 clknet_leaf_96_CLK VGND VGND VPWR VPWR clkload64/Y sky130_fd_sc_hd__clkinv_4
X_8121_ _4034_ VGND VGND VPWR VPWR _0578_ sky130_fd_sc_hd__clkbuf_1
Xclkload97 clknet_leaf_57_CLK VGND VGND VPWR VPWR clkload97/Y sky130_fd_sc_hd__clkinv_4
X_8052_ _3004_ net985 _3994_ VGND VGND VPWR VPWR _3998_ sky130_fd_sc_hd__mux2_1
X_5264_ RF.reg_arr\[16\]\[10\] RF.reg_arr\[17\]\[10\] RF.reg_arr\[18\]\[10\] RF.reg_arr\[19\]\[10\]
+ _1947_ _1948_ VGND VGND VPWR VPWR _2053_ sky130_fd_sc_hd__mux4_1
X_7003_ _3439_ VGND VGND VPWR VPWR _0055_ sky130_fd_sc_hd__clkbuf_1
X_5195_ _1982_ _1983_ _1604_ VGND VGND VPWR VPWR _1984_ sky130_fd_sc_hd__mux2_1
X_8954_ clknet_leaf_29_CLK _0187_ VGND VGND VPWR VPWR RF.reg_arr\[29\]\[28\] sky130_fd_sc_hd__dfxtp_1
X_8885_ clknet_leaf_42_CLK _0118_ VGND VGND VPWR VPWR RF.reg_arr\[3\]\[23\] sky130_fd_sc_hd__dfxtp_1
X_7905_ _3919_ VGND VGND VPWR VPWR _0477_ sky130_fd_sc_hd__clkbuf_1
X_7836_ _3882_ VGND VGND VPWR VPWR _0445_ sky130_fd_sc_hd__clkbuf_1
XFILLER_0_108_307 VGND VGND VPWR VPWR sky130_fd_sc_hd__fill_1
XFILLER_0_19_633 VGND VGND VPWR VPWR sky130_fd_sc_hd__fill_1
XFILLER_0_108_318 VGND VGND VPWR VPWR sky130_fd_sc_hd__decap_4
X_4979_ RF.reg_arr\[12\]\[27\] RF.reg_arr\[13\]\[27\] RF.reg_arr\[14\]\[27\] RF.reg_arr\[15\]\[27\]
+ _1626_ _1628_ VGND VGND VPWR VPWR _1768_ sky130_fd_sc_hd__mux4_1
X_7767_ net155 _3383_ _3812_ VGND VGND VPWR VPWR _3846_ sky130_fd_sc_hd__mux2_1
X_7698_ _3809_ VGND VGND VPWR VPWR _0380_ sky130_fd_sc_hd__clkbuf_1
XFILLER_0_18_154 VGND VGND VPWR VPWR sky130_fd_sc_hd__decap_3
Xclkload3 clknet_3_4__leaf_CLK VGND VGND VPWR VPWR clkload3/X sky130_fd_sc_hd__clkbuf_8
X_9506_ clknet_leaf_73_CLK _0739_ VGND VGND VPWR VPWR RF.reg_arr\[10\]\[4\] sky130_fd_sc_hd__dfxtp_1
X_6718_ _3063_ net770 _3270_ VGND VGND VPWR VPWR _3273_ sky130_fd_sc_hd__mux2_1
XFILLER_0_116_362 VGND VGND VPWR VPWR sky130_fd_sc_hd__fill_2
X_9437_ clknet_leaf_18_CLK _0670_ VGND VGND VPWR VPWR RF.reg_arr\[17\]\[31\] sky130_fd_sc_hd__dfxtp_1
XFILLER_0_33_113 VGND VGND VPWR VPWR sky130_fd_sc_hd__decap_3
X_6649_ _3235_ VGND VGND VPWR VPWR _0929_ sky130_fd_sc_hd__clkbuf_1
XFILLER_0_61_477 VGND VGND VPWR VPWR sky130_fd_sc_hd__decap_3
X_9368_ clknet_leaf_35_CLK _0601_ VGND VGND VPWR VPWR RF.reg_arr\[18\]\[26\] sky130_fd_sc_hd__dfxtp_1
XFILLER_0_61_499 VGND VGND VPWR VPWR sky130_fd_sc_hd__fill_2
X_9299_ clknet_leaf_47_CLK _0532_ VGND VGND VPWR VPWR RF.reg_arr\[25\]\[21\] sky130_fd_sc_hd__dfxtp_1
X_8319_ _4139_ VGND VGND VPWR VPWR _0671_ sky130_fd_sc_hd__clkbuf_1
XTAP_TAPCELL_ROW_70_1095 VGND VPWR sky130_fd_sc_hd__tapvpwrvgnd_1
XTAP_TAPCELL_ROW_109_1559 VGND VPWR sky130_fd_sc_hd__tapvpwrvgnd_1
XFILLER_0_69_588 VGND VGND VPWR VPWR sky130_fd_sc_hd__fill_2
XFILLER_0_84_525 VGND VGND VPWR VPWR sky130_fd_sc_hd__decap_6
XTAP_TAPCELL_ROW_25_550 VGND VPWR sky130_fd_sc_hd__tapvpwrvgnd_1
XFILLER_0_56_216 VGND VGND VPWR VPWR sky130_fd_sc_hd__decap_4
XTAP_TAPCELL_ROW_53_892 VGND VPWR sky130_fd_sc_hd__tapvpwrvgnd_1
XFILLER_0_112_27 VGND VGND VPWR VPWR sky130_fd_sc_hd__fill_1
XFILLER_0_25_625 VGND VGND VPWR VPWR sky130_fd_sc_hd__fill_2
XFILLER_0_20_363 VGND VGND VPWR VPWR sky130_fd_sc_hd__fill_1
XTAP_TAPCELL_ROW_88_1312 VGND VPWR sky130_fd_sc_hd__tapvpwrvgnd_1
XFILLER_0_79_319 VGND VGND VPWR VPWR sky130_fd_sc_hd__decap_6
XFILLER_0_79_308 VGND VGND VPWR VPWR sky130_fd_sc_hd__fill_2
XFILLER_0_27_9 VGND VGND VPWR VPWR sky130_fd_sc_hd__fill_1
X_5951_ _2023_ _2418_ VGND VGND VPWR VPWR _2724_ sky130_fd_sc_hd__nor2_1
X_4902_ _1619_ _1690_ VGND VGND VPWR VPWR _1691_ sky130_fd_sc_hd__nor2_1
XFILLER_0_75_503 VGND VGND VPWR VPWR sky130_fd_sc_hd__fill_1
XFILLER_0_1_57 VPWR VGND VPWR VGND sky130_ef_sc_hd__decap_12
X_8670_ clknet_leaf_72_CLK _0927_ VGND VGND VPWR VPWR RF.reg_arr\[15\]\[0\] sky130_fd_sc_hd__dfxtp_1
X_5882_ _2657_ _2658_ _1738_ VGND VGND VPWR VPWR _2659_ sky130_fd_sc_hd__mux2_1
X_7621_ net240 _3373_ _3763_ VGND VGND VPWR VPWR _3769_ sky130_fd_sc_hd__mux2_1
XFILLER_0_7_302 VGND VGND VPWR VPWR sky130_fd_sc_hd__decap_4
XFILLER_0_28_430 VGND VGND VPWR VPWR sky130_fd_sc_hd__fill_1
X_4833_ _1621_ VGND VGND VPWR VPWR _1622_ sky130_fd_sc_hd__buf_4
X_7552_ _3732_ VGND VGND VPWR VPWR _0311_ sky130_fd_sc_hd__clkbuf_1
X_4764_ RF.reg_arr\[28\]\[25\] RF.reg_arr\[29\]\[25\] RF.reg_arr\[30\]\[25\] RF.reg_arr\[31\]\[25\]
+ _1273_ _1275_ VGND VGND VPWR VPWR _1553_ sky130_fd_sc_hd__mux4_1
XFILLER_0_7_335 VGND VGND VPWR VPWR sky130_fd_sc_hd__fill_1
XFILLER_0_28_463 VGND VGND VPWR VPWR sky130_fd_sc_hd__fill_1
XTAP_TAPCELL_ROW_99_1441 VGND VPWR sky130_fd_sc_hd__tapvpwrvgnd_1
X_6503_ _3156_ VGND VGND VPWR VPWR _0862_ sky130_fd_sc_hd__clkbuf_1
X_7483_ _3111_ net390 _3689_ VGND VGND VPWR VPWR _3695_ sky130_fd_sc_hd__mux2_1
XFILLER_0_102_82 VGND VGND VPWR VPWR sky130_fd_sc_hd__fill_2
X_6434_ net37 VGND VGND VPWR VPWR _3121_ sky130_fd_sc_hd__clkbuf_2
X_4695_ RF.reg_arr\[20\]\[12\] RF.reg_arr\[21\]\[12\] RF.reg_arr\[22\]\[12\] RF.reg_arr\[23\]\[12\]
+ _1051_ _1053_ VGND VGND VPWR VPWR _1484_ sky130_fd_sc_hd__mux4_1
X_9222_ clknet_leaf_81_CLK _0455_ VGND VGND VPWR VPWR RF.reg_arr\[22\]\[8\] sky130_fd_sc_hd__dfxtp_1
XFILLER_0_101_505 VPWR VGND VPWR VGND sky130_ef_sc_hd__decap_12
XFILLER_0_60_3 VGND VGND VPWR VPWR sky130_fd_sc_hd__fill_1
X_6365_ _3074_ VGND VGND VPWR VPWR _0806_ sky130_fd_sc_hd__clkbuf_1
X_9153_ clknet_leaf_65_CLK _0386_ VGND VGND VPWR VPWR RF.reg_arr\[9\]\[3\] sky130_fd_sc_hd__dfxtp_1
X_8104_ _2986_ net458 _4016_ VGND VGND VPWR VPWR _4025_ sky130_fd_sc_hd__mux2_1
XFILLER_0_101_549 VGND VGND VPWR VPWR sky130_fd_sc_hd__fill_1
X_9084_ clknet_leaf_20_CLK _0317_ VGND VGND VPWR VPWR RF.reg_arr\[28\]\[30\] sky130_fd_sc_hd__dfxtp_1
X_5316_ RF.reg_arr\[20\]\[9\] RF.reg_arr\[21\]\[9\] RF.reg_arr\[22\]\[9\] RF.reg_arr\[23\]\[9\]
+ _1623_ _1596_ VGND VGND VPWR VPWR _2105_ sky130_fd_sc_hd__mux4_1
X_6296_ net272 _3029_ _3019_ VGND VGND VPWR VPWR _3030_ sky130_fd_sc_hd__mux2_1
X_8035_ _3988_ VGND VGND VPWR VPWR _0538_ sky130_fd_sc_hd__clkbuf_1
X_5247_ RF.reg_arr\[4\]\[0\] RF.reg_arr\[5\]\[0\] RF.reg_arr\[6\]\[0\] RF.reg_arr\[7\]\[0\]
+ _1674_ _1680_ VGND VGND VPWR VPWR _2036_ sky130_fd_sc_hd__mux4_1
Xhold37 RF.reg_arr\[0\]\[30\] VGND VGND VPWR VPWR net119 sky130_fd_sc_hd__dlygate4sd3_1
Xhold26 RF.reg_arr\[0\]\[22\] VGND VGND VPWR VPWR net108 sky130_fd_sc_hd__dlygate4sd3_1
Xhold59 RF.reg_arr\[1\]\[22\] VGND VGND VPWR VPWR net141 sky130_fd_sc_hd__dlygate4sd3_1
Xhold48 RF.reg_arr\[0\]\[8\] VGND VGND VPWR VPWR net130 sky130_fd_sc_hd__dlygate4sd3_1
X_5178_ RF.reg_arr\[20\]\[16\] RF.reg_arr\[21\]\[16\] RF.reg_arr\[22\]\[16\] RF.reg_arr\[23\]\[16\]
+ _1884_ _1886_ VGND VGND VPWR VPWR _1967_ sky130_fd_sc_hd__mux4_1
XFILLER_0_97_116 VGND VGND VPWR VPWR sky130_fd_sc_hd__decap_3
XFILLER_0_97_127 VPWR VGND VPWR VGND sky130_ef_sc_hd__decap_12
XTAP_TAPCELL_ROW_3_289 VGND VPWR sky130_fd_sc_hd__tapvpwrvgnd_1
X_8937_ clknet_leaf_12_CLK _0170_ VGND VGND VPWR VPWR RF.reg_arr\[29\]\[11\] sky130_fd_sc_hd__dfxtp_1
XFILLER_0_66_525 VGND VGND VPWR VPWR sky130_fd_sc_hd__decap_6
X_8868_ clknet_leaf_88_CLK _0101_ VGND VGND VPWR VPWR RF.reg_arr\[3\]\[6\] sky130_fd_sc_hd__dfxtp_1
X_7819_ _3105_ net338 _3871_ VGND VGND VPWR VPWR _3874_ sky130_fd_sc_hd__mux2_1
XFILLER_0_66_569 VGND VGND VPWR VPWR sky130_fd_sc_hd__decap_3
X_8799_ clknet_leaf_57_CLK _0032_ VGND VGND VPWR VPWR RF.reg_arr\[4\]\[1\] sky130_fd_sc_hd__dfxtp_1
XFILLER_0_108_137 VGND VGND VPWR VPWR sky130_fd_sc_hd__decap_3
XTAP_TAPCELL_ROW_22_520 VGND VPWR sky130_fd_sc_hd__tapvpwrvgnd_1
XTAP_TAPCELL_ROW_50_851 VGND VPWR sky130_fd_sc_hd__tapvpwrvgnd_1
XFILLER_0_104_321 VGND VGND VPWR VPWR sky130_fd_sc_hd__fill_2
XFILLER_0_21_105 VGND VGND VPWR VPWR sky130_fd_sc_hd__decap_6
XFILLER_0_21_127 VGND VGND VPWR VPWR sky130_fd_sc_hd__fill_1
XFILLER_0_14_190 VGND VGND VPWR VPWR sky130_fd_sc_hd__decap_6
XTAP_TAPCELL_ROW_72_1113 VGND VPWR sky130_fd_sc_hd__tapvpwrvgnd_1
XFILLER_0_89_606 VGND VGND VPWR VPWR sky130_fd_sc_hd__decap_8
XFILLER_0_107_38 VGND VGND VPWR VPWR sky130_fd_sc_hd__fill_1
XFILLER_0_89_617 VGND VGND VPWR VPWR sky130_fd_sc_hd__fill_2
XTAP_TAPCELL_ROW_58_951 VGND VPWR sky130_fd_sc_hd__tapvpwrvgnd_1
XFILLER_0_97_650 VGND VGND VPWR VPWR sky130_fd_sc_hd__decap_8
XTAP_TAPCELL_ROW_83_1253 VGND VPWR sky130_fd_sc_hd__tapvpwrvgnd_1
XTAP_TAPCELL_ROW_83_1242 VGND VPWR sky130_fd_sc_hd__tapvpwrvgnd_1
XFILLER_0_57_569 VGND VGND VPWR VPWR sky130_fd_sc_hd__fill_1
XFILLER_0_32_79 VGND VGND VPWR VPWR sky130_fd_sc_hd__decap_4
XFILLER_0_114_118 VGND VGND VPWR VPWR sky130_fd_sc_hd__decap_6
XFILLER_0_80_550 VGND VGND VPWR VPWR sky130_fd_sc_hd__decap_6
XFILLER_0_4_338 VGND VGND VPWR VPWR sky130_fd_sc_hd__fill_1
XFILLER_0_12_116 VGND VGND VPWR VPWR sky130_fd_sc_hd__decap_6
XFILLER_0_12_105 VGND VGND VPWR VPWR sky130_fd_sc_hd__fill_2
Xhold507 RF.reg_arr\[28\]\[8\] VGND VGND VPWR VPWR net589 sky130_fd_sc_hd__dlygate4sd3_1
X_4480_ _1055_ _1268_ net8 VGND VGND VPWR VPWR _1269_ sky130_fd_sc_hd__a21o_1
Xhold518 RF.reg_arr\[3\]\[11\] VGND VGND VPWR VPWR net600 sky130_fd_sc_hd__dlygate4sd3_1
XFILLER_0_0_522 VGND VGND VPWR VPWR sky130_fd_sc_hd__fill_1
Xhold529 RF.reg_arr\[10\]\[13\] VGND VGND VPWR VPWR net611 sky130_fd_sc_hd__dlygate4sd3_1
X_6150_ _2026_ _2906_ _2909_ _2910_ _2911_ VGND VGND VPWR VPWR _2912_ sky130_fd_sc_hd__o311a_1
XTAP_TAPCELL_ROW_94_1382 VGND VPWR sky130_fd_sc_hd__tapvpwrvgnd_1
X_5101_ _1880_ _1882_ _1889_ _1636_ _1586_ VGND VGND VPWR VPWR _1890_ sky130_fd_sc_hd__a221o_1
X_6081_ _2200_ _2784_ _2845_ _2420_ VGND VGND VPWR VPWR _2846_ sky130_fd_sc_hd__a22o_1
X_5032_ RF.reg_arr\[4\]\[2\] RF.reg_arr\[5\]\[2\] RF.reg_arr\[6\]\[2\] RF.reg_arr\[7\]\[2\]
+ _1050_ _1052_ VGND VGND VPWR VPWR _1821_ sky130_fd_sc_hd__mux4_1
XTAP_TAPCELL_ROW_0_237 VGND VPWR sky130_fd_sc_hd__tapvpwrvgnd_1
XTAP_TAPCELL_ROW_0_248 VGND VPWR sky130_fd_sc_hd__tapvpwrvgnd_1
X_6983_ net23 VGND VGND VPWR VPWR _3426_ sky130_fd_sc_hd__buf_2
X_5934_ _2051_ _2707_ VGND VGND VPWR VPWR _2708_ sky130_fd_sc_hd__nor2_1
X_8722_ clknet_leaf_16_CLK _0979_ VGND VGND VPWR VPWR RF.reg_arr\[14\]\[20\] sky130_fd_sc_hd__dfxtp_1
XTAP_TAPCELL_ROW_36_678 VGND VPWR sky130_fd_sc_hd__tapvpwrvgnd_1
X_5865_ _2630_ _2635_ _2642_ _2446_ VGND VGND VPWR VPWR net51 sky130_fd_sc_hd__o22a_1
X_8653_ clknet_leaf_102_CLK _0910_ VGND VGND VPWR VPWR RF.reg_arr\[8\]\[15\] sky130_fd_sc_hd__dfxtp_1
XTAP_TAPCELL_ROW_36_689 VGND VPWR sky130_fd_sc_hd__tapvpwrvgnd_1
X_4816_ _1604_ VGND VGND VPWR VPWR _1605_ sky130_fd_sc_hd__clkbuf_8
X_7604_ net690 _3424_ _3752_ VGND VGND VPWR VPWR _3760_ sky130_fd_sc_hd__mux2_1
XFILLER_0_90_336 VGND VGND VPWR VPWR sky130_fd_sc_hd__fill_1
X_5796_ _2503_ _2541_ _2576_ VGND VGND VPWR VPWR _2577_ sky130_fd_sc_hd__a21o_1
X_8584_ clknet_leaf_64_CLK _0841_ VGND VGND VPWR VPWR RF.reg_arr\[0\]\[10\] sky130_fd_sc_hd__dfxtp_1
X_4747_ _1534_ _1535_ _1128_ VGND VGND VPWR VPWR _1536_ sky130_fd_sc_hd__mux2_1
X_7535_ _3723_ VGND VGND VPWR VPWR _0303_ sky130_fd_sc_hd__clkbuf_1
X_4678_ _1272_ _1458_ _1462_ _1466_ VGND VGND VPWR VPWR _1467_ sky130_fd_sc_hd__o2bb2a_2
X_7466_ _3094_ net1084 _3678_ VGND VGND VPWR VPWR _3686_ sky130_fd_sc_hd__mux2_1
X_6417_ _3109_ net668 _3101_ VGND VGND VPWR VPWR _3110_ sky130_fd_sc_hd__mux2_1
X_9205_ clknet_leaf_17_CLK _0438_ VGND VGND VPWR VPWR RF.reg_arr\[24\]\[23\] sky130_fd_sc_hd__dfxtp_1
X_7397_ _3094_ net1011 _3641_ VGND VGND VPWR VPWR _3649_ sky130_fd_sc_hd__mux2_1
Xoutput49 net49 VGND VGND VPWR VPWR result[0] sky130_fd_sc_hd__clkbuf_4
X_6348_ net36 VGND VGND VPWR VPWR _3063_ sky130_fd_sc_hd__buf_2
XFILLER_0_3_393 VGND VGND VPWR VPWR sky130_fd_sc_hd__decap_8
X_9136_ clknet_leaf_0_CLK _0369_ VGND VGND VPWR VPWR RF.reg_arr\[30\]\[18\] sky130_fd_sc_hd__dfxtp_1
XTAP_TAPCELL_ROW_8_348 VGND VPWR sky130_fd_sc_hd__tapvpwrvgnd_1
X_9067_ clknet_leaf_93_CLK _0300_ VGND VGND VPWR VPWR RF.reg_arr\[28\]\[13\] sky130_fd_sc_hd__dfxtp_1
X_6279_ net15 VGND VGND VPWR VPWR _3018_ sky130_fd_sc_hd__buf_2
X_8018_ _3979_ VGND VGND VPWR VPWR _0530_ sky130_fd_sc_hd__clkbuf_1
XTAP_TAPCELL_ROW_106_1518 VGND VPWR sky130_fd_sc_hd__tapvpwrvgnd_1
XFILLER_0_98_436 VGND VGND VPWR VPWR sky130_fd_sc_hd__fill_1
XTAP_TAPCELL_ROW_55_910 VGND VPWR sky130_fd_sc_hd__tapvpwrvgnd_1
XTAP_TAPCELL_ROW_106_1529 VGND VPWR sky130_fd_sc_hd__tapvpwrvgnd_1
XFILLER_0_39_503 VGND VGND VPWR VPWR sky130_fd_sc_hd__fill_1
XFILLER_0_39_547 VGND VGND VPWR VPWR sky130_fd_sc_hd__fill_1
XFILLER_0_93_141 VGND VGND VPWR VPWR sky130_fd_sc_hd__fill_1
XFILLER_0_81_325 VGND VGND VPWR VPWR sky130_fd_sc_hd__fill_2
XFILLER_0_34_241 VGND VGND VPWR VPWR sky130_fd_sc_hd__fill_2
Xclkbuf_leaf_40_CLK clknet_3_3__leaf_CLK VGND VGND VPWR VPWR clknet_leaf_40_CLK sky130_fd_sc_hd__clkbuf_8
XFILLER_0_27_57 VGND VGND VPWR VPWR sky130_fd_sc_hd__decap_8
XFILLER_0_77_609 VGND VGND VPWR VPWR sky130_fd_sc_hd__decap_6
X_5650_ _1811_ _1894_ _2366_ VGND VGND VPWR VPWR _2437_ sky130_fd_sc_hd__mux2_1
XTAP_TAPCELL_ROW_61_979 VGND VPWR sky130_fd_sc_hd__tapvpwrvgnd_1
XTAP_TAPCELL_ROW_33_648 VGND VPWR sky130_fd_sc_hd__tapvpwrvgnd_1
X_4601_ RF.reg_arr\[16\]\[6\] RF.reg_arr\[17\]\[6\] RF.reg_arr\[18\]\[6\] RF.reg_arr\[19\]\[6\]
+ _1093_ _1094_ VGND VGND VPWR VPWR _1390_ sky130_fd_sc_hd__mux4_1
X_5581_ _2029_ _2365_ _2368_ VGND VGND VPWR VPWR _2369_ sky130_fd_sc_hd__o21ai_1
XTAP_TAPCELL_ROW_96_1400 VGND VPWR sky130_fd_sc_hd__tapvpwrvgnd_1
X_4532_ _1317_ _1318_ _1319_ _1320_ _1296_ _1173_ VGND VGND VPWR VPWR _1321_ sky130_fd_sc_hd__mux4_1
X_7320_ _3608_ VGND VGND VPWR VPWR _0203_ sky130_fd_sc_hd__clkbuf_1
XFILLER_0_25_274 VGND VGND VPWR VPWR sky130_fd_sc_hd__decap_6
XFILLER_0_111_611 VGND VGND VPWR VPWR sky130_fd_sc_hd__decap_4
XFILLER_0_13_447 VGND VGND VPWR VPWR sky130_fd_sc_hd__fill_1
X_7251_ _3084_ net759 _3569_ VGND VGND VPWR VPWR _3572_ sky130_fd_sc_hd__mux2_1
Xhold326 RF.reg_arr\[28\]\[14\] VGND VGND VPWR VPWR net408 sky130_fd_sc_hd__dlygate4sd3_1
Xhold304 RF.reg_arr\[3\]\[15\] VGND VGND VPWR VPWR net386 sky130_fd_sc_hd__dlygate4sd3_1
XFILLER_0_40_244 VGND VGND VPWR VPWR sky130_fd_sc_hd__decap_8
Xhold315 RF.reg_arr\[2\]\[16\] VGND VGND VPWR VPWR net397 sky130_fd_sc_hd__dlygate4sd3_1
X_4463_ RF.reg_arr\[0\]\[10\] RF.reg_arr\[1\]\[10\] RF.reg_arr\[2\]\[10\] RF.reg_arr\[3\]\[10\]
+ _1229_ _1230_ VGND VGND VPWR VPWR _1252_ sky130_fd_sc_hd__mux4_1
XFILLER_0_111_655 VGND VGND VPWR VPWR sky130_fd_sc_hd__fill_1
X_6202_ _2959_ _2957_ _1663_ _2954_ VGND VGND VPWR VPWR _2960_ sky130_fd_sc_hd__o2bb2a_4
Xhold348 RF.reg_arr\[24\]\[23\] VGND VGND VPWR VPWR net430 sky130_fd_sc_hd__dlygate4sd3_1
Xhold337 RF.reg_arr\[29\]\[20\] VGND VGND VPWR VPWR net419 sky130_fd_sc_hd__dlygate4sd3_1
XFILLER_0_7_78 VGND VGND VPWR VPWR sky130_fd_sc_hd__fill_2
Xhold359 RF.reg_arr\[24\]\[18\] VGND VGND VPWR VPWR net441 sky130_fd_sc_hd__dlygate4sd3_1
Xclkbuf_leaf_31_CLK clknet_3_2__leaf_CLK VGND VGND VPWR VPWR clknet_leaf_31_CLK sky130_fd_sc_hd__clkbuf_8
XFILLER_0_7_89 VGND VGND VPWR VPWR sky130_fd_sc_hd__fill_2
XPHY_EDGE_ROW_15_Right_15 VGND VGND VPWR VPWR sky130_fd_sc_hd__decap_3
X_7182_ net556 _3414_ _3532_ VGND VGND VPWR VPWR _3535_ sky130_fd_sc_hd__mux2_1
XFILLER_0_40_299 VGND VGND VPWR VPWR sky130_fd_sc_hd__decap_6
X_4394_ _1181_ _1182_ _1133_ VGND VGND VPWR VPWR _1183_ sky130_fd_sc_hd__mux2_1
X_6133_ _2865_ _2893_ _2892_ _2872_ VGND VGND VPWR VPWR _2896_ sky130_fd_sc_hd__o211a_1
XTAP_TAPCELL_ROW_5_307 VGND VPWR sky130_fd_sc_hd__tapvpwrvgnd_1
X_6064_ _1333_ _2547_ _2828_ VGND VGND VPWR VPWR _2830_ sky130_fd_sc_hd__nand3_1
Xhold1004 RF.reg_arr\[30\]\[30\] VGND VGND VPWR VPWR net1086 sky130_fd_sc_hd__dlygate4sd3_1
Xhold1015 RF.reg_arr\[10\]\[11\] VGND VGND VPWR VPWR net1097 sky130_fd_sc_hd__dlygate4sd3_1
X_5015_ RF.reg_arr\[4\]\[25\] RF.reg_arr\[5\]\[25\] RF.reg_arr\[6\]\[25\] RF.reg_arr\[7\]\[25\]
+ _1677_ _1683_ VGND VGND VPWR VPWR _1804_ sky130_fd_sc_hd__mux4_1
Xhold1037 RF.reg_arr\[20\]\[15\] VGND VGND VPWR VPWR net1119 sky130_fd_sc_hd__dlygate4sd3_1
Xhold1026 RF.reg_arr\[14\]\[17\] VGND VGND VPWR VPWR net1108 sky130_fd_sc_hd__dlygate4sd3_1
XFILLER_0_108_81 VGND VGND VPWR VPWR sky130_fd_sc_hd__decap_3
XFILLER_0_84_85 VGND VGND VPWR VPWR sky130_fd_sc_hd__fill_2
XFILLER_0_23_3 VGND VGND VPWR VPWR sky130_fd_sc_hd__decap_8
Xclkbuf_leaf_98_CLK clknet_3_4__leaf_CLK VGND VGND VPWR VPWR clknet_leaf_98_CLK sky130_fd_sc_hd__clkbuf_8
X_6966_ net684 _3414_ _3410_ VGND VGND VPWR VPWR _3415_ sky130_fd_sc_hd__mux2_1
XPHY_EDGE_ROW_24_Right_24 VGND VGND VPWR VPWR sky130_fd_sc_hd__decap_3
XFILLER_0_88_491 VGND VGND VPWR VPWR sky130_fd_sc_hd__decap_8
X_5917_ _1533_ _2691_ VGND VGND VPWR VPWR _2692_ sky130_fd_sc_hd__xnor2_1
XFILLER_0_76_653 VGND VGND VPWR VPWR sky130_fd_sc_hd__fill_2
XFILLER_0_76_631 VGND VGND VPWR VPWR sky130_fd_sc_hd__fill_1
X_8705_ clknet_leaf_66_CLK _0962_ VGND VGND VPWR VPWR RF.reg_arr\[14\]\[3\] sky130_fd_sc_hd__dfxtp_1
X_6897_ _3368_ VGND VGND VPWR VPWR _0020_ sky130_fd_sc_hd__clkbuf_1
XTAP_TAPCELL_ROW_101_1459 VGND VPWR sky130_fd_sc_hd__tapvpwrvgnd_1
XFILLER_0_90_111 VGND VGND VPWR VPWR sky130_fd_sc_hd__fill_1
X_5848_ _2624_ _2626_ VGND VGND VPWR VPWR _2627_ sky130_fd_sc_hd__xnor2_1
X_8636_ clknet_leaf_18_CLK _0893_ VGND VGND VPWR VPWR RF.reg_arr\[16\]\[30\] sky130_fd_sc_hd__dfxtp_1
XFILLER_0_63_314 VGND VGND VPWR VPWR sky130_fd_sc_hd__decap_3
XFILLER_0_8_452 VGND VGND VPWR VPWR sky130_fd_sc_hd__decap_4
X_5779_ _2197_ _2560_ VGND VGND VPWR VPWR _2561_ sky130_fd_sc_hd__or2_1
X_8567_ clknet_leaf_25_CLK _0824_ VGND VGND VPWR VPWR RF.reg_arr\[23\]\[25\] sky130_fd_sc_hd__dfxtp_1
X_7518_ _3714_ VGND VGND VPWR VPWR _0295_ sky130_fd_sc_hd__clkbuf_1
X_8498_ net385 net28 _2977_ VGND VGND VPWR VPWR _4233_ sky130_fd_sc_hd__mux2_1
XFILLER_0_31_233 VGND VGND VPWR VPWR sky130_fd_sc_hd__fill_2
XFILLER_0_102_633 VGND VGND VPWR VPWR sky130_fd_sc_hd__fill_2
XFILLER_0_101_110 VGND VGND VPWR VPWR sky130_fd_sc_hd__fill_2
X_7449_ _3077_ net1022 _3667_ VGND VGND VPWR VPWR _3677_ sky130_fd_sc_hd__mux2_1
XFILLER_0_4_691 VGND VGND VPWR VPWR sky130_fd_sc_hd__fill_1
XFILLER_0_31_277 VGND VGND VPWR VPWR sky130_fd_sc_hd__decap_3
XPHY_EDGE_ROW_33_Right_33 VGND VGND VPWR VPWR sky130_fd_sc_hd__decap_3
XFILLER_0_102_677 VGND VGND VPWR VPWR sky130_fd_sc_hd__decap_3
Xclkbuf_leaf_22_CLK clknet_3_2__leaf_CLK VGND VGND VPWR VPWR clknet_leaf_22_CLK sky130_fd_sc_hd__clkbuf_8
Xhold871 RF.reg_arr\[20\]\[8\] VGND VGND VPWR VPWR net953 sky130_fd_sc_hd__dlygate4sd3_1
Xhold882 RF.reg_arr\[10\]\[12\] VGND VGND VPWR VPWR net964 sky130_fd_sc_hd__dlygate4sd3_1
Xhold860 RF.reg_arr\[4\]\[4\] VGND VGND VPWR VPWR net942 sky130_fd_sc_hd__dlygate4sd3_1
X_9119_ clknet_leaf_57_CLK _0352_ VGND VGND VPWR VPWR RF.reg_arr\[30\]\[1\] sky130_fd_sc_hd__dfxtp_1
Xhold893 RF.reg_arr\[25\]\[10\] VGND VGND VPWR VPWR net975 sky130_fd_sc_hd__dlygate4sd3_1
XTAP_TAPCELL_ROW_112_1599 VGND VPWR sky130_fd_sc_hd__tapvpwrvgnd_1
XPHY_EDGE_ROW_42_Right_42 VGND VGND VPWR VPWR sky130_fd_sc_hd__decap_3
XTAP_TAPCELL_ROW_67_1056 VGND VPWR sky130_fd_sc_hd__tapvpwrvgnd_1
Xclkbuf_leaf_89_CLK clknet_3_4__leaf_CLK VGND VGND VPWR VPWR clknet_leaf_89_CLK sky130_fd_sc_hd__clkbuf_8
XFILLER_0_13_15 VPWR VGND VPWR VGND sky130_ef_sc_hd__decap_12
XTAP_TAPCELL_ROW_80_1212 VGND VPWR sky130_fd_sc_hd__tapvpwrvgnd_1
XFILLER_0_82_645 VPWR VGND VPWR VGND sky130_ef_sc_hd__decap_12
XFILLER_0_81_122 VGND VGND VPWR VPWR sky130_fd_sc_hd__decap_8
XTAP_TAPCELL_ROW_30_607 VGND VPWR sky130_fd_sc_hd__tapvpwrvgnd_1
XFILLER_0_82_689 VGND VGND VPWR VPWR sky130_fd_sc_hd__decap_3
XFILLER_0_82_667 VGND VGND VPWR VPWR sky130_fd_sc_hd__fill_1
XFILLER_0_35_561 VGND VGND VPWR VPWR sky130_fd_sc_hd__decap_4
XPHY_EDGE_ROW_51_Right_51 VGND VGND VPWR VPWR sky130_fd_sc_hd__decap_3
XTAP_TAPCELL_ROW_10_375 VGND VPWR sky130_fd_sc_hd__tapvpwrvgnd_1
XFILLER_0_1_105 VGND VGND VPWR VPWR sky130_fd_sc_hd__decap_4
XFILLER_0_50_531 VGND VGND VPWR VPWR sky130_fd_sc_hd__fill_1
XTAP_TAPCELL_ROW_78_1185 VGND VPWR sky130_fd_sc_hd__tapvpwrvgnd_1
Xclkbuf_leaf_13_CLK clknet_3_1__leaf_CLK VGND VGND VPWR VPWR clknet_leaf_13_CLK sky130_fd_sc_hd__clkbuf_8
XTAP_TAPCELL_ROW_91_1341 VGND VPWR sky130_fd_sc_hd__tapvpwrvgnd_1
XPHY_EDGE_ROW_60_Right_60 VGND VGND VPWR VPWR sky130_fd_sc_hd__decap_3
XTAP_TAPCELL_ROW_38_707 VGND VPWR sky130_fd_sc_hd__tapvpwrvgnd_1
XFILLER_0_54_66 VGND VGND VPWR VPWR sky130_fd_sc_hd__fill_1
X_6820_ net654 _3035_ _3318_ VGND VGND VPWR VPWR _3327_ sky130_fd_sc_hd__mux2_1
XFILLER_0_58_642 VGND VGND VPWR VPWR sky130_fd_sc_hd__fill_2
XFILLER_0_58_620 VPWR VGND VPWR VGND sky130_ef_sc_hd__decap_12
XTAP_TAPCELL_ROW_18_464 VGND VPWR sky130_fd_sc_hd__tapvpwrvgnd_1
XFILLER_0_58_664 VGND VGND VPWR VPWR sky130_fd_sc_hd__fill_2
XFILLER_0_9_249 VGND VGND VPWR VPWR sky130_fd_sc_hd__fill_1
X_6751_ _3096_ net1121 _3281_ VGND VGND VPWR VPWR _3290_ sky130_fd_sc_hd__mux2_1
XFILLER_0_45_303 VGND VGND VPWR VPWR sky130_fd_sc_hd__fill_1
X_5702_ _2124_ _2430_ _2275_ _2421_ VGND VGND VPWR VPWR _2487_ sky130_fd_sc_hd__a22o_1
XFILLER_0_73_645 VGND VGND VPWR VPWR sky130_fd_sc_hd__decap_3
X_6682_ _3252_ VGND VGND VPWR VPWR _0945_ sky130_fd_sc_hd__clkbuf_1
X_9470_ clknet_leaf_67_CLK _0703_ VGND VGND VPWR VPWR RF.reg_arr\[11\]\[0\] sky130_fd_sc_hd__dfxtp_1
X_5633_ _2049_ _2197_ VGND VGND VPWR VPWR _2420_ sky130_fd_sc_hd__nor2_2
XFILLER_0_72_144 VGND VGND VPWR VPWR sky130_fd_sc_hd__decap_4
X_8421_ net362 _3424_ _4185_ VGND VGND VPWR VPWR _4193_ sky130_fd_sc_hd__mux2_1
X_5564_ _2350_ _2351_ VGND VGND VPWR VPWR _2352_ sky130_fd_sc_hd__nor2_1
XFILLER_0_60_306 VGND VGND VPWR VPWR sky130_fd_sc_hd__fill_2
X_8352_ _4156_ VGND VGND VPWR VPWR _0687_ sky130_fd_sc_hd__clkbuf_1
XFILLER_0_115_279 VGND VGND VPWR VPWR sky130_fd_sc_hd__fill_1
X_4515_ _1176_ VGND VGND VPWR VPWR _1304_ sky130_fd_sc_hd__clkbuf_4
Xhold101 RF.reg_arr\[5\]\[24\] VGND VGND VPWR VPWR net183 sky130_fd_sc_hd__dlygate4sd3_1
X_7303_ _3599_ VGND VGND VPWR VPWR _0195_ sky130_fd_sc_hd__clkbuf_1
XFILLER_0_53_380 VGND VGND VPWR VPWR sky130_fd_sc_hd__fill_2
XPHY_EDGE_ROW_103_Right_103 VGND VGND VPWR VPWR sky130_fd_sc_hd__decap_3
Xhold112 RF.reg_arr\[18\]\[25\] VGND VGND VPWR VPWR net194 sky130_fd_sc_hd__dlygate4sd3_1
Xhold134 RF.reg_arr\[13\]\[25\] VGND VGND VPWR VPWR net216 sky130_fd_sc_hd__dlygate4sd3_1
Xhold123 RF.reg_arr\[10\]\[5\] VGND VGND VPWR VPWR net205 sky130_fd_sc_hd__dlygate4sd3_1
X_5495_ RF.reg_arr\[8\]\[3\] RF.reg_arr\[9\]\[3\] RF.reg_arr\[10\]\[3\] RF.reg_arr\[11\]\[3\]
+ _1674_ _1680_ VGND VGND VPWR VPWR _2284_ sky130_fd_sc_hd__mux4_1
X_8283_ net170 _3422_ _4113_ VGND VGND VPWR VPWR _4120_ sky130_fd_sc_hd__mux2_1
Xhold167 RF.reg_arr\[18\]\[29\] VGND VGND VPWR VPWR net249 sky130_fd_sc_hd__dlygate4sd3_1
Xhold156 RF.reg_arr\[3\]\[23\] VGND VGND VPWR VPWR net238 sky130_fd_sc_hd__dlygate4sd3_1
X_7234_ _3067_ net658 _3558_ VGND VGND VPWR VPWR _3563_ sky130_fd_sc_hd__mux2_1
X_4446_ RF.reg_arr\[4\]\[9\] RF.reg_arr\[5\]\[9\] RF.reg_arr\[6\]\[9\] RF.reg_arr\[7\]\[9\]
+ _1229_ _1230_ VGND VGND VPWR VPWR _1235_ sky130_fd_sc_hd__mux4_1
Xhold145 RF.reg_arr\[1\]\[13\] VGND VGND VPWR VPWR net227 sky130_fd_sc_hd__dlygate4sd3_1
XFILLER_0_111_485 VGND VGND VPWR VPWR sky130_fd_sc_hd__fill_1
Xhold178 RF.reg_arr\[16\]\[21\] VGND VGND VPWR VPWR net260 sky130_fd_sc_hd__dlygate4sd3_1
Xhold189 RF.reg_arr\[16\]\[1\] VGND VGND VPWR VPWR net271 sky130_fd_sc_hd__dlygate4sd3_1
X_4377_ RF.reg_arr\[20\]\[19\] RF.reg_arr\[21\]\[19\] RF.reg_arr\[22\]\[19\] RF.reg_arr\[23\]\[19\]
+ _1164_ _1165_ VGND VGND VPWR VPWR _1166_ sky130_fd_sc_hd__mux4_1
X_7165_ net983 _3397_ _3521_ VGND VGND VPWR VPWR _3526_ sky130_fd_sc_hd__mux2_1
X_6116_ _2051_ _2749_ _2879_ _2026_ VGND VGND VPWR VPWR _2880_ sky130_fd_sc_hd__a211o_1
XPHY_EDGE_ROW_13_Left_130 VGND VGND VPWR VPWR sky130_fd_sc_hd__decap_3
X_7096_ _3489_ VGND VGND VPWR VPWR _0098_ sky130_fd_sc_hd__clkbuf_1
X_6047_ _1868_ _2813_ VGND VGND VPWR VPWR _2814_ sky130_fd_sc_hd__xor2_2
XFILLER_0_95_225 VGND VGND VPWR VPWR sky130_fd_sc_hd__fill_1
X_7998_ _3957_ VGND VGND VPWR VPWR _3969_ sky130_fd_sc_hd__buf_4
X_6949_ net43 VGND VGND VPWR VPWR _3403_ sky130_fd_sc_hd__buf_2
XFILLER_0_64_645 VGND VGND VPWR VPWR sky130_fd_sc_hd__decap_4
X_8619_ clknet_leaf_93_CLK _0876_ VGND VGND VPWR VPWR RF.reg_arr\[16\]\[13\] sky130_fd_sc_hd__dfxtp_1
XFILLER_0_106_257 VGND VGND VPWR VPWR sky130_fd_sc_hd__fill_1
XFILLER_0_63_166 VGND VGND VPWR VPWR sky130_fd_sc_hd__fill_2
XTAP_TAPCELL_ROW_114_1617 VGND VPWR sky130_fd_sc_hd__tapvpwrvgnd_1
Xhold690 RF.reg_arr\[27\]\[11\] VGND VGND VPWR VPWR net772 sky130_fd_sc_hd__dlygate4sd3_1
XFILLER_0_115_27 VPWR VGND VPWR VGND sky130_ef_sc_hd__decap_12
XFILLER_0_59_439 VGND VGND VPWR VPWR sky130_fd_sc_hd__decap_8
XTAP_TAPCELL_ROW_15_434 VGND VPWR sky130_fd_sc_hd__tapvpwrvgnd_1
Xclkbuf_leaf_2_CLK clknet_3_1__leaf_CLK VGND VGND VPWR VPWR clknet_leaf_2_CLK sky130_fd_sc_hd__clkbuf_8
XTAP_TAPCELL_ROW_43_765 VGND VPWR sky130_fd_sc_hd__tapvpwrvgnd_1
XFILLER_0_55_623 VGND VGND VPWR VPWR sky130_fd_sc_hd__fill_1
XFILLER_0_40_13 VGND VGND VPWR VPWR sky130_fd_sc_hd__fill_1
XFILLER_0_112_205 VGND VGND VPWR VPWR sky130_fd_sc_hd__decap_3
XFILLER_0_2_436 VGND VGND VPWR VPWR sky130_fd_sc_hd__fill_1
X_5280_ _1756_ _2068_ VGND VGND VPWR VPWR _2069_ sky130_fd_sc_hd__or2_1
XFILLER_0_2_458 VGND VGND VPWR VPWR sky130_fd_sc_hd__fill_1
X_4300_ _1062_ _1081_ _1086_ _1088_ _1063_ VGND VGND VPWR VPWR _1089_ sky130_fd_sc_hd__a221o_1
XFILLER_0_50_372 VGND VGND VPWR VPWR sky130_fd_sc_hd__fill_1
XFILLER_0_10_269 VGND VGND VPWR VPWR sky130_fd_sc_hd__fill_2
XFILLER_0_10_247 VGND VGND VPWR VPWR sky130_fd_sc_hd__fill_2
X_8970_ clknet_leaf_100_CLK _0203_ VGND VGND VPWR VPWR RF.reg_arr\[31\]\[12\] sky130_fd_sc_hd__dfxtp_1
X_7921_ _3928_ VGND VGND VPWR VPWR _0484_ sky130_fd_sc_hd__clkbuf_1
X_7852_ _3069_ net1033 _3886_ VGND VGND VPWR VPWR _3892_ sky130_fd_sc_hd__mux2_1
X_4995_ _1619_ _1783_ VGND VGND VPWR VPWR _1784_ sky130_fd_sc_hd__nor2_1
X_6803_ _3306_ VGND VGND VPWR VPWR _3318_ sky130_fd_sc_hd__clkbuf_8
X_7783_ _3069_ net1028 _3849_ VGND VGND VPWR VPWR _3855_ sky130_fd_sc_hd__mux2_1
XFILLER_0_92_228 VGND VGND VPWR VPWR sky130_fd_sc_hd__fill_1
XFILLER_0_73_420 VGND VGND VPWR VPWR sky130_fd_sc_hd__fill_1
X_9522_ clknet_leaf_14_CLK _0755_ VGND VGND VPWR VPWR RF.reg_arr\[10\]\[20\] sky130_fd_sc_hd__dfxtp_1
X_6734_ _3269_ VGND VGND VPWR VPWR _3281_ sky130_fd_sc_hd__clkbuf_8
X_9453_ clknet_leaf_102_CLK _0686_ VGND VGND VPWR VPWR RF.reg_arr\[12\]\[15\] sky130_fd_sc_hd__dfxtp_1
XFILLER_0_18_347 VGND VGND VPWR VPWR sky130_fd_sc_hd__decap_3
XFILLER_0_45_133 VGND VGND VPWR VPWR sky130_fd_sc_hd__decap_4
XFILLER_0_46_645 VGND VGND VPWR VPWR sky130_fd_sc_hd__decap_6
XFILLER_0_90_3 VGND VGND VPWR VPWR sky130_fd_sc_hd__decap_4
XFILLER_0_61_615 VGND VGND VPWR VPWR sky130_fd_sc_hd__fill_1
X_6665_ _3079_ net937 _3243_ VGND VGND VPWR VPWR _3244_ sky130_fd_sc_hd__mux2_1
X_8404_ net283 _3407_ _4174_ VGND VGND VPWR VPWR _4184_ sky130_fd_sc_hd__mux2_1
X_5616_ _2402_ _2403_ VGND VGND VPWR VPWR _2404_ sky130_fd_sc_hd__nand2_1
X_9384_ clknet_leaf_12_CLK _0617_ VGND VGND VPWR VPWR RF.reg_arr\[13\]\[10\] sky130_fd_sc_hd__dfxtp_1
X_6596_ _3195_ VGND VGND VPWR VPWR _3207_ sky130_fd_sc_hd__buf_4
X_5547_ _2051_ _2199_ _2335_ VGND VGND VPWR VPWR _2336_ sky130_fd_sc_hd__a21o_1
X_8335_ _4147_ VGND VGND VPWR VPWR _0679_ sky130_fd_sc_hd__clkbuf_1
XFILLER_0_41_361 VGND VGND VPWR VPWR sky130_fd_sc_hd__fill_1
X_8266_ net202 _3405_ _4102_ VGND VGND VPWR VPWR _4111_ sky130_fd_sc_hd__mux2_1
X_5478_ RF.reg_arr\[4\]\[6\] RF.reg_arr\[5\]\[6\] RF.reg_arr\[6\]\[6\] RF.reg_arr\[7\]\[6\]
+ _1624_ _1597_ VGND VGND VPWR VPWR _2267_ sky130_fd_sc_hd__mux4_1
XFILLER_0_41_383 VGND VGND VPWR VPWR sky130_fd_sc_hd__fill_1
X_7217_ net246 _3381_ _3543_ VGND VGND VPWR VPWR _3553_ sky130_fd_sc_hd__mux2_1
X_4429_ _1039_ _1217_ VGND VGND VPWR VPWR _1218_ sky130_fd_sc_hd__nand2_1
X_8197_ _4074_ VGND VGND VPWR VPWR _0614_ sky130_fd_sc_hd__clkbuf_1
X_7148_ _3516_ VGND VGND VPWR VPWR _0123_ sky130_fd_sc_hd__clkbuf_1
X_7079_ net211 _3379_ _3471_ VGND VGND VPWR VPWR _3480_ sky130_fd_sc_hd__mux2_1
XFILLER_0_96_512 VGND VGND VPWR VPWR sky130_fd_sc_hd__fill_1
XTAP_TAPCELL_ROW_64_1015 VGND VPWR sky130_fd_sc_hd__tapvpwrvgnd_1
XFILLER_0_96_589 VPWR VGND VPWR VGND sky130_ef_sc_hd__decap_12
XFILLER_0_36_122 VGND VGND VPWR VPWR sky130_fd_sc_hd__fill_2
XFILLER_0_36_133 VGND VGND VPWR VPWR sky130_fd_sc_hd__decap_6
XTAP_TAPCELL_ROW_40_735 VGND VPWR sky130_fd_sc_hd__tapvpwrvgnd_1
XFILLER_0_24_306 VGND VGND VPWR VPWR sky130_fd_sc_hd__fill_2
XFILLER_0_107_577 VGND VGND VPWR VPWR sky130_fd_sc_hd__decap_3
XFILLER_0_101_18 VPWR VGND VPWR VGND sky130_ef_sc_hd__decap_12
XTAP_TAPCELL_ROW_20_492 VGND VPWR sky130_fd_sc_hd__tapvpwrvgnd_1
XFILLER_0_32_394 VGND VGND VPWR VPWR sky130_fd_sc_hd__decap_4
XTAP_TAPCELL_ROW_75_1155 VGND VPWR sky130_fd_sc_hd__tapvpwrvgnd_1
XFILLER_0_19_47 VGND VGND VPWR VPWR sky130_fd_sc_hd__decap_6
XTAP_TAPCELL_ROW_48_824 VGND VPWR sky130_fd_sc_hd__tapvpwrvgnd_1
XFILLER_0_35_57 VGND VGND VPWR VPWR sky130_fd_sc_hd__decap_6
XFILLER_0_59_225 VGND VGND VPWR VPWR sky130_fd_sc_hd__fill_1
XTAP_TAPCELL_ROW_86_1284 VGND VPWR sky130_fd_sc_hd__tapvpwrvgnd_1
XTAP_TAPCELL_ROW_28_592 VGND VPWR sky130_fd_sc_hd__tapvpwrvgnd_1
X_4780_ RF.reg_arr\[16\]\[24\] RF.reg_arr\[17\]\[24\] RF.reg_arr\[18\]\[24\] RF.reg_arr\[19\]\[24\]
+ _1327_ _1328_ VGND VGND VPWR VPWR _1569_ sky130_fd_sc_hd__mux4_1
XFILLER_0_27_111 VGND VGND VPWR VPWR sky130_fd_sc_hd__fill_1
XFILLER_0_82_250 VGND VGND VPWR VPWR sky130_fd_sc_hd__fill_2
XFILLER_0_43_626 VGND VGND VPWR VPWR sky130_fd_sc_hd__fill_1
XFILLER_0_55_486 VGND VGND VPWR VPWR sky130_fd_sc_hd__decap_6
XFILLER_0_113_503 VGND VGND VPWR VPWR sky130_fd_sc_hd__fill_1
X_6450_ net123 VGND VGND VPWR VPWR _3130_ sky130_fd_sc_hd__clkbuf_1
Xclkload10 clknet_leaf_5_CLK VGND VGND VPWR VPWR clkload10/Y sky130_fd_sc_hd__clkinv_8
XFILLER_0_113_547 VPWR VGND VPWR VGND sky130_ef_sc_hd__decap_12
Xclkload43 clknet_leaf_16_CLK VGND VGND VPWR VPWR clkload43/Y sky130_fd_sc_hd__clkinv_1
Xclkload32 clknet_leaf_22_CLK VGND VGND VPWR VPWR clkload32/Y sky130_fd_sc_hd__bufinv_16
XFILLER_0_70_467 VGND VGND VPWR VPWR sky130_fd_sc_hd__fill_2
X_6381_ _3085_ VGND VGND VPWR VPWR _0811_ sky130_fd_sc_hd__clkbuf_1
XFILLER_0_30_309 VGND VGND VPWR VPWR sky130_fd_sc_hd__fill_1
X_5401_ _2188_ _2189_ _1610_ VGND VGND VPWR VPWR _2190_ sky130_fd_sc_hd__mux2_1
Xclkload21 clknet_leaf_11_CLK VGND VGND VPWR VPWR clkload21/Y sky130_fd_sc_hd__inv_6
Xclkload87 clknet_leaf_50_CLK VGND VGND VPWR VPWR clkload87/Y sky130_fd_sc_hd__clkinvlp_4
X_5332_ _1584_ _2120_ VGND VGND VPWR VPWR _2121_ sky130_fd_sc_hd__or2_1
Xclkload54 clknet_leaf_43_CLK VGND VGND VPWR VPWR clkload54/Y sky130_fd_sc_hd__clkinvlp_4
Xclkload76 clknet_leaf_78_CLK VGND VGND VPWR VPWR clkload76/Y sky130_fd_sc_hd__clkinvlp_4
Xclkload65 clknet_leaf_97_CLK VGND VGND VPWR VPWR clkload65/Y sky130_fd_sc_hd__inv_8
X_8120_ net393 _3395_ _4030_ VGND VGND VPWR VPWR _4034_ sky130_fd_sc_hd__mux2_1
Xclkload98 clknet_leaf_58_CLK VGND VGND VPWR VPWR clkload98/Y sky130_fd_sc_hd__clkinv_4
X_8051_ _3997_ VGND VGND VPWR VPWR _0545_ sky130_fd_sc_hd__clkbuf_1
X_5263_ RF.reg_arr\[20\]\[10\] RF.reg_arr\[21\]\[10\] RF.reg_arr\[22\]\[10\] RF.reg_arr\[23\]\[10\]
+ _1624_ _1597_ VGND VGND VPWR VPWR _2052_ sky130_fd_sc_hd__mux4_1
X_7002_ net301 _3371_ _3431_ VGND VGND VPWR VPWR _3439_ sky130_fd_sc_hd__mux2_1
X_5194_ RF.reg_arr\[28\]\[17\] RF.reg_arr\[29\]\[17\] RF.reg_arr\[30\]\[17\] RF.reg_arr\[31\]\[17\]
+ _1883_ _1885_ VGND VGND VPWR VPWR _1983_ sky130_fd_sc_hd__mux4_1
X_8953_ clknet_leaf_33_CLK _0186_ VGND VGND VPWR VPWR RF.reg_arr\[29\]\[27\] sky130_fd_sc_hd__dfxtp_1
X_7904_ _3121_ net703 _3885_ VGND VGND VPWR VPWR _3919_ sky130_fd_sc_hd__mux2_1
X_8884_ clknet_leaf_44_CLK _0117_ VGND VGND VPWR VPWR RF.reg_arr\[3\]\[22\] sky130_fd_sc_hd__dfxtp_1
XFILLER_0_116_81 VGND VGND VPWR VPWR sky130_fd_sc_hd__decap_3
X_7835_ _3121_ net1073 _3848_ VGND VGND VPWR VPWR _3882_ sky130_fd_sc_hd__mux2_1
XFILLER_0_18_100 VGND VGND VPWR VPWR sky130_fd_sc_hd__fill_1
X_4978_ _1637_ _1766_ VGND VGND VPWR VPWR _1767_ sky130_fd_sc_hd__nor2_1
X_7766_ _3845_ VGND VGND VPWR VPWR _0412_ sky130_fd_sc_hd__clkbuf_1
XFILLER_0_93_559 VGND VGND VPWR VPWR sky130_fd_sc_hd__fill_1
XFILLER_0_18_122 VPWR VGND VPWR VGND sky130_ef_sc_hd__decap_12
X_9505_ clknet_leaf_66_CLK _0738_ VGND VGND VPWR VPWR RF.reg_arr\[10\]\[3\] sky130_fd_sc_hd__dfxtp_1
X_7697_ _3119_ net722 _3799_ VGND VGND VPWR VPWR _3809_ sky130_fd_sc_hd__mux2_1
Xclkload4 clknet_3_6__leaf_CLK VGND VGND VPWR VPWR clkload4/X sky130_fd_sc_hd__clkbuf_8
XFILLER_0_80_209 VGND VGND VPWR VPWR sky130_fd_sc_hd__fill_2
XFILLER_0_73_272 VGND VGND VPWR VPWR sky130_fd_sc_hd__decap_4
XFILLER_0_34_604 VGND VGND VPWR VPWR sky130_fd_sc_hd__fill_1
XFILLER_0_46_486 VGND VGND VPWR VPWR sky130_fd_sc_hd__fill_2
X_6717_ _3272_ VGND VGND VPWR VPWR _0960_ sky130_fd_sc_hd__clkbuf_1
X_9436_ clknet_leaf_19_CLK _0669_ VGND VGND VPWR VPWR RF.reg_arr\[17\]\[30\] sky130_fd_sc_hd__dfxtp_1
X_6648_ _3063_ net769 _3232_ VGND VGND VPWR VPWR _3235_ sky130_fd_sc_hd__mux2_1
XFILLER_0_104_514 VPWR VGND VPWR VGND sky130_ef_sc_hd__decap_12
X_9367_ clknet_leaf_40_CLK _0600_ VGND VGND VPWR VPWR RF.reg_arr\[18\]\[25\] sky130_fd_sc_hd__dfxtp_1
X_6579_ _3198_ VGND VGND VPWR VPWR _0896_ sky130_fd_sc_hd__clkbuf_1
X_8318_ _2994_ net496 _4138_ VGND VGND VPWR VPWR _4139_ sky130_fd_sc_hd__mux2_1
X_9298_ clknet_leaf_16_CLK _0531_ VGND VGND VPWR VPWR RF.reg_arr\[25\]\[20\] sky130_fd_sc_hd__dfxtp_1
X_8249_ _4101_ VGND VGND VPWR VPWR _4102_ sky130_fd_sc_hd__clkbuf_8
XTAP_TAPCELL_ROW_70_1096 VGND VPWR sky130_fd_sc_hd__tapvpwrvgnd_1
XFILLER_0_84_537 VGND VGND VPWR VPWR sky130_fd_sc_hd__fill_1
XTAP_TAPCELL_ROW_25_551 VGND VPWR sky130_fd_sc_hd__tapvpwrvgnd_1
XTAP_TAPCELL_ROW_53_882 VGND VPWR sky130_fd_sc_hd__tapvpwrvgnd_1
XTAP_TAPCELL_ROW_53_893 VGND VPWR sky130_fd_sc_hd__tapvpwrvgnd_1
XFILLER_0_25_615 VGND VGND VPWR VPWR sky130_fd_sc_hd__fill_1
XFILLER_0_37_486 VGND VGND VPWR VPWR sky130_fd_sc_hd__fill_2
XFILLER_0_25_637 VGND VGND VPWR VPWR sky130_fd_sc_hd__fill_2
XFILLER_0_24_169 VGND VGND VPWR VPWR sky130_fd_sc_hd__decap_3
XFILLER_0_52_489 VGND VGND VPWR VPWR sky130_fd_sc_hd__fill_1
XFILLER_0_32_191 VGND VGND VPWR VPWR sky130_fd_sc_hd__fill_2
XTAP_TAPCELL_ROW_88_1313 VGND VPWR sky130_fd_sc_hd__tapvpwrvgnd_1
XTAP_TAPCELL_ROW_88_1302 VGND VPWR sky130_fd_sc_hd__tapvpwrvgnd_1
X_5950_ _2596_ _2718_ _2722_ _2381_ VGND VGND VPWR VPWR _2723_ sky130_fd_sc_hd__o22ai_1
X_4901_ _1688_ _1689_ _1605_ VGND VGND VPWR VPWR _1690_ sky130_fd_sc_hd__mux2_1
XFILLER_0_1_69 VPWR VGND VPWR VGND sky130_ef_sc_hd__decap_12
X_7620_ _3768_ VGND VGND VPWR VPWR _0343_ sky130_fd_sc_hd__clkbuf_1
X_5881_ _2085_ _2176_ VGND VGND VPWR VPWR _2658_ sky130_fd_sc_hd__nand2_1
XFILLER_0_75_559 VGND VGND VPWR VPWR sky130_fd_sc_hd__fill_1
X_4832_ net1 VGND VGND VPWR VPWR _1621_ sky130_fd_sc_hd__buf_4
X_7551_ net639 _3371_ _3727_ VGND VGND VPWR VPWR _3732_ sky130_fd_sc_hd__mux2_1
XFILLER_0_90_507 VPWR VGND VPWR VGND sky130_ef_sc_hd__decap_12
X_4763_ RF.reg_arr\[16\]\[25\] RF.reg_arr\[17\]\[25\] RF.reg_arr\[18\]\[25\] RF.reg_arr\[19\]\[25\]
+ _1273_ _1275_ VGND VGND VPWR VPWR _1552_ sky130_fd_sc_hd__mux4_1
XFILLER_0_28_475 VGND VGND VPWR VPWR sky130_fd_sc_hd__fill_1
X_7482_ _3694_ VGND VGND VPWR VPWR _0279_ sky130_fd_sc_hd__clkbuf_1
XTAP_TAPCELL_ROW_99_1442 VGND VPWR sky130_fd_sc_hd__tapvpwrvgnd_1
X_6502_ net99 VGND VGND VPWR VPWR _3156_ sky130_fd_sc_hd__clkbuf_1
X_4694_ _1272_ _1474_ _1478_ _1482_ VGND VGND VPWR VPWR _1483_ sky130_fd_sc_hd__o2bb2a_2
XFILLER_0_28_486 VGND VGND VPWR VPWR sky130_fd_sc_hd__fill_2
X_6433_ _3120_ VGND VGND VPWR VPWR _0828_ sky130_fd_sc_hd__clkbuf_1
XFILLER_0_113_300 VGND VGND VPWR VPWR sky130_fd_sc_hd__fill_1
XFILLER_0_70_253 VGND VGND VPWR VPWR sky130_fd_sc_hd__fill_2
X_9221_ clknet_leaf_98_CLK _0454_ VGND VGND VPWR VPWR RF.reg_arr\[22\]\[7\] sky130_fd_sc_hd__dfxtp_1
XFILLER_0_113_344 VPWR VGND VPWR VGND sky130_ef_sc_hd__decap_12
XFILLER_0_101_517 VPWR VGND VPWR VGND sky130_ef_sc_hd__decap_12
X_9152_ clknet_leaf_58_CLK _0385_ VGND VGND VPWR VPWR RF.reg_arr\[9\]\[2\] sky130_fd_sc_hd__dfxtp_1
X_6364_ _3073_ net941 _3059_ VGND VGND VPWR VPWR _3074_ sky130_fd_sc_hd__mux2_1
X_9083_ clknet_leaf_30_CLK _0316_ VGND VGND VPWR VPWR RF.reg_arr\[28\]\[29\] sky130_fd_sc_hd__dfxtp_1
X_8103_ _4024_ VGND VGND VPWR VPWR _0570_ sky130_fd_sc_hd__clkbuf_1
X_5315_ _1584_ _2103_ VGND VGND VPWR VPWR _2104_ sky130_fd_sc_hd__or2_1
X_6295_ net20 VGND VGND VPWR VPWR _3029_ sky130_fd_sc_hd__buf_2
X_8034_ _2984_ net750 _3980_ VGND VGND VPWR VPWR _3988_ sky130_fd_sc_hd__mux2_1
X_5246_ _2031_ _2032_ _2033_ _2034_ _1863_ _1634_ VGND VGND VPWR VPWR _2035_ sky130_fd_sc_hd__mux4_1
XPHY_EDGE_ROW_89_Right_89 VGND VGND VPWR VPWR sky130_fd_sc_hd__decap_3
Xhold38 RF.reg_arr\[0\]\[7\] VGND VGND VPWR VPWR net120 sky130_fd_sc_hd__dlygate4sd3_1
Xhold27 RF.reg_arr\[0\]\[13\] VGND VGND VPWR VPWR net109 sky130_fd_sc_hd__dlygate4sd3_1
X_5177_ _1946_ _1965_ VGND VGND VPWR VPWR _1966_ sky130_fd_sc_hd__nand2_1
Xhold49 RF.reg_arr\[9\]\[22\] VGND VGND VPWR VPWR net131 sky130_fd_sc_hd__dlygate4sd3_1
X_8936_ clknet_leaf_10_CLK _0169_ VGND VGND VPWR VPWR RF.reg_arr\[29\]\[10\] sky130_fd_sc_hd__dfxtp_1
XFILLER_0_78_386 VGND VGND VPWR VPWR sky130_fd_sc_hd__decap_8
X_8867_ clknet_leaf_87_CLK _0100_ VGND VGND VPWR VPWR RF.reg_arr\[3\]\[5\] sky130_fd_sc_hd__dfxtp_1
XPHY_EDGE_ROW_98_Right_98 VGND VGND VPWR VPWR sky130_fd_sc_hd__decap_3
X_7818_ _3873_ VGND VGND VPWR VPWR _0436_ sky130_fd_sc_hd__clkbuf_1
XTAP_TAPCELL_ROW_22_510 VGND VPWR sky130_fd_sc_hd__tapvpwrvgnd_1
X_8798_ clknet_leaf_67_CLK _0031_ VGND VGND VPWR VPWR RF.reg_arr\[4\]\[0\] sky130_fd_sc_hd__dfxtp_1
X_7749_ net303 _3433_ _3835_ VGND VGND VPWR VPWR _3837_ sky130_fd_sc_hd__mux2_1
XTAP_TAPCELL_ROW_22_521 VGND VPWR sky130_fd_sc_hd__tapvpwrvgnd_1
XTAP_TAPCELL_ROW_50_852 VGND VPWR sky130_fd_sc_hd__tapvpwrvgnd_1
XFILLER_0_46_272 VGND VGND VPWR VPWR sky130_fd_sc_hd__fill_2
X_9419_ clknet_leaf_93_CLK _0652_ VGND VGND VPWR VPWR RF.reg_arr\[17\]\[13\] sky130_fd_sc_hd__dfxtp_1
XFILLER_0_21_117 VGND VGND VPWR VPWR sky130_fd_sc_hd__fill_1
XTAP_TAPCELL_ROW_72_1114 VGND VPWR sky130_fd_sc_hd__tapvpwrvgnd_1
XPHY_EDGE_ROW_5_Left_122 VGND VGND VPWR VPWR sky130_fd_sc_hd__decap_3
XFILLER_0_100_550 VGND VGND VPWR VPWR sky130_fd_sc_hd__decap_6
XFILLER_0_107_28 VGND VGND VPWR VPWR sky130_fd_sc_hd__fill_1
XTAP_TAPCELL_ROW_58_952 VGND VPWR sky130_fd_sc_hd__tapvpwrvgnd_1
XFILLER_0_16_15 VGND VGND VPWR VPWR sky130_fd_sc_hd__decap_8
XFILLER_0_96_172 VGND VGND VPWR VPWR sky130_fd_sc_hd__decap_4
XTAP_TAPCELL_ROW_83_1243 VGND VPWR sky130_fd_sc_hd__tapvpwrvgnd_1
XFILLER_0_57_559 VGND VGND VPWR VPWR sky130_fd_sc_hd__fill_1
XFILLER_0_72_518 VPWR VGND VPWR VGND sky130_ef_sc_hd__decap_12
XFILLER_0_65_570 VGND VGND VPWR VPWR sky130_fd_sc_hd__decap_6
XFILLER_0_115_609 VGND VGND VPWR VPWR sky130_fd_sc_hd__decap_6
XFILLER_0_4_306 VGND VGND VPWR VPWR sky130_fd_sc_hd__fill_2
XFILLER_0_52_253 VGND VGND VPWR VPWR sky130_fd_sc_hd__decap_6
Xhold508 RF.reg_arr\[24\]\[29\] VGND VGND VPWR VPWR net590 sky130_fd_sc_hd__dlygate4sd3_1
XFILLER_0_13_629 VGND VGND VPWR VPWR sky130_fd_sc_hd__decap_8
Xhold519 RF.reg_arr\[6\]\[21\] VGND VGND VPWR VPWR net601 sky130_fd_sc_hd__dlygate4sd3_1
XTAP_TAPCELL_ROW_94_1383 VGND VPWR sky130_fd_sc_hd__tapvpwrvgnd_1
XFILLER_0_21_673 VGND VGND VPWR VPWR sky130_fd_sc_hd__decap_3
X_6080_ _2820_ _2844_ _2366_ VGND VGND VPWR VPWR _2845_ sky130_fd_sc_hd__mux2_1
X_5100_ _1887_ _1888_ _1854_ VGND VGND VPWR VPWR _1889_ sky130_fd_sc_hd__mux2_1
XFILLER_0_0_589 VPWR VGND VPWR VGND sky130_ef_sc_hd__decap_12
X_5031_ _1039_ _1819_ VGND VGND VPWR VPWR _1820_ sky130_fd_sc_hd__nand2_1
XFILLER_0_57_66 VGND VGND VPWR VPWR sky130_fd_sc_hd__decap_3
XPHY_EDGE_ROW_69_Left_186 VGND VGND VPWR VPWR sky130_fd_sc_hd__decap_3
XTAP_TAPCELL_ROW_0_238 VGND VPWR sky130_fd_sc_hd__tapvpwrvgnd_1
XTAP_TAPCELL_ROW_0_249 VGND VPWR sky130_fd_sc_hd__tapvpwrvgnd_1
X_6982_ _3425_ VGND VGND VPWR VPWR _0048_ sky130_fd_sc_hd__clkbuf_1
X_8721_ clknet_leaf_7_CLK _0978_ VGND VGND VPWR VPWR RF.reg_arr\[14\]\[19\] sky130_fd_sc_hd__dfxtp_1
X_5933_ _2632_ _2706_ _2361_ VGND VGND VPWR VPWR _2707_ sky130_fd_sc_hd__mux2_1
XFILLER_0_75_301 VGND VGND VPWR VPWR sky130_fd_sc_hd__fill_1
X_5864_ _2638_ _2641_ VGND VGND VPWR VPWR _2642_ sky130_fd_sc_hd__xor2_1
X_8652_ clknet_leaf_96_CLK _0909_ VGND VGND VPWR VPWR RF.reg_arr\[8\]\[14\] sky130_fd_sc_hd__dfxtp_1
XTAP_TAPCELL_ROW_36_679 VGND VPWR sky130_fd_sc_hd__tapvpwrvgnd_1
X_4815_ _1603_ VGND VGND VPWR VPWR _1604_ sky130_fd_sc_hd__clkbuf_8
XFILLER_0_8_645 VGND VGND VPWR VPWR sky130_fd_sc_hd__fill_1
X_7603_ _3759_ VGND VGND VPWR VPWR _0335_ sky130_fd_sc_hd__clkbuf_1
X_8583_ clknet_leaf_65_CLK _0840_ VGND VGND VPWR VPWR RF.reg_arr\[0\]\[9\] sky130_fd_sc_hd__dfxtp_1
XTAP_TAPCELL_ROW_103_1490 VGND VPWR sky130_fd_sc_hd__tapvpwrvgnd_1
X_5795_ _2543_ _2542_ _2551_ _2575_ VGND VGND VPWR VPWR _2576_ sky130_fd_sc_hd__a211o_1
X_7534_ net207 _3422_ _3716_ VGND VGND VPWR VPWR _3723_ sky130_fd_sc_hd__mux2_1
XFILLER_0_71_540 VPWR VGND VPWR VGND sky130_ef_sc_hd__decap_12
X_4746_ RF.reg_arr\[16\]\[15\] RF.reg_arr\[17\]\[15\] RF.reg_arr\[18\]\[15\] RF.reg_arr\[19\]\[15\]
+ _1134_ _1135_ VGND VGND VPWR VPWR _1535_ sky130_fd_sc_hd__mux4_1
X_4677_ _1282_ _1465_ _1163_ VGND VGND VPWR VPWR _1466_ sky130_fd_sc_hd__o21ai_1
XPHY_EDGE_ROW_78_Left_195 VGND VGND VPWR VPWR sky130_fd_sc_hd__decap_3
XFILLER_0_43_264 VGND VGND VPWR VPWR sky130_fd_sc_hd__fill_1
X_7465_ _3685_ VGND VGND VPWR VPWR _0271_ sky130_fd_sc_hd__clkbuf_1
X_6416_ net30 VGND VGND VPWR VPWR _3109_ sky130_fd_sc_hd__clkbuf_2
XFILLER_0_101_314 VGND VGND VPWR VPWR sky130_fd_sc_hd__decap_6
X_9204_ clknet_leaf_62_CLK _0437_ VGND VGND VPWR VPWR RF.reg_arr\[24\]\[22\] sky130_fd_sc_hd__dfxtp_1
XFILLER_0_3_372 VPWR VGND VPWR VGND sky130_ef_sc_hd__decap_12
X_7396_ _3648_ VGND VGND VPWR VPWR _0239_ sky130_fd_sc_hd__clkbuf_1
X_6347_ _3062_ VGND VGND VPWR VPWR _0800_ sky130_fd_sc_hd__clkbuf_1
X_9135_ clknet_leaf_106_CLK _0368_ VGND VGND VPWR VPWR RF.reg_arr\[30\]\[17\] sky130_fd_sc_hd__dfxtp_1
XTAP_TAPCELL_ROW_8_349 VGND VPWR sky130_fd_sc_hd__tapvpwrvgnd_1
X_9066_ clknet_leaf_99_CLK _0299_ VGND VGND VPWR VPWR RF.reg_arr\[28\]\[12\] sky130_fd_sc_hd__dfxtp_1
X_6278_ _3017_ VGND VGND VPWR VPWR _0776_ sky130_fd_sc_hd__clkbuf_1
X_8017_ _3037_ net1013 _3969_ VGND VGND VPWR VPWR _3979_ sky130_fd_sc_hd__mux2_1
X_5229_ RF.reg_arr\[12\]\[3\] RF.reg_arr\[13\]\[3\] RF.reg_arr\[14\]\[3\] RF.reg_arr\[15\]\[3\]
+ _1229_ _1230_ VGND VGND VPWR VPWR _2018_ sky130_fd_sc_hd__mux4_1
XFILLER_0_98_415 VGND VGND VPWR VPWR sky130_fd_sc_hd__decap_4
XTAP_TAPCELL_ROW_55_911 VGND VPWR sky130_fd_sc_hd__tapvpwrvgnd_1
XTAP_TAPCELL_ROW_106_1519 VGND VPWR sky130_fd_sc_hd__tapvpwrvgnd_1
X_8919_ clknet_leaf_37_CLK _0152_ VGND VGND VPWR VPWR RF.reg_arr\[7\]\[25\] sky130_fd_sc_hd__dfxtp_1
XFILLER_0_109_447 VGND VGND VPWR VPWR sky130_fd_sc_hd__fill_1
XFILLER_0_47_592 VGND VGND VPWR VPWR sky130_fd_sc_hd__fill_2
XFILLER_0_105_653 VPWR VGND VPWR VGND sky130_ef_sc_hd__decap_12
XFILLER_0_34_253 VGND VGND VPWR VPWR sky130_fd_sc_hd__fill_2
XFILLER_0_104_141 VGND VGND VPWR VPWR sky130_fd_sc_hd__fill_2
XFILLER_0_89_415 VGND VGND VPWR VPWR sky130_fd_sc_hd__fill_2
Xmax_cap81 _2643_ VGND VGND VPWR VPWR net81 sky130_fd_sc_hd__buf_2
XFILLER_0_43_24 VGND VGND VPWR VPWR sky130_fd_sc_hd__decap_3
XFILLER_0_57_301 VGND VGND VPWR VPWR sky130_fd_sc_hd__decap_3
XFILLER_0_57_345 VGND VGND VPWR VPWR sky130_fd_sc_hd__fill_1
XTAP_TAPCELL_ROW_33_649 VGND VPWR sky130_fd_sc_hd__tapvpwrvgnd_1
XFILLER_0_57_378 VGND VGND VPWR VPWR sky130_fd_sc_hd__fill_2
XFILLER_0_84_197 VGND VGND VPWR VPWR sky130_fd_sc_hd__decap_6
XFILLER_0_72_326 VGND VGND VPWR VPWR sky130_fd_sc_hd__fill_1
X_4600_ RF.reg_arr\[20\]\[6\] RF.reg_arr\[21\]\[6\] RF.reg_arr\[22\]\[6\] RF.reg_arr\[23\]\[6\]
+ net93 _1094_ VGND VGND VPWR VPWR _1389_ sky130_fd_sc_hd__mux4_1
XFILLER_0_111_3 VPWR VGND VPWR VGND sky130_ef_sc_hd__decap_12
X_5580_ _2366_ _2367_ VGND VGND VPWR VPWR _2368_ sky130_fd_sc_hd__or2_1
XTAP_TAPCELL_ROW_96_1401 VGND VPWR sky130_fd_sc_hd__tapvpwrvgnd_1
XFILLER_0_4_114 VGND VGND VPWR VPWR sky130_fd_sc_hd__fill_1
XFILLER_0_87_9 VGND VGND VPWR VPWR sky130_fd_sc_hd__decap_3
X_4531_ RF.reg_arr\[24\]\[23\] RF.reg_arr\[25\]\[23\] RF.reg_arr\[26\]\[23\] RF.reg_arr\[27\]\[23\]
+ _1316_ _1304_ VGND VGND VPWR VPWR _1320_ sky130_fd_sc_hd__mux4_1
XFILLER_0_13_426 VGND VGND VPWR VPWR sky130_fd_sc_hd__decap_8
X_7250_ _3571_ VGND VGND VPWR VPWR _0170_ sky130_fd_sc_hd__clkbuf_1
Xhold305 RF.reg_arr\[10\]\[7\] VGND VGND VPWR VPWR net387 sky130_fd_sc_hd__dlygate4sd3_1
Xhold316 RF.reg_arr\[3\]\[8\] VGND VGND VPWR VPWR net398 sky130_fd_sc_hd__dlygate4sd3_1
X_4462_ RF.reg_arr\[4\]\[10\] RF.reg_arr\[5\]\[10\] RF.reg_arr\[6\]\[10\] RF.reg_arr\[7\]\[10\]
+ _1043_ _1083_ VGND VGND VPWR VPWR _1251_ sky130_fd_sc_hd__mux4_1
XFILLER_0_111_645 VGND VGND VPWR VPWR sky130_fd_sc_hd__decap_6
XFILLER_0_111_634 VGND VGND VPWR VPWR sky130_fd_sc_hd__fill_2
X_6201_ _2955_ VGND VGND VPWR VPWR _2959_ sky130_fd_sc_hd__inv_2
Xhold338 RF.reg_arr\[26\]\[23\] VGND VGND VPWR VPWR net420 sky130_fd_sc_hd__dlygate4sd3_1
Xhold327 RF.reg_arr\[6\]\[22\] VGND VGND VPWR VPWR net409 sky130_fd_sc_hd__dlygate4sd3_1
XFILLER_0_68_32 VGND VGND VPWR VPWR sky130_fd_sc_hd__fill_1
XFILLER_0_7_46 VGND VGND VPWR VPWR sky130_fd_sc_hd__decap_8
Xhold349 RF.reg_arr\[25\]\[9\] VGND VGND VPWR VPWR net431 sky130_fd_sc_hd__dlygate4sd3_1
XFILLER_0_40_278 VGND VGND VPWR VPWR sky130_fd_sc_hd__fill_1
XFILLER_0_68_54 VGND VGND VPWR VPWR sky130_fd_sc_hd__decap_6
X_7181_ _3534_ VGND VGND VPWR VPWR _0138_ sky130_fd_sc_hd__clkbuf_1
X_4393_ RF.reg_arr\[12\]\[19\] RF.reg_arr\[13\]\[19\] RF.reg_arr\[14\]\[19\] RF.reg_arr\[15\]\[19\]
+ _1164_ _1165_ VGND VGND VPWR VPWR _1182_ sky130_fd_sc_hd__mux4_1
X_6132_ _2892_ _2894_ VGND VGND VPWR VPWR _2895_ sky130_fd_sc_hd__nor2_1
XTAP_TAPCELL_ROW_5_308 VGND VPWR sky130_fd_sc_hd__tapvpwrvgnd_1
X_6063_ _2828_ _2547_ _1333_ VGND VGND VPWR VPWR _2829_ sky130_fd_sc_hd__a21o_1
Xhold1005 RF.reg_arr\[15\]\[17\] VGND VGND VPWR VPWR net1087 sky130_fd_sc_hd__dlygate4sd3_1
Xhold1016 RF.reg_arr\[27\]\[26\] VGND VGND VPWR VPWR net1098 sky130_fd_sc_hd__dlygate4sd3_1
X_5014_ _1605_ _1802_ _1618_ VGND VGND VPWR VPWR _1803_ sky130_fd_sc_hd__a21o_1
XFILLER_0_84_42 VGND VGND VPWR VPWR sky130_fd_sc_hd__decap_4
Xhold1027 RF.reg_arr\[30\]\[0\] VGND VGND VPWR VPWR net1109 sky130_fd_sc_hd__dlygate4sd3_1
Xhold1038 RF.reg_arr\[14\]\[19\] VGND VGND VPWR VPWR net1120 sky130_fd_sc_hd__dlygate4sd3_1
XFILLER_0_108_93 VGND VGND VPWR VPWR sky130_fd_sc_hd__fill_1
XFILLER_0_16_3 VPWR VGND VPWR VGND sky130_ef_sc_hd__decap_12
X_6965_ net17 VGND VGND VPWR VPWR _3414_ sky130_fd_sc_hd__buf_2
X_5916_ _1517_ _2666_ _2547_ VGND VGND VPWR VPWR _2691_ sky130_fd_sc_hd__o21ai_1
X_8704_ clknet_leaf_65_CLK _0961_ VGND VGND VPWR VPWR RF.reg_arr\[14\]\[2\] sky130_fd_sc_hd__dfxtp_1
X_8635_ clknet_leaf_33_CLK _0892_ VGND VGND VPWR VPWR RF.reg_arr\[16\]\[29\] sky130_fd_sc_hd__dfxtp_1
X_6896_ net263 _3042_ _3366_ VGND VGND VPWR VPWR _3368_ sky130_fd_sc_hd__mux2_1
XFILLER_0_76_687 VGND VGND VPWR VPWR sky130_fd_sc_hd__fill_1
XFILLER_0_91_646 VGND VGND VPWR VPWR sky130_fd_sc_hd__decap_6
XFILLER_0_91_635 VGND VGND VPWR VPWR sky130_fd_sc_hd__fill_2
X_5847_ _2581_ _2611_ _2625_ VGND VGND VPWR VPWR _2626_ sky130_fd_sc_hd__a21oi_1
XFILLER_0_8_442 VGND VGND VPWR VPWR sky130_fd_sc_hd__fill_1
X_8566_ clknet_leaf_52_CLK _0823_ VGND VGND VPWR VPWR RF.reg_arr\[23\]\[24\] sky130_fd_sc_hd__dfxtp_1
XPHY_EDGE_ROW_86_Left_203 VGND VGND VPWR VPWR sky130_fd_sc_hd__decap_3
X_5778_ _2508_ _2559_ _1737_ VGND VGND VPWR VPWR _2560_ sky130_fd_sc_hd__mux2_1
X_8497_ _4232_ VGND VGND VPWR VPWR _0756_ sky130_fd_sc_hd__clkbuf_1
X_4729_ RF.reg_arr\[20\]\[14\] RF.reg_arr\[21\]\[14\] RF.reg_arr\[22\]\[14\] RF.reg_arr\[23\]\[14\]
+ _1117_ _1118_ VGND VGND VPWR VPWR _1518_ sky130_fd_sc_hd__mux4_1
X_7517_ net589 _3405_ _3705_ VGND VGND VPWR VPWR _3714_ sky130_fd_sc_hd__mux2_1
XFILLER_0_16_264 VGND VGND VPWR VPWR sky130_fd_sc_hd__decap_6
X_7448_ _3676_ VGND VGND VPWR VPWR _0263_ sky130_fd_sc_hd__clkbuf_1
XFILLER_0_102_645 VGND VGND VPWR VPWR sky130_fd_sc_hd__decap_3
Xhold850 RF.reg_arr\[31\]\[29\] VGND VGND VPWR VPWR net932 sky130_fd_sc_hd__dlygate4sd3_1
Xhold861 RF.reg_arr\[16\]\[31\] VGND VGND VPWR VPWR net943 sky130_fd_sc_hd__dlygate4sd3_1
X_7379_ _3639_ VGND VGND VPWR VPWR _0231_ sky130_fd_sc_hd__clkbuf_1
Xhold872 RF.reg_arr\[18\]\[0\] VGND VGND VPWR VPWR net954 sky130_fd_sc_hd__dlygate4sd3_1
Xhold894 RF.reg_arr\[31\]\[27\] VGND VGND VPWR VPWR net976 sky130_fd_sc_hd__dlygate4sd3_1
Xhold883 RF.reg_arr\[16\]\[7\] VGND VGND VPWR VPWR net965 sky130_fd_sc_hd__dlygate4sd3_1
X_9118_ clknet_leaf_74_CLK _0351_ VGND VGND VPWR VPWR RF.reg_arr\[30\]\[0\] sky130_fd_sc_hd__dfxtp_1
X_9049_ clknet_leaf_32_CLK _0282_ VGND VGND VPWR VPWR RF.reg_arr\[26\]\[27\] sky130_fd_sc_hd__dfxtp_1
XPHY_EDGE_ROW_95_Left_212 VGND VGND VPWR VPWR sky130_fd_sc_hd__decap_3
XFILLER_0_98_201 VGND VGND VPWR VPWR sky130_fd_sc_hd__fill_1
XTAP_TAPCELL_ROW_67_1057 VGND VPWR sky130_fd_sc_hd__tapvpwrvgnd_1
XFILLER_0_67_621 VGND VGND VPWR VPWR sky130_fd_sc_hd__fill_1
XFILLER_0_104_29 VGND VGND VPWR VPWR sky130_fd_sc_hd__decap_6
XTAP_TAPCELL_ROW_80_1213 VGND VPWR sky130_fd_sc_hd__tapvpwrvgnd_1
XFILLER_0_109_255 VPWR VGND VPWR VGND sky130_ef_sc_hd__decap_12
XFILLER_0_81_101 VGND VGND VPWR VPWR sky130_fd_sc_hd__fill_2
XFILLER_0_66_186 VGND VGND VPWR VPWR sky130_fd_sc_hd__fill_2
XTAP_TAPCELL_ROW_30_608 VGND VPWR sky130_fd_sc_hd__tapvpwrvgnd_1
XTAP_TAPCELL_ROW_10_376 VGND VPWR sky130_fd_sc_hd__tapvpwrvgnd_1
XFILLER_0_22_223 VGND VGND VPWR VPWR sky130_fd_sc_hd__fill_2
XFILLER_0_22_234 VGND VGND VPWR VPWR sky130_fd_sc_hd__fill_2
XTAP_TAPCELL_ROW_78_1186 VGND VPWR sky130_fd_sc_hd__tapvpwrvgnd_1
XFILLER_0_50_565 VGND VGND VPWR VPWR sky130_fd_sc_hd__fill_1
XTAP_TAPCELL_ROW_91_1342 VGND VPWR sky130_fd_sc_hd__tapvpwrvgnd_1
XFILLER_0_38_46 VGND VGND VPWR VPWR sky130_fd_sc_hd__fill_1
XTAP_TAPCELL_ROW_38_708 VGND VPWR sky130_fd_sc_hd__tapvpwrvgnd_1
XFILLER_0_89_234 VGND VGND VPWR VPWR sky130_fd_sc_hd__fill_2
XFILLER_0_58_632 VGND VGND VPWR VPWR sky130_fd_sc_hd__fill_1
X_6750_ _3289_ VGND VGND VPWR VPWR _0976_ sky130_fd_sc_hd__clkbuf_1
XTAP_TAPCELL_ROW_18_465 VGND VPWR sky130_fd_sc_hd__tapvpwrvgnd_1
X_5701_ _2002_ _2196_ _1831_ VGND VGND VPWR VPWR _2486_ sky130_fd_sc_hd__mux2_1
X_6681_ _3096_ net1122 _3243_ VGND VGND VPWR VPWR _3252_ sky130_fd_sc_hd__mux2_1
XFILLER_0_115_203 VGND VGND VPWR VPWR sky130_fd_sc_hd__decap_3
X_5632_ _2029_ _2312_ VGND VGND VPWR VPWR _2419_ sky130_fd_sc_hd__or2_1
X_8420_ _4192_ VGND VGND VPWR VPWR _0719_ sky130_fd_sc_hd__clkbuf_1
X_5563_ _1113_ _1697_ VGND VGND VPWR VPWR _2351_ sky130_fd_sc_hd__and2_1
XFILLER_0_72_178 VGND VGND VPWR VPWR sky130_fd_sc_hd__fill_2
X_8351_ _3031_ net895 _4149_ VGND VGND VPWR VPWR _4156_ sky130_fd_sc_hd__mux2_1
X_4514_ _1302_ VGND VGND VPWR VPWR _1303_ sky130_fd_sc_hd__buf_4
XFILLER_0_79_53 VGND VGND VPWR VPWR sky130_fd_sc_hd__decap_3
X_7302_ _3067_ net1110 _3594_ VGND VGND VPWR VPWR _3599_ sky130_fd_sc_hd__mux2_1
Xhold113 RF.reg_arr\[17\]\[29\] VGND VGND VPWR VPWR net195 sky130_fd_sc_hd__dlygate4sd3_1
Xhold124 RF.reg_arr\[6\]\[26\] VGND VGND VPWR VPWR net206 sky130_fd_sc_hd__dlygate4sd3_1
X_8282_ _4119_ VGND VGND VPWR VPWR _0654_ sky130_fd_sc_hd__clkbuf_1
Xhold135 RF.reg_arr\[19\]\[5\] VGND VGND VPWR VPWR net217 sky130_fd_sc_hd__dlygate4sd3_1
Xhold102 RF.reg_arr\[3\]\[0\] VGND VGND VPWR VPWR net184 sky130_fd_sc_hd__dlygate4sd3_1
X_5494_ _2279_ _2282_ _1634_ VGND VGND VPWR VPWR _2283_ sky130_fd_sc_hd__mux2_1
Xhold157 RF.reg_arr\[18\]\[9\] VGND VGND VPWR VPWR net239 sky130_fd_sc_hd__dlygate4sd3_1
Xhold146 RF.reg_arr\[9\]\[14\] VGND VGND VPWR VPWR net228 sky130_fd_sc_hd__dlygate4sd3_1
Xhold168 RF.reg_arr\[6\]\[8\] VGND VGND VPWR VPWR net250 sky130_fd_sc_hd__dlygate4sd3_1
X_4445_ net6 _1233_ net7 VGND VGND VPWR VPWR _1234_ sky130_fd_sc_hd__o21a_1
X_7233_ _3562_ VGND VGND VPWR VPWR _0162_ sky130_fd_sc_hd__clkbuf_1
Xhold179 RF.reg_arr\[11\]\[20\] VGND VGND VPWR VPWR net261 sky130_fd_sc_hd__dlygate4sd3_1
X_4376_ _1118_ VGND VGND VPWR VPWR _1165_ sky130_fd_sc_hd__buf_4
XFILLER_0_0_150 VGND VGND VPWR VPWR sky130_fd_sc_hd__fill_2
XFILLER_0_0_161 VGND VGND VPWR VPWR sky130_fd_sc_hd__decap_4
XFILLER_0_1_673 VPWR VGND VPWR VGND sky130_ef_sc_hd__decap_12
X_7164_ _3525_ VGND VGND VPWR VPWR _0130_ sky130_fd_sc_hd__clkbuf_1
X_6115_ _2200_ _2807_ _2878_ _2421_ VGND VGND VPWR VPWR _2879_ sky130_fd_sc_hd__a22o_1
XFILLER_0_95_52 VGND VGND VPWR VPWR sky130_fd_sc_hd__decap_4
X_7095_ net143 _3395_ _3485_ VGND VGND VPWR VPWR _3489_ sky130_fd_sc_hd__mux2_1
X_6046_ _1383_ _2812_ VGND VGND VPWR VPWR _2813_ sky130_fd_sc_hd__xnor2_2
X_7997_ _3968_ VGND VGND VPWR VPWR _0520_ sky130_fd_sc_hd__clkbuf_1
X_6948_ _3402_ VGND VGND VPWR VPWR _0037_ sky130_fd_sc_hd__clkbuf_1
XFILLER_0_63_101 VGND VGND VPWR VPWR sky130_fd_sc_hd__decap_4
X_6879_ net472 _3025_ _3355_ VGND VGND VPWR VPWR _3359_ sky130_fd_sc_hd__mux2_1
X_8618_ clknet_leaf_98_CLK _0875_ VGND VGND VPWR VPWR RF.reg_arr\[16\]\[12\] sky130_fd_sc_hd__dfxtp_1
XFILLER_0_8_261 VGND VGND VPWR VPWR sky130_fd_sc_hd__decap_3
XFILLER_0_8_250 VGND VGND VPWR VPWR sky130_fd_sc_hd__fill_2
XFILLER_0_48_197 VGND VGND VPWR VPWR sky130_fd_sc_hd__decap_3
XFILLER_0_106_225 VGND VGND VPWR VPWR sky130_fd_sc_hd__fill_1
XFILLER_0_63_178 VGND VGND VPWR VPWR sky130_fd_sc_hd__fill_1
X_8549_ clknet_leaf_98_CLK _0806_ VGND VGND VPWR VPWR RF.reg_arr\[23\]\[7\] sky130_fd_sc_hd__dfxtp_1
XTAP_TAPCELL_ROW_114_1618 VGND VPWR sky130_fd_sc_hd__tapvpwrvgnd_1
XFILLER_0_32_587 VGND VGND VPWR VPWR sky130_fd_sc_hd__fill_1
XFILLER_0_5_3 VPWR VGND VPWR VGND sky130_ef_sc_hd__decap_12
Xhold680 RF.reg_arr\[30\]\[10\] VGND VGND VPWR VPWR net762 sky130_fd_sc_hd__dlygate4sd3_1
Xhold691 RF.reg_arr\[14\]\[4\] VGND VGND VPWR VPWR net773 sky130_fd_sc_hd__dlygate4sd3_1
XFILLER_0_99_521 VGND VGND VPWR VPWR sky130_fd_sc_hd__decap_3
XFILLER_0_115_39 VPWR VGND VPWR VGND sky130_ef_sc_hd__decap_12
XFILLER_0_86_248 VGND VGND VPWR VPWR sky130_fd_sc_hd__decap_4
XTAP_TAPCELL_ROW_15_435 VGND VPWR sky130_fd_sc_hd__tapvpwrvgnd_1
XFILLER_0_39_142 VGND VGND VPWR VPWR sky130_fd_sc_hd__fill_1
XTAP_TAPCELL_ROW_43_766 VGND VPWR sky130_fd_sc_hd__tapvpwrvgnd_1
XFILLER_0_27_337 VGND VGND VPWR VPWR sky130_fd_sc_hd__decap_3
XFILLER_0_27_348 VGND VGND VPWR VPWR sky130_fd_sc_hd__decap_8
XFILLER_0_70_638 VGND VGND VPWR VPWR sky130_fd_sc_hd__decap_3
XFILLER_0_23_521 VGND VGND VPWR VPWR sky130_fd_sc_hd__fill_2
XFILLER_0_50_395 VPWR VGND VPWR VGND sky130_ef_sc_hd__decap_12
X_7920_ _3008_ net864 _3922_ VGND VGND VPWR VPWR _3928_ sky130_fd_sc_hd__mux2_1
X_7851_ _3891_ VGND VGND VPWR VPWR _0451_ sky130_fd_sc_hd__clkbuf_1
X_6802_ _3317_ VGND VGND VPWR VPWR _1000_ sky130_fd_sc_hd__clkbuf_1
X_4994_ _1781_ _1782_ _1605_ VGND VGND VPWR VPWR _1783_ sky130_fd_sc_hd__mux2_1
X_7782_ _3854_ VGND VGND VPWR VPWR _0419_ sky130_fd_sc_hd__clkbuf_1
XFILLER_0_14_81 VGND VGND VPWR VPWR sky130_fd_sc_hd__decap_3
X_6733_ _3280_ VGND VGND VPWR VPWR _0968_ sky130_fd_sc_hd__clkbuf_1
X_9521_ clknet_leaf_7_CLK _0754_ VGND VGND VPWR VPWR RF.reg_arr\[10\]\[19\] sky130_fd_sc_hd__dfxtp_1
XFILLER_0_116_501 VGND VGND VPWR VPWR sky130_fd_sc_hd__decap_3
XFILLER_0_85_281 VPWR VGND VPWR VGND sky130_ef_sc_hd__decap_12
XFILLER_0_73_432 VPWR VGND VPWR VGND sky130_ef_sc_hd__decap_12
XFILLER_0_18_337 VGND VGND VPWR VPWR sky130_fd_sc_hd__fill_1
XFILLER_0_18_359 VGND VGND VPWR VPWR sky130_fd_sc_hd__decap_4
X_9452_ clknet_leaf_93_CLK _0685_ VGND VGND VPWR VPWR RF.reg_arr\[12\]\[14\] sky130_fd_sc_hd__dfxtp_1
X_6664_ _3231_ VGND VGND VPWR VPWR _3243_ sky130_fd_sc_hd__clkbuf_8
X_5615_ _1667_ _2254_ VGND VGND VPWR VPWR _2403_ sky130_fd_sc_hd__nand2_1
X_8403_ _4183_ VGND VGND VPWR VPWR _0711_ sky130_fd_sc_hd__clkbuf_1
XFILLER_0_5_264 VGND VGND VPWR VPWR sky130_fd_sc_hd__fill_2
X_9383_ clknet_leaf_64_CLK _0616_ VGND VGND VPWR VPWR RF.reg_arr\[13\]\[9\] sky130_fd_sc_hd__dfxtp_1
X_6595_ _3206_ VGND VGND VPWR VPWR _0904_ sky130_fd_sc_hd__clkbuf_1
X_5546_ _2200_ _2275_ _2333_ _2334_ VGND VGND VPWR VPWR _2335_ sky130_fd_sc_hd__a211o_1
X_8334_ _3014_ net831 _4138_ VGND VGND VPWR VPWR _4147_ sky130_fd_sc_hd__mux2_1
X_8265_ _4110_ VGND VGND VPWR VPWR _0646_ sky130_fd_sc_hd__clkbuf_1
X_5477_ _1845_ _2265_ VGND VGND VPWR VPWR _2266_ sky130_fd_sc_hd__nand2_1
X_7216_ _3552_ VGND VGND VPWR VPWR _0155_ sky130_fd_sc_hd__clkbuf_1
X_4428_ _1215_ _1216_ _1075_ VGND VGND VPWR VPWR _1217_ sky130_fd_sc_hd__mux2_1
X_8196_ _3012_ net686 _4066_ VGND VGND VPWR VPWR _4074_ sky130_fd_sc_hd__mux2_1
X_7147_ net583 _3379_ _3507_ VGND VGND VPWR VPWR _3516_ sky130_fd_sc_hd__mux2_1
X_4359_ RF.reg_arr\[24\]\[17\] RF.reg_arr\[25\]\[17\] RF.reg_arr\[26\]\[17\] RF.reg_arr\[27\]\[17\]
+ _1117_ _1118_ VGND VGND VPWR VPWR _1148_ sky130_fd_sc_hd__mux4_1
X_7078_ _3479_ VGND VGND VPWR VPWR _0090_ sky130_fd_sc_hd__clkbuf_1
X_6029_ _1911_ _2788_ VGND VGND VPWR VPWR _2797_ sky130_fd_sc_hd__nor2_1
XTAP_TAPCELL_ROW_64_1016 VGND VPWR sky130_fd_sc_hd__tapvpwrvgnd_1
XFILLER_0_64_421 VGND VGND VPWR VPWR sky130_fd_sc_hd__decap_3
XFILLER_0_9_570 VGND VGND VPWR VPWR sky130_fd_sc_hd__fill_2
XTAP_TAPCELL_ROW_40_736 VGND VPWR sky130_fd_sc_hd__tapvpwrvgnd_1
XFILLER_0_91_284 VGND VGND VPWR VPWR sky130_fd_sc_hd__fill_1
XTAP_TAPCELL_ROW_20_493 VGND VPWR sky130_fd_sc_hd__tapvpwrvgnd_1
XTAP_TAPCELL_ROW_75_1156 VGND VPWR sky130_fd_sc_hd__tapvpwrvgnd_1
XTAP_TAPCELL_ROW_48_825 VGND VPWR sky130_fd_sc_hd__tapvpwrvgnd_1
XFILLER_0_87_502 VGND VGND VPWR VPWR sky130_fd_sc_hd__fill_2
XPHY_EDGE_ROW_32_Left_149 VGND VGND VPWR VPWR sky130_fd_sc_hd__decap_3
XFILLER_0_87_535 VGND VGND VPWR VPWR sky130_fd_sc_hd__fill_1
XTAP_TAPCELL_ROW_86_1285 VGND VPWR sky130_fd_sc_hd__tapvpwrvgnd_1
XFILLER_0_59_259 VGND VGND VPWR VPWR sky130_fd_sc_hd__fill_1
XFILLER_0_59_248 VGND VGND VPWR VPWR sky130_fd_sc_hd__decap_3
XTAP_TAPCELL_ROW_28_582 VGND VPWR sky130_fd_sc_hd__tapvpwrvgnd_1
XTAP_TAPCELL_ROW_28_593 VGND VPWR sky130_fd_sc_hd__tapvpwrvgnd_1
XFILLER_0_67_270 VGND VGND VPWR VPWR sky130_fd_sc_hd__fill_1
XFILLER_0_67_281 VGND VGND VPWR VPWR sky130_fd_sc_hd__decap_4
XFILLER_0_55_443 VGND VGND VPWR VPWR sky130_fd_sc_hd__decap_4
XFILLER_0_70_446 VGND VGND VPWR VPWR sky130_fd_sc_hd__decap_4
Xclkload44 clknet_leaf_32_CLK VGND VGND VPWR VPWR clkload44/Y sky130_fd_sc_hd__clkinv_4
Xclkload33 clknet_leaf_23_CLK VGND VGND VPWR VPWR clkload33/Y sky130_fd_sc_hd__bufinv_16
Xclkload22 clknet_leaf_13_CLK VGND VGND VPWR VPWR clkload22/X sky130_fd_sc_hd__clkbuf_4
X_6380_ _3084_ net859 _3080_ VGND VGND VPWR VPWR _3085_ sky130_fd_sc_hd__mux2_1
Xclkbuf_3_5__f_CLK clknet_0_CLK VGND VGND VPWR VPWR clknet_3_5__leaf_CLK sky130_fd_sc_hd__clkbuf_16
XPHY_EDGE_ROW_41_Left_158 VGND VGND VPWR VPWR sky130_fd_sc_hd__decap_3
X_5400_ RF.reg_arr\[0\]\[13\] RF.reg_arr\[1\]\[13\] RF.reg_arr\[2\]\[13\] RF.reg_arr\[3\]\[13\]
+ _1846_ _1849_ VGND VGND VPWR VPWR _2189_ sky130_fd_sc_hd__mux4_1
XFILLER_0_51_660 VGND VGND VPWR VPWR sky130_fd_sc_hd__fill_2
Xclkload11 clknet_leaf_6_CLK VGND VGND VPWR VPWR clkload11/Y sky130_fd_sc_hd__inv_8
XFILLER_0_113_559 VGND VGND VPWR VPWR sky130_fd_sc_hd__fill_1
XFILLER_0_11_502 VGND VGND VPWR VPWR sky130_fd_sc_hd__fill_2
Xclkload66 clknet_leaf_98_CLK VGND VGND VPWR VPWR clkload66/Y sky130_fd_sc_hd__inv_8
Xclkload55 clknet_leaf_84_CLK VGND VGND VPWR VPWR clkload55/Y sky130_fd_sc_hd__clkinv_4
Xclkload77 clknet_leaf_79_CLK VGND VGND VPWR VPWR clkload77/Y sky130_fd_sc_hd__clkinv_4
X_5331_ _1642_ _2111_ _2115_ _2119_ VGND VGND VPWR VPWR _2120_ sky130_fd_sc_hd__a2bb2o_2
Xclkload88 clknet_leaf_51_CLK VGND VGND VPWR VPWR clkload88/Y sky130_fd_sc_hd__clkinvlp_4
Xclkload99 clknet_leaf_59_CLK VGND VGND VPWR VPWR clkload99/Y sky130_fd_sc_hd__clkinv_8
X_8050_ _3002_ net1005 _3994_ VGND VGND VPWR VPWR _3997_ sky130_fd_sc_hd__mux2_1
X_5262_ _2050_ VGND VGND VPWR VPWR _2051_ sky130_fd_sc_hd__buf_2
X_7001_ _3438_ VGND VGND VPWR VPWR _0054_ sky130_fd_sc_hd__clkbuf_1
X_5193_ RF.reg_arr\[24\]\[17\] RF.reg_arr\[25\]\[17\] RF.reg_arr\[26\]\[17\] RF.reg_arr\[27\]\[17\]
+ _1883_ _1885_ VGND VGND VPWR VPWR _1982_ sky130_fd_sc_hd__mux4_1
XPHY_EDGE_ROW_50_Left_167 VGND VGND VPWR VPWR sky130_fd_sc_hd__decap_3
X_8952_ clknet_leaf_34_CLK _0185_ VGND VGND VPWR VPWR RF.reg_arr\[29\]\[26\] sky130_fd_sc_hd__dfxtp_1
X_7903_ _3918_ VGND VGND VPWR VPWR _0476_ sky130_fd_sc_hd__clkbuf_1
X_8883_ clknet_leaf_47_CLK _0116_ VGND VGND VPWR VPWR RF.reg_arr\[3\]\[21\] sky130_fd_sc_hd__dfxtp_1
X_7834_ _3881_ VGND VGND VPWR VPWR _0444_ sky130_fd_sc_hd__clkbuf_1
XFILLER_0_93_505 VGND VGND VPWR VPWR sky130_fd_sc_hd__fill_1
X_7765_ net456 _3381_ _3835_ VGND VGND VPWR VPWR _3845_ sky130_fd_sc_hd__mux2_1
X_4977_ _1764_ _1765_ _1613_ VGND VGND VPWR VPWR _1766_ sky130_fd_sc_hd__mux2_1
X_9504_ clknet_leaf_61_CLK _0737_ VGND VGND VPWR VPWR RF.reg_arr\[10\]\[2\] sky130_fd_sc_hd__dfxtp_1
X_6716_ _3061_ net335 _3270_ VGND VGND VPWR VPWR _3272_ sky130_fd_sc_hd__mux2_1
X_7696_ _3808_ VGND VGND VPWR VPWR _0379_ sky130_fd_sc_hd__clkbuf_1
XFILLER_0_73_262 VGND VGND VPWR VPWR sky130_fd_sc_hd__fill_1
XFILLER_0_73_240 VGND VGND VPWR VPWR sky130_fd_sc_hd__fill_2
Xclkload5 clknet_3_7__leaf_CLK VGND VGND VPWR VPWR clkload5/Y sky130_fd_sc_hd__inv_8
X_9435_ clknet_leaf_33_CLK _0668_ VGND VGND VPWR VPWR RF.reg_arr\[17\]\[29\] sky130_fd_sc_hd__dfxtp_1
XFILLER_0_6_562 VGND VGND VPWR VPWR sky130_fd_sc_hd__fill_2
X_6647_ _3234_ VGND VGND VPWR VPWR _0928_ sky130_fd_sc_hd__clkbuf_1
X_9366_ clknet_leaf_52_CLK _0599_ VGND VGND VPWR VPWR RF.reg_arr\[18\]\[24\] sky130_fd_sc_hd__dfxtp_1
XFILLER_0_104_526 VGND VGND VPWR VPWR sky130_fd_sc_hd__decap_6
X_6578_ net245 _3000_ _3196_ VGND VGND VPWR VPWR _3198_ sky130_fd_sc_hd__mux2_1
X_5529_ RF.reg_arr\[20\]\[1\] RF.reg_arr\[21\]\[1\] RF.reg_arr\[22\]\[1\] RF.reg_arr\[23\]\[1\]
+ net1 net2 VGND VGND VPWR VPWR _2318_ sky130_fd_sc_hd__mux4_1
XFILLER_0_14_362 VGND VGND VPWR VPWR sky130_fd_sc_hd__fill_2
XFILLER_0_14_351 VGND VGND VPWR VPWR sky130_fd_sc_hd__fill_2
XFILLER_0_42_671 VGND VGND VPWR VPWR sky130_fd_sc_hd__decap_4
X_8317_ _4137_ VGND VGND VPWR VPWR _4138_ sky130_fd_sc_hd__clkbuf_8
XFILLER_0_14_395 VGND VGND VPWR VPWR sky130_fd_sc_hd__fill_2
X_9297_ clknet_leaf_3_CLK _0530_ VGND VGND VPWR VPWR RF.reg_arr\[25\]\[19\] sky130_fd_sc_hd__dfxtp_1
X_8248_ _3342_ _3158_ VGND VGND VPWR VPWR _4101_ sky130_fd_sc_hd__nor2_2
X_8179_ _4064_ VGND VGND VPWR VPWR _0606_ sky130_fd_sc_hd__clkbuf_1
XTAP_TAPCELL_ROW_70_1097 VGND VPWR sky130_fd_sc_hd__tapvpwrvgnd_1
XTAP_TAPCELL_ROW_70_1086 VGND VPWR sky130_fd_sc_hd__tapvpwrvgnd_1
XTAP_TAPCELL_ROW_25_552 VGND VPWR sky130_fd_sc_hd__tapvpwrvgnd_1
XTAP_TAPCELL_ROW_53_883 VGND VPWR sky130_fd_sc_hd__tapvpwrvgnd_1
XFILLER_0_112_29 VPWR VGND VPWR VGND sky130_ef_sc_hd__decap_12
XFILLER_0_21_27 VGND VGND VPWR VPWR sky130_fd_sc_hd__fill_2
XFILLER_0_24_137 VGND VGND VPWR VPWR sky130_fd_sc_hd__decap_3
XFILLER_0_40_608 VGND VGND VPWR VPWR sky130_fd_sc_hd__fill_2
XFILLER_0_52_457 VGND VGND VPWR VPWR sky130_fd_sc_hd__decap_3
XFILLER_0_33_671 VGND VGND VPWR VPWR sky130_fd_sc_hd__fill_1
XTAP_TAPCELL_ROW_88_1303 VGND VPWR sky130_fd_sc_hd__tapvpwrvgnd_1
XFILLER_0_1_15 VPWR VGND VPWR VGND sky130_ef_sc_hd__decap_12
X_4900_ RF.reg_arr\[12\]\[29\] RF.reg_arr\[13\]\[29\] RF.reg_arr\[14\]\[29\] RF.reg_arr\[15\]\[29\]
+ _1627_ _1629_ VGND VGND VPWR VPWR _1689_ sky130_fd_sc_hd__mux4_1
XFILLER_0_87_332 VGND VGND VPWR VPWR sky130_fd_sc_hd__decap_4
X_5880_ _1115_ _2068_ _2122_ VGND VGND VPWR VPWR _2657_ sky130_fd_sc_hd__a21oi_1
XFILLER_0_75_505 VPWR VGND VPWR VGND sky130_ef_sc_hd__decap_12
X_4831_ _1606_ _1615_ _1619_ VGND VGND VPWR VPWR _1620_ sky130_fd_sc_hd__mux2_1
XFILLER_0_62_78 VGND VGND VPWR VPWR sky130_fd_sc_hd__fill_1
XFILLER_0_47_207 VGND VGND VPWR VPWR sky130_fd_sc_hd__fill_1
XFILLER_0_90_519 VGND VGND VPWR VPWR sky130_fd_sc_hd__fill_2
X_4762_ RF.reg_arr\[20\]\[25\] RF.reg_arr\[21\]\[25\] RF.reg_arr\[22\]\[25\] RF.reg_arr\[23\]\[25\]
+ _1450_ _1451_ VGND VGND VPWR VPWR _1551_ sky130_fd_sc_hd__mux4_1
X_7550_ _3731_ VGND VGND VPWR VPWR _0310_ sky130_fd_sc_hd__clkbuf_1
XFILLER_0_7_337 VGND VGND VPWR VPWR sky130_fd_sc_hd__decap_6
X_7481_ _3109_ net545 _3689_ VGND VGND VPWR VPWR _3694_ sky130_fd_sc_hd__mux2_1
XTAP_TAPCELL_ROW_99_1443 VGND VPWR sky130_fd_sc_hd__tapvpwrvgnd_1
X_4693_ _1282_ _1481_ _1163_ VGND VGND VPWR VPWR _1482_ sky130_fd_sc_hd__o21ai_1
X_6501_ _3155_ VGND VGND VPWR VPWR _0861_ sky130_fd_sc_hd__clkbuf_1
X_6432_ _3119_ net838 _3101_ VGND VGND VPWR VPWR _3120_ sky130_fd_sc_hd__mux2_1
Xclkload100 clknet_leaf_60_CLK VGND VGND VPWR VPWR clkload100/Y sky130_fd_sc_hd__clkinvlp_4
X_9220_ clknet_leaf_83_CLK _0453_ VGND VGND VPWR VPWR RF.reg_arr\[22\]\[6\] sky130_fd_sc_hd__dfxtp_1
XFILLER_0_113_356 VPWR VGND VPWR VGND sky130_ef_sc_hd__decap_12
XFILLER_0_70_276 VGND VGND VPWR VPWR sky130_fd_sc_hd__fill_2
X_9151_ clknet_leaf_57_CLK _0384_ VGND VGND VPWR VPWR RF.reg_arr\[9\]\[1\] sky130_fd_sc_hd__dfxtp_1
XFILLER_0_101_529 VGND VGND VPWR VPWR sky130_fd_sc_hd__decap_6
X_8102_ _2984_ net1006 _4016_ VGND VGND VPWR VPWR _4024_ sky130_fd_sc_hd__mux2_1
XFILLER_0_87_20 VGND VGND VPWR VPWR sky130_fd_sc_hd__decap_6
X_6363_ net43 VGND VGND VPWR VPWR _3073_ sky130_fd_sc_hd__clkbuf_2
X_9082_ clknet_leaf_30_CLK _0315_ VGND VGND VPWR VPWR RF.reg_arr\[28\]\[28\] sky130_fd_sc_hd__dfxtp_1
X_6294_ _3028_ VGND VGND VPWR VPWR _0781_ sky130_fd_sc_hd__clkbuf_1
X_5314_ _1642_ _2094_ _2102_ VGND VGND VPWR VPWR _2103_ sky130_fd_sc_hd__o21ai_4
X_8033_ _3987_ VGND VGND VPWR VPWR _0537_ sky130_fd_sc_hd__clkbuf_1
X_5245_ RF.reg_arr\[24\]\[0\] RF.reg_arr\[25\]\[0\] RF.reg_arr\[26\]\[0\] RF.reg_arr\[27\]\[0\]
+ _1622_ _1595_ VGND VGND VPWR VPWR _2034_ sky130_fd_sc_hd__mux4_1
Xhold17 RF.reg_arr\[0\]\[31\] VGND VGND VPWR VPWR net99 sky130_fd_sc_hd__dlygate4sd3_1
Xhold28 RF.reg_arr\[0\]\[1\] VGND VGND VPWR VPWR net110 sky130_fd_sc_hd__dlygate4sd3_1
XFILLER_0_46_3 VGND VGND VPWR VPWR sky130_fd_sc_hd__decap_3
X_5176_ _1895_ _1964_ _1756_ VGND VGND VPWR VPWR _1965_ sky130_fd_sc_hd__o21ai_1
Xhold39 RF.reg_arr\[0\]\[14\] VGND VGND VPWR VPWR net121 sky130_fd_sc_hd__dlygate4sd3_1
XTAP_TAPCELL_ROW_108_1550 VGND VPWR sky130_fd_sc_hd__tapvpwrvgnd_1
X_8935_ clknet_leaf_78_CLK _0168_ VGND VGND VPWR VPWR RF.reg_arr\[29\]\[9\] sky130_fd_sc_hd__dfxtp_1
XFILLER_0_78_365 VGND VGND VPWR VPWR sky130_fd_sc_hd__decap_4
X_8866_ clknet_leaf_66_CLK _0099_ VGND VGND VPWR VPWR RF.reg_arr\[3\]\[4\] sky130_fd_sc_hd__dfxtp_1
XFILLER_0_93_357 VGND VGND VPWR VPWR sky130_fd_sc_hd__decap_8
XFILLER_0_93_346 VGND VGND VPWR VPWR sky130_fd_sc_hd__fill_2
XFILLER_0_93_324 VGND VGND VPWR VPWR sky130_fd_sc_hd__decap_3
XFILLER_0_93_335 VGND VGND VPWR VPWR sky130_fd_sc_hd__fill_1
X_8797_ clknet_leaf_23_CLK _0030_ VGND VGND VPWR VPWR RF.reg_arr\[5\]\[31\] sky130_fd_sc_hd__dfxtp_1
X_7817_ _3103_ net926 _3871_ VGND VGND VPWR VPWR _3873_ sky130_fd_sc_hd__mux2_1
XFILLER_0_108_117 VGND VGND VPWR VPWR sky130_fd_sc_hd__fill_1
X_7748_ _3836_ VGND VGND VPWR VPWR _0403_ sky130_fd_sc_hd__clkbuf_1
XFILLER_0_19_465 VGND VGND VPWR VPWR sky130_fd_sc_hd__fill_1
XTAP_TAPCELL_ROW_22_511 VGND VPWR sky130_fd_sc_hd__tapvpwrvgnd_1
X_7679_ _3100_ net779 _3799_ VGND VGND VPWR VPWR _3800_ sky130_fd_sc_hd__mux2_1
XFILLER_0_46_262 VGND VGND VPWR VPWR sky130_fd_sc_hd__fill_2
XTAP_TAPCELL_ROW_50_853 VGND VPWR sky130_fd_sc_hd__tapvpwrvgnd_1
XFILLER_0_116_150 VPWR VGND VPWR VGND sky130_ef_sc_hd__decap_12
X_9418_ clknet_leaf_99_CLK _0651_ VGND VGND VPWR VPWR RF.reg_arr\[17\]\[12\] sky130_fd_sc_hd__dfxtp_1
XFILLER_0_15_682 VGND VGND VPWR VPWR sky130_fd_sc_hd__decap_8
XFILLER_0_61_298 VGND VGND VPWR VPWR sky130_fd_sc_hd__decap_3
X_9349_ clknet_leaf_98_CLK _0582_ VGND VGND VPWR VPWR RF.reg_arr\[18\]\[7\] sky130_fd_sc_hd__dfxtp_1
XTAP_TAPCELL_ROW_72_1115 VGND VPWR sky130_fd_sc_hd__tapvpwrvgnd_1
XFILLER_0_100_573 VPWR VGND VPWR VGND sky130_ef_sc_hd__decap_12
XTAP_TAPCELL_ROW_58_942 VGND VPWR sky130_fd_sc_hd__tapvpwrvgnd_1
XTAP_TAPCELL_ROW_58_953 VGND VPWR sky130_fd_sc_hd__tapvpwrvgnd_1
XTAP_TAPCELL_ROW_2_280 VGND VPWR sky130_fd_sc_hd__tapvpwrvgnd_1
XPHY_EDGE_ROW_106_Left_223 VGND VGND VPWR VPWR sky130_fd_sc_hd__decap_3
XTAP_TAPCELL_ROW_83_1244 VGND VPWR sky130_fd_sc_hd__tapvpwrvgnd_1
XFILLER_0_57_527 VGND VGND VPWR VPWR sky130_fd_sc_hd__fill_1
XFILLER_0_57_516 VGND VGND VPWR VPWR sky130_fd_sc_hd__fill_2
XFILLER_0_57_505 VGND VGND VPWR VPWR sky130_fd_sc_hd__decap_8
XFILLER_0_96_195 VGND VGND VPWR VPWR sky130_fd_sc_hd__fill_1
XFILLER_0_108_651 VGND VGND VPWR VPWR sky130_fd_sc_hd__fill_1
XFILLER_0_108_684 VGND VGND VPWR VPWR sky130_fd_sc_hd__decap_8
XFILLER_0_80_530 VGND VGND VPWR VPWR sky130_fd_sc_hd__fill_2
Xhold509 RF.reg_arr\[8\]\[20\] VGND VGND VPWR VPWR net591 sky130_fd_sc_hd__dlygate4sd3_1
XFILLER_0_40_416 VGND VGND VPWR VPWR sky130_fd_sc_hd__decap_4
XFILLER_0_52_276 VGND VGND VPWR VPWR sky130_fd_sc_hd__fill_2
XFILLER_0_52_287 VGND VGND VPWR VPWR sky130_fd_sc_hd__decap_3
XPHY_EDGE_ROW_115_Left_232 VGND VGND VPWR VPWR sky130_fd_sc_hd__decap_3
XFILLER_0_110_315 VGND VGND VPWR VPWR sky130_fd_sc_hd__fill_1
XTAP_TAPCELL_ROW_94_1384 VGND VPWR sky130_fd_sc_hd__tapvpwrvgnd_1
X_5030_ _1817_ _1818_ _1041_ VGND VGND VPWR VPWR _1819_ sky130_fd_sc_hd__mux2_1
XFILLER_0_73_22 VPWR VGND VPWR VGND sky130_ef_sc_hd__decap_12
X_6981_ net743 _3424_ _3410_ VGND VGND VPWR VPWR _3425_ sky130_fd_sc_hd__mux2_1
X_5932_ _2677_ _2705_ _2366_ VGND VGND VPWR VPWR _2706_ sky130_fd_sc_hd__mux2_1
XFILLER_0_88_630 VGND VGND VPWR VPWR sky130_fd_sc_hd__fill_2
XFILLER_0_73_77 VGND VGND VPWR VPWR sky130_fd_sc_hd__decap_6
XTAP_TAPCELL_ROW_0_239 VGND VPWR sky130_fd_sc_hd__tapvpwrvgnd_1
X_8720_ clknet_leaf_1_CLK _0977_ VGND VGND VPWR VPWR RF.reg_arr\[14\]\[18\] sky130_fd_sc_hd__dfxtp_1
XFILLER_0_88_685 VGND VGND VPWR VPWR sky130_fd_sc_hd__fill_1
X_5863_ _2639_ _2626_ _2640_ VGND VGND VPWR VPWR _2641_ sky130_fd_sc_hd__o21ai_1
XFILLER_0_75_346 VGND VGND VPWR VPWR sky130_fd_sc_hd__fill_1
XFILLER_0_75_335 VGND VGND VPWR VPWR sky130_fd_sc_hd__fill_1
X_8651_ clknet_leaf_92_CLK _0908_ VGND VGND VPWR VPWR RF.reg_arr\[8\]\[13\] sky130_fd_sc_hd__dfxtp_1
X_5794_ _2253_ _2549_ _2537_ _2271_ VGND VGND VPWR VPWR _2575_ sky130_fd_sc_hd__a211oi_1
XFILLER_0_8_635 VGND VGND VPWR VPWR sky130_fd_sc_hd__decap_8
X_8582_ clknet_leaf_66_CLK _0839_ VGND VGND VPWR VPWR RF.reg_arr\[0\]\[8\] sky130_fd_sc_hd__dfxtp_1
X_4814_ net3 VGND VGND VPWR VPWR _1603_ sky130_fd_sc_hd__buf_4
X_7602_ net397 _3422_ _3752_ VGND VGND VPWR VPWR _3759_ sky130_fd_sc_hd__mux2_1
XTAP_TAPCELL_ROW_103_1491 VGND VPWR sky130_fd_sc_hd__tapvpwrvgnd_1
X_4745_ RF.reg_arr\[20\]\[15\] RF.reg_arr\[21\]\[15\] RF.reg_arr\[22\]\[15\] RF.reg_arr\[23\]\[15\]
+ _1134_ _1135_ VGND VGND VPWR VPWR _1534_ sky130_fd_sc_hd__mux4_1
X_7533_ _3722_ VGND VGND VPWR VPWR _0302_ sky130_fd_sc_hd__clkbuf_1
XFILLER_0_56_582 VGND VGND VPWR VPWR sky130_fd_sc_hd__decap_6
XFILLER_0_71_552 VGND VGND VPWR VPWR sky130_fd_sc_hd__decap_4
XFILLER_0_7_167 VGND VGND VPWR VPWR sky130_fd_sc_hd__fill_1
XFILLER_0_114_643 VGND VGND VPWR VPWR sky130_fd_sc_hd__fill_1
X_4676_ _1463_ _1464_ _1281_ VGND VGND VPWR VPWR _1465_ sky130_fd_sc_hd__mux2_1
XFILLER_0_43_254 VGND VGND VPWR VPWR sky130_fd_sc_hd__fill_1
X_7464_ _3092_ net1009 _3678_ VGND VGND VPWR VPWR _3685_ sky130_fd_sc_hd__mux2_1
X_9203_ clknet_leaf_46_CLK _0436_ VGND VGND VPWR VPWR RF.reg_arr\[24\]\[21\] sky130_fd_sc_hd__dfxtp_1
X_6415_ _3108_ VGND VGND VPWR VPWR _0822_ sky130_fd_sc_hd__clkbuf_1
X_7395_ _3092_ net935 _3641_ VGND VGND VPWR VPWR _3648_ sky130_fd_sc_hd__mux2_1
XFILLER_0_101_337 VGND VGND VPWR VPWR sky130_fd_sc_hd__fill_1
XFILLER_0_98_96 VGND VGND VPWR VPWR sky130_fd_sc_hd__decap_4
X_6346_ _3061_ net394 _3059_ VGND VGND VPWR VPWR _3062_ sky130_fd_sc_hd__mux2_1
XFILLER_0_3_384 VGND VGND VPWR VPWR sky130_fd_sc_hd__fill_2
X_9134_ clknet_leaf_6_CLK _0367_ VGND VGND VPWR VPWR RF.reg_arr\[30\]\[16\] sky130_fd_sc_hd__dfxtp_1
X_9065_ clknet_leaf_14_CLK _0298_ VGND VGND VPWR VPWR RF.reg_arr\[28\]\[11\] sky130_fd_sc_hd__dfxtp_1
X_8016_ _3978_ VGND VGND VPWR VPWR _0529_ sky130_fd_sc_hd__clkbuf_1
X_6277_ net809 _3016_ _2998_ VGND VGND VPWR VPWR _3017_ sky130_fd_sc_hd__mux2_1
X_5228_ RF.reg_arr\[8\]\[3\] RF.reg_arr\[9\]\[3\] RF.reg_arr\[10\]\[3\] RF.reg_arr\[11\]\[3\]
+ _1229_ _1230_ VGND VGND VPWR VPWR _2017_ sky130_fd_sc_hd__mux4_1
X_5159_ _1834_ VGND VGND VPWR VPWR _1948_ sky130_fd_sc_hd__buf_4
XTAP_TAPCELL_ROW_55_912 VGND VPWR sky130_fd_sc_hd__tapvpwrvgnd_1
X_8918_ clknet_leaf_50_CLK _0151_ VGND VGND VPWR VPWR RF.reg_arr\[7\]\[24\] sky130_fd_sc_hd__dfxtp_1
XFILLER_0_79_685 VGND VGND VPWR VPWR sky130_fd_sc_hd__fill_1
XFILLER_0_39_505 VGND VGND VPWR VPWR sky130_fd_sc_hd__decap_6
XFILLER_0_94_622 VGND VGND VPWR VPWR sky130_fd_sc_hd__fill_2
XFILLER_0_78_195 VGND VGND VPWR VPWR sky130_fd_sc_hd__fill_1
X_8849_ clknet_leaf_4_CLK _0082_ VGND VGND VPWR VPWR RF.reg_arr\[19\]\[19\] sky130_fd_sc_hd__dfxtp_1
XFILLER_0_62_552 VGND VGND VPWR VPWR sky130_fd_sc_hd__decap_8
XFILLER_0_62_541 VGND VGND VPWR VPWR sky130_fd_sc_hd__decap_8
XFILLER_0_15_490 VGND VGND VPWR VPWR sky130_fd_sc_hd__decap_6
XFILLER_0_89_449 VGND VGND VPWR VPWR sky130_fd_sc_hd__fill_1
XFILLER_0_104_3 VPWR VGND VPWR VGND sky130_ef_sc_hd__decap_12
XTAP_TAPCELL_ROW_96_1402 VGND VPWR sky130_fd_sc_hd__tapvpwrvgnd_1
X_4530_ RF.reg_arr\[28\]\[23\] RF.reg_arr\[29\]\[23\] RF.reg_arr\[30\]\[23\] RF.reg_arr\[31\]\[23\]
+ _1316_ _1304_ VGND VGND VPWR VPWR _1319_ sky130_fd_sc_hd__mux4_1
XFILLER_0_4_126 VGND VGND VPWR VPWR sky130_fd_sc_hd__decap_3
Xhold306 RF.reg_arr\[31\]\[25\] VGND VGND VPWR VPWR net388 sky130_fd_sc_hd__dlygate4sd3_1
Xhold317 RF.reg_arr\[1\]\[23\] VGND VGND VPWR VPWR net399 sky130_fd_sc_hd__dlygate4sd3_1
X_4461_ _1059_ _1247_ _1249_ _1061_ VGND VGND VPWR VPWR _1250_ sky130_fd_sc_hd__o211a_1
X_6200_ _2951_ _2952_ _2568_ _2958_ VGND VGND VPWR VPWR net72 sky130_fd_sc_hd__o2bb2a_1
Xhold339 RF.reg_arr\[14\]\[22\] VGND VGND VPWR VPWR net421 sky130_fd_sc_hd__dlygate4sd3_1
X_7180_ net437 _3412_ _3532_ VGND VGND VPWR VPWR _3534_ sky130_fd_sc_hd__mux2_1
Xhold328 RF.reg_arr\[29\]\[10\] VGND VGND VPWR VPWR net410 sky130_fd_sc_hd__dlygate4sd3_1
X_6131_ _2865_ _2893_ _2872_ VGND VGND VPWR VPWR _2894_ sky130_fd_sc_hd__o21a_1
X_4392_ RF.reg_arr\[8\]\[19\] RF.reg_arr\[9\]\[19\] RF.reg_arr\[10\]\[19\] RF.reg_arr\[11\]\[19\]
+ _1164_ _1165_ VGND VGND VPWR VPWR _1181_ sky130_fd_sc_hd__mux4_1
XTAP_TAPCELL_ROW_5_309 VGND VPWR sky130_fd_sc_hd__tapvpwrvgnd_1
XFILLER_0_0_365 VGND VGND VPWR VPWR sky130_fd_sc_hd__fill_2
X_6062_ _2827_ _1206_ _2738_ net94 VGND VGND VPWR VPWR _2828_ sky130_fd_sc_hd__or4_4
Xhold1006 RF.reg_arr\[6\]\[12\] VGND VGND VPWR VPWR net1088 sky130_fd_sc_hd__dlygate4sd3_1
X_5013_ RF.reg_arr\[12\]\[25\] RF.reg_arr\[13\]\[25\] RF.reg_arr\[14\]\[25\] RF.reg_arr\[15\]\[25\]
+ _1592_ _1599_ VGND VGND VPWR VPWR _1802_ sky130_fd_sc_hd__mux4_1
XFILLER_0_84_32 VGND VGND VPWR VPWR sky130_fd_sc_hd__fill_1
Xhold1017 RF.reg_arr\[20\]\[7\] VGND VGND VPWR VPWR net1099 sky130_fd_sc_hd__dlygate4sd3_1
Xhold1028 RF.reg_arr\[31\]\[4\] VGND VGND VPWR VPWR net1110 sky130_fd_sc_hd__dlygate4sd3_1
Xhold1039 RF.reg_arr\[14\]\[18\] VGND VGND VPWR VPWR net1121 sky130_fd_sc_hd__dlygate4sd3_1
XFILLER_0_30_6 VGND VGND VPWR VPWR sky130_fd_sc_hd__decap_4
X_6964_ _3413_ VGND VGND VPWR VPWR _0042_ sky130_fd_sc_hd__clkbuf_1
XPHY_EDGE_ROW_5_Right_5 VGND VGND VPWR VPWR sky130_fd_sc_hd__decap_3
X_5915_ _2521_ _2689_ VGND VGND VPWR VPWR _2690_ sky130_fd_sc_hd__nor2_1
X_6895_ _3367_ VGND VGND VPWR VPWR _0019_ sky130_fd_sc_hd__clkbuf_1
X_8703_ clknet_leaf_67_CLK _0960_ VGND VGND VPWR VPWR RF.reg_arr\[14\]\[1\] sky130_fd_sc_hd__dfxtp_1
X_8634_ clknet_leaf_33_CLK _0891_ VGND VGND VPWR VPWR RF.reg_arr\[16\]\[28\] sky130_fd_sc_hd__dfxtp_1
X_5846_ _2572_ _2609_ _2610_ VGND VGND VPWR VPWR _2625_ sky130_fd_sc_hd__a21bo_1
X_8565_ clknet_leaf_40_CLK _0822_ VGND VGND VPWR VPWR RF.reg_arr\[23\]\[23\] sky130_fd_sc_hd__dfxtp_1
X_5777_ _2403_ _2405_ VGND VGND VPWR VPWR _2559_ sky130_fd_sc_hd__nand2_1
XTAP_TAPCELL_ROW_60_970 VGND VPWR sky130_fd_sc_hd__tapvpwrvgnd_1
X_4728_ _1499_ _1516_ VGND VGND VPWR VPWR _1517_ sky130_fd_sc_hd__nand2_1
X_8496_ net219 net27 _4222_ VGND VGND VPWR VPWR _4232_ sky130_fd_sc_hd__mux2_1
X_7516_ _3713_ VGND VGND VPWR VPWR _0294_ sky130_fd_sc_hd__clkbuf_1
X_4659_ _1416_ _1447_ VGND VGND VPWR VPWR _1448_ sky130_fd_sc_hd__nor2_1
XFILLER_0_71_393 VGND VGND VPWR VPWR sky130_fd_sc_hd__decap_3
XFILLER_0_71_371 VPWR VGND VPWR VGND sky130_ef_sc_hd__decap_12
X_7447_ _3075_ net1062 _3667_ VGND VGND VPWR VPWR _3676_ sky130_fd_sc_hd__mux2_1
XTAP_TAPCELL_ROW_116_1660 VGND VPWR sky130_fd_sc_hd__tapvpwrvgnd_1
XFILLER_0_114_473 VGND VGND VPWR VPWR sky130_fd_sc_hd__decap_3
XFILLER_0_3_181 VGND VGND VPWR VPWR sky130_fd_sc_hd__decap_3
XFILLER_0_102_657 VPWR VGND VPWR VGND sky130_ef_sc_hd__decap_12
Xhold862 RF.reg_arr\[29\]\[1\] VGND VGND VPWR VPWR net944 sky130_fd_sc_hd__dlygate4sd3_1
X_7378_ _3075_ net1054 _3630_ VGND VGND VPWR VPWR _3639_ sky130_fd_sc_hd__mux2_1
Xhold840 RF.reg_arr\[20\]\[5\] VGND VGND VPWR VPWR net922 sky130_fd_sc_hd__dlygate4sd3_1
Xhold873 RF.reg_arr\[15\]\[6\] VGND VGND VPWR VPWR net955 sky130_fd_sc_hd__dlygate4sd3_1
Xhold851 RF.reg_arr\[24\]\[19\] VGND VGND VPWR VPWR net933 sky130_fd_sc_hd__dlygate4sd3_1
XFILLER_0_101_178 VGND VGND VPWR VPWR sky130_fd_sc_hd__decap_4
XFILLER_0_101_167 VGND VGND VPWR VPWR sky130_fd_sc_hd__fill_1
X_6329_ net190 _2984_ _3040_ VGND VGND VPWR VPWR _3051_ sky130_fd_sc_hd__mux2_1
X_9117_ clknet_leaf_27_CLK _0350_ VGND VGND VPWR VPWR RF.reg_arr\[2\]\[31\] sky130_fd_sc_hd__dfxtp_1
Xhold895 RF.reg_arr\[22\]\[8\] VGND VGND VPWR VPWR net977 sky130_fd_sc_hd__dlygate4sd3_1
Xhold884 RF.reg_arr\[16\]\[10\] VGND VGND VPWR VPWR net966 sky130_fd_sc_hd__dlygate4sd3_1
X_9048_ clknet_leaf_34_CLK _0281_ VGND VGND VPWR VPWR RF.reg_arr\[26\]\[26\] sky130_fd_sc_hd__dfxtp_1
XTAP_TAPCELL_ROW_67_1058 VGND VPWR sky130_fd_sc_hd__tapvpwrvgnd_1
XFILLER_0_94_463 VPWR VGND VPWR VGND sky130_ef_sc_hd__decap_12
XTAP_TAPCELL_ROW_80_1214 VGND VPWR sky130_fd_sc_hd__tapvpwrvgnd_1
XFILLER_0_39_368 VGND VGND VPWR VPWR sky130_fd_sc_hd__fill_2
XTAP_TAPCELL_ROW_30_609 VGND VPWR sky130_fd_sc_hd__tapvpwrvgnd_1
XFILLER_0_54_305 VGND VGND VPWR VPWR sky130_fd_sc_hd__decap_3
XTAP_TAPCELL_ROW_10_377 VGND VPWR sky130_fd_sc_hd__tapvpwrvgnd_1
XTAP_TAPCELL_ROW_10_366 VGND VPWR sky130_fd_sc_hd__tapvpwrvgnd_1
XTAP_TAPCELL_ROW_78_1187 VGND VPWR sky130_fd_sc_hd__tapvpwrvgnd_1
XFILLER_0_1_129 VGND VGND VPWR VPWR sky130_fd_sc_hd__fill_1
XTAP_TAPCELL_ROW_91_1343 VGND VPWR sky130_fd_sc_hd__tapvpwrvgnd_1
XTAP_TAPCELL_ROW_38_709 VGND VPWR sky130_fd_sc_hd__tapvpwrvgnd_1
XTAP_TAPCELL_ROW_18_466 VGND VPWR sky130_fd_sc_hd__tapvpwrvgnd_1
X_5700_ _2050_ VGND VGND VPWR VPWR _2485_ sky130_fd_sc_hd__buf_2
XFILLER_0_70_23 VGND VGND VPWR VPWR sky130_fd_sc_hd__decap_4
X_6680_ _3251_ VGND VGND VPWR VPWR _0944_ sky130_fd_sc_hd__clkbuf_1
XTAP_TAPCELL_ROW_100_1450 VGND VPWR sky130_fd_sc_hd__tapvpwrvgnd_1
X_5631_ _2334_ VGND VGND VPWR VPWR _2418_ sky130_fd_sc_hd__buf_2
X_5562_ _1113_ _1664_ VGND VGND VPWR VPWR _2350_ sky130_fd_sc_hd__nor2_1
XFILLER_0_72_157 VGND VGND VPWR VPWR sky130_fd_sc_hd__decap_4
X_8350_ _4155_ VGND VGND VPWR VPWR _0686_ sky130_fd_sc_hd__clkbuf_1
X_4513_ _1175_ VGND VGND VPWR VPWR _1302_ sky130_fd_sc_hd__buf_6
XFILLER_0_5_457 VGND VGND VPWR VPWR sky130_fd_sc_hd__decap_3
X_8281_ net869 _3420_ _4113_ VGND VGND VPWR VPWR _4119_ sky130_fd_sc_hd__mux2_1
X_7301_ _3598_ VGND VGND VPWR VPWR _0194_ sky130_fd_sc_hd__clkbuf_1
XFILLER_0_80_190 VGND VGND VPWR VPWR sky130_fd_sc_hd__decap_6
Xhold103 RF.reg_arr\[11\]\[21\] VGND VGND VPWR VPWR net185 sky130_fd_sc_hd__dlygate4sd3_1
Xhold114 RF.reg_arr\[21\]\[2\] VGND VGND VPWR VPWR net196 sky130_fd_sc_hd__dlygate4sd3_1
XFILLER_0_13_246 VGND VGND VPWR VPWR sky130_fd_sc_hd__decap_6
Xhold125 RF.reg_arr\[28\]\[16\] VGND VGND VPWR VPWR net207 sky130_fd_sc_hd__dlygate4sd3_1
X_5493_ _2280_ _2281_ _1863_ VGND VGND VPWR VPWR _2282_ sky130_fd_sc_hd__mux2_1
X_7232_ _3065_ net558 _3558_ VGND VGND VPWR VPWR _3562_ sky130_fd_sc_hd__mux2_1
Xhold158 RF.reg_arr\[2\]\[25\] VGND VGND VPWR VPWR net240 sky130_fd_sc_hd__dlygate4sd3_1
XFILLER_0_13_279 VGND VGND VPWR VPWR sky130_fd_sc_hd__fill_1
XFILLER_0_1_641 VPWR VGND VPWR VGND sky130_ef_sc_hd__decap_12
Xhold136 RF.reg_arr\[9\]\[4\] VGND VGND VPWR VPWR net218 sky130_fd_sc_hd__dlygate4sd3_1
X_4444_ RF.reg_arr\[8\]\[9\] RF.reg_arr\[9\]\[9\] RF.reg_arr\[10\]\[9\] RF.reg_arr\[11\]\[9\]
+ _1043_ _1083_ VGND VGND VPWR VPWR _1233_ sky130_fd_sc_hd__mux4_1
Xhold147 RF.reg_arr\[1\]\[11\] VGND VGND VPWR VPWR net229 sky130_fd_sc_hd__dlygate4sd3_1
Xhold169 RF.reg_arr\[7\]\[25\] VGND VGND VPWR VPWR net251 sky130_fd_sc_hd__dlygate4sd3_1
X_4375_ _1117_ VGND VGND VPWR VPWR _1164_ sky130_fd_sc_hd__buf_6
XFILLER_0_1_685 VGND VGND VPWR VPWR sky130_fd_sc_hd__decap_6
X_7163_ net278 _3395_ _3521_ VGND VGND VPWR VPWR _3525_ sky130_fd_sc_hd__mux2_1
X_6114_ _2839_ _2877_ _2001_ VGND VGND VPWR VPWR _2878_ sky130_fd_sc_hd__mux2_1
X_7094_ _3488_ VGND VGND VPWR VPWR _0097_ sky130_fd_sc_hd__clkbuf_1
XFILLER_0_0_195 VGND VGND VPWR VPWR sky130_fd_sc_hd__fill_1
X_6045_ _2811_ _1206_ _2738_ net94 _2547_ VGND VGND VPWR VPWR _2812_ sky130_fd_sc_hd__o41a_1
X_7996_ _3016_ net431 _3958_ VGND VGND VPWR VPWR _3968_ sky130_fd_sc_hd__mux2_1
X_6947_ net392 _3401_ _3389_ VGND VGND VPWR VPWR _3402_ sky130_fd_sc_hd__mux2_1
XFILLER_0_64_625 VGND VGND VPWR VPWR sky130_fd_sc_hd__fill_2
XFILLER_0_63_113 VGND VGND VPWR VPWR sky130_fd_sc_hd__fill_2
X_6878_ _3358_ VGND VGND VPWR VPWR _0011_ sky130_fd_sc_hd__clkbuf_1
XFILLER_0_36_305 VGND VGND VPWR VPWR sky130_fd_sc_hd__decap_3
X_5829_ _2120_ _2608_ VGND VGND VPWR VPWR _2609_ sky130_fd_sc_hd__nand2_1
X_8617_ clknet_leaf_13_CLK _0874_ VGND VGND VPWR VPWR RF.reg_arr\[16\]\[11\] sky130_fd_sc_hd__dfxtp_1
XFILLER_0_91_466 VGND VGND VPWR VPWR sky130_fd_sc_hd__fill_1
X_8548_ clknet_leaf_83_CLK _0805_ VGND VGND VPWR VPWR RF.reg_arr\[23\]\[6\] sky130_fd_sc_hd__dfxtp_1
XTAP_TAPCELL_ROW_114_1619 VGND VPWR sky130_fd_sc_hd__tapvpwrvgnd_1
XFILLER_0_102_421 VGND VGND VPWR VPWR sky130_fd_sc_hd__fill_2
X_8479_ _4223_ VGND VGND VPWR VPWR _0747_ sky130_fd_sc_hd__clkbuf_1
Xhold670 RF.reg_arr\[19\]\[13\] VGND VGND VPWR VPWR net752 sky130_fd_sc_hd__dlygate4sd3_1
Xhold681 RF.reg_arr\[26\]\[2\] VGND VGND VPWR VPWR net763 sky130_fd_sc_hd__dlygate4sd3_1
Xhold692 RF.reg_arr\[10\]\[3\] VGND VGND VPWR VPWR net774 sky130_fd_sc_hd__dlygate4sd3_1
XFILLER_0_99_533 VGND VGND VPWR VPWR sky130_fd_sc_hd__fill_1
XFILLER_0_67_452 VGND VGND VPWR VPWR sky130_fd_sc_hd__decap_6
XTAP_TAPCELL_ROW_15_436 VGND VPWR sky130_fd_sc_hd__tapvpwrvgnd_1
XTAP_TAPCELL_ROW_43_767 VGND VPWR sky130_fd_sc_hd__tapvpwrvgnd_1
XFILLER_0_55_603 VGND VGND VPWR VPWR sky130_fd_sc_hd__decap_4
XFILLER_0_42_319 VGND VGND VPWR VPWR sky130_fd_sc_hd__fill_2
XFILLER_0_35_382 VGND VGND VPWR VPWR sky130_fd_sc_hd__fill_1
XFILLER_0_35_393 VGND VGND VPWR VPWR sky130_fd_sc_hd__decap_4
XFILLER_0_105_281 VGND VGND VPWR VPWR sky130_fd_sc_hd__decap_6
XFILLER_0_49_57 VGND VGND VPWR VPWR sky130_fd_sc_hd__decap_3
XFILLER_0_4_15 VPWR VGND VPWR VGND sky130_ef_sc_hd__decap_12
X_7850_ _3067_ net473 _3886_ VGND VGND VPWR VPWR _3891_ sky130_fd_sc_hd__mux2_1
X_6801_ net275 _3016_ _3307_ VGND VGND VPWR VPWR _3317_ sky130_fd_sc_hd__mux2_1
X_4993_ RF.reg_arr\[12\]\[24\] RF.reg_arr\[13\]\[24\] RF.reg_arr\[14\]\[24\] RF.reg_arr\[15\]\[24\]
+ _1678_ _1684_ VGND VGND VPWR VPWR _1782_ sky130_fd_sc_hd__mux4_1
XFILLER_0_81_66 VGND VGND VPWR VPWR sky130_fd_sc_hd__decap_4
X_7781_ _3067_ net676 _3849_ VGND VGND VPWR VPWR _3854_ sky130_fd_sc_hd__mux2_1
XFILLER_0_14_60 VGND VGND VPWR VPWR sky130_fd_sc_hd__decap_4
X_9520_ clknet_leaf_3_CLK _0753_ VGND VGND VPWR VPWR RF.reg_arr\[10\]\[18\] sky130_fd_sc_hd__dfxtp_1
X_6732_ _3077_ net637 _3270_ VGND VGND VPWR VPWR _3280_ sky130_fd_sc_hd__mux2_1
XFILLER_0_85_293 VGND VGND VPWR VPWR sky130_fd_sc_hd__fill_1
XFILLER_0_73_444 VGND VGND VPWR VPWR sky130_fd_sc_hd__decap_4
X_9451_ clknet_leaf_89_CLK _0684_ VGND VGND VPWR VPWR RF.reg_arr\[12\]\[13\] sky130_fd_sc_hd__dfxtp_1
XFILLER_0_45_113 VGND VGND VPWR VPWR sky130_fd_sc_hd__fill_1
X_6663_ _3242_ VGND VGND VPWR VPWR _0936_ sky130_fd_sc_hd__clkbuf_1
X_5614_ _1756_ _2104_ VGND VGND VPWR VPWR _2402_ sky130_fd_sc_hd__nand2_1
XFILLER_0_73_455 VGND VGND VPWR VPWR sky130_fd_sc_hd__decap_8
X_8402_ net886 _3405_ _4174_ VGND VGND VPWR VPWR _4183_ sky130_fd_sc_hd__mux2_1
XFILLER_0_116_557 VGND VGND VPWR VPWR sky130_fd_sc_hd__decap_3
X_9382_ clknet_leaf_79_CLK _0615_ VGND VGND VPWR VPWR RF.reg_arr\[13\]\[8\] sky130_fd_sc_hd__dfxtp_1
X_6594_ net669 _3016_ _3196_ VGND VGND VPWR VPWR _3206_ sky130_fd_sc_hd__mux2_1
X_5545_ _1066_ _1090_ VGND VGND VPWR VPWR _2334_ sky130_fd_sc_hd__nand2_2
XFILLER_0_14_555 VGND VGND VPWR VPWR sky130_fd_sc_hd__decap_8
XFILLER_0_14_544 VGND VGND VPWR VPWR sky130_fd_sc_hd__fill_2
X_8333_ _4146_ VGND VGND VPWR VPWR _0678_ sky130_fd_sc_hd__clkbuf_1
X_8264_ net372 _3403_ _4102_ VGND VGND VPWR VPWR _4110_ sky130_fd_sc_hd__mux2_1
X_5476_ _2263_ _2264_ _1604_ VGND VGND VPWR VPWR _2265_ sky130_fd_sc_hd__mux2_1
X_7215_ net312 _3379_ _3543_ VGND VGND VPWR VPWR _3552_ sky130_fd_sc_hd__mux2_1
X_8195_ _4073_ VGND VGND VPWR VPWR _0613_ sky130_fd_sc_hd__clkbuf_1
X_4427_ RF.reg_arr\[8\]\[8\] RF.reg_arr\[9\]\[8\] RF.reg_arr\[10\]\[8\] RF.reg_arr\[11\]\[8\]
+ net1126 _1069_ VGND VGND VPWR VPWR _1216_ sky130_fd_sc_hd__mux4_1
X_7146_ _3515_ VGND VGND VPWR VPWR _0122_ sky130_fd_sc_hd__clkbuf_1
X_4358_ RF.reg_arr\[28\]\[17\] RF.reg_arr\[29\]\[17\] RF.reg_arr\[30\]\[17\] RF.reg_arr\[31\]\[17\]
+ _1117_ _1118_ VGND VGND VPWR VPWR _1147_ sky130_fd_sc_hd__mux4_1
X_7077_ net328 _3377_ _3471_ VGND VGND VPWR VPWR _3479_ sky130_fd_sc_hd__mux2_1
X_4289_ _1072_ _1076_ _1077_ VGND VGND VPWR VPWR _1078_ sky130_fd_sc_hd__mux2_1
X_6028_ _2781_ _2787_ _2796_ _2446_ VGND VGND VPWR VPWR net61 sky130_fd_sc_hd__o2bb2a_1
XTAP_TAPCELL_ROW_64_1017 VGND VPWR sky130_fd_sc_hd__tapvpwrvgnd_1
X_7979_ _3959_ VGND VGND VPWR VPWR _0511_ sky130_fd_sc_hd__clkbuf_1
XFILLER_0_49_474 VGND VGND VPWR VPWR sky130_fd_sc_hd__fill_2
XFILLER_0_64_433 VGND VGND VPWR VPWR sky130_fd_sc_hd__decap_4
XFILLER_0_37_647 VGND VGND VPWR VPWR sky130_fd_sc_hd__fill_1
XTAP_TAPCELL_ROW_40_726 VGND VPWR sky130_fd_sc_hd__tapvpwrvgnd_1
XTAP_TAPCELL_ROW_40_737 VGND VPWR sky130_fd_sc_hd__tapvpwrvgnd_1
XFILLER_0_107_557 VGND VGND VPWR VPWR sky130_fd_sc_hd__decap_3
XFILLER_0_45_691 VGND VGND VPWR VPWR sky130_fd_sc_hd__fill_1
XFILLER_0_17_393 VGND VGND VPWR VPWR sky130_fd_sc_hd__fill_2
XTAP_TAPCELL_ROW_20_494 VGND VPWR sky130_fd_sc_hd__tapvpwrvgnd_1
XFILLER_0_102_251 VGND VGND VPWR VPWR sky130_fd_sc_hd__fill_1
XTAP_TAPCELL_ROW_75_1157 VGND VPWR sky130_fd_sc_hd__tapvpwrvgnd_1
XTAP_TAPCELL_ROW_75_1146 VGND VPWR sky130_fd_sc_hd__tapvpwrvgnd_1
XTAP_TAPCELL_ROW_48_826 VGND VPWR sky130_fd_sc_hd__tapvpwrvgnd_1
XTAP_TAPCELL_ROW_86_1286 VGND VPWR sky130_fd_sc_hd__tapvpwrvgnd_1
XTAP_TAPCELL_ROW_28_583 VGND VPWR sky130_fd_sc_hd__tapvpwrvgnd_1
XFILLER_0_27_113 VGND VGND VPWR VPWR sky130_fd_sc_hd__decap_3
XFILLER_0_51_47 VGND VGND VPWR VPWR sky130_fd_sc_hd__decap_6
XFILLER_0_27_146 VGND VGND VPWR VPWR sky130_fd_sc_hd__fill_1
XFILLER_0_113_505 VGND VGND VPWR VPWR sky130_fd_sc_hd__decap_4
Xclkload34 clknet_leaf_24_CLK VGND VGND VPWR VPWR clkload34/Y sky130_fd_sc_hd__clkinv_1
Xclkload23 clknet_leaf_94_CLK VGND VGND VPWR VPWR clkload23/Y sky130_fd_sc_hd__clkinvlp_4
Xclkload12 clknet_leaf_7_CLK VGND VGND VPWR VPWR clkload12/Y sky130_fd_sc_hd__inv_6
Xclkload45 clknet_leaf_33_CLK VGND VGND VPWR VPWR clkload45/Y sky130_fd_sc_hd__clkinv_1
XFILLER_0_11_525 VGND VGND VPWR VPWR sky130_fd_sc_hd__fill_1
XFILLER_0_2_246 VGND VGND VPWR VPWR sky130_fd_sc_hd__decap_6
Xclkload67 clknet_leaf_99_CLK VGND VGND VPWR VPWR clkload67/Y sky130_fd_sc_hd__clkinvlp_4
Xclkload78 clknet_leaf_80_CLK VGND VGND VPWR VPWR clkload78/Y sky130_fd_sc_hd__inv_8
Xclkload56 clknet_leaf_85_CLK VGND VGND VPWR VPWR clkload56/Y sky130_fd_sc_hd__inv_8
X_5330_ _1842_ _2118_ _1585_ VGND VGND VPWR VPWR _2119_ sky130_fd_sc_hd__a21oi_1
Xclkload89 clknet_leaf_52_CLK VGND VGND VPWR VPWR clkload89/Y sky130_fd_sc_hd__clkinvlp_4
X_5261_ _2049_ VGND VGND VPWR VPWR _2050_ sky130_fd_sc_hd__buf_2
X_7000_ net411 _3437_ _3431_ VGND VGND VPWR VPWR _3438_ sky130_fd_sc_hd__mux2_1
X_5192_ _1895_ _1980_ _1667_ VGND VGND VPWR VPWR _1981_ sky130_fd_sc_hd__o21ai_1
X_8951_ clknet_leaf_32_CLK _0184_ VGND VGND VPWR VPWR RF.reg_arr\[29\]\[25\] sky130_fd_sc_hd__dfxtp_1
X_7902_ _3119_ net694 _3908_ VGND VGND VPWR VPWR _3918_ sky130_fd_sc_hd__mux2_1
X_8882_ clknet_leaf_14_CLK _0115_ VGND VGND VPWR VPWR RF.reg_arr\[3\]\[20\] sky130_fd_sc_hd__dfxtp_1
X_7833_ _3119_ net590 _3871_ VGND VGND VPWR VPWR _3881_ sky130_fd_sc_hd__mux2_1
X_7764_ _3844_ VGND VGND VPWR VPWR _0411_ sky130_fd_sc_hd__clkbuf_1
X_4976_ RF.reg_arr\[0\]\[27\] RF.reg_arr\[1\]\[27\] RF.reg_arr\[2\]\[27\] RF.reg_arr\[3\]\[27\]
+ _1626_ _1628_ VGND VGND VPWR VPWR _1765_ sky130_fd_sc_hd__mux4_1
X_9503_ clknet_leaf_57_CLK _0736_ VGND VGND VPWR VPWR RF.reg_arr\[10\]\[1\] sky130_fd_sc_hd__dfxtp_1
X_6715_ _3271_ VGND VGND VPWR VPWR _0959_ sky130_fd_sc_hd__clkbuf_1
X_7695_ _3117_ net679 _3799_ VGND VGND VPWR VPWR _3808_ sky130_fd_sc_hd__mux2_1
X_9434_ clknet_leaf_31_CLK _0667_ VGND VGND VPWR VPWR RF.reg_arr\[17\]\[28\] sky130_fd_sc_hd__dfxtp_1
XFILLER_0_6_541 VGND VGND VPWR VPWR sky130_fd_sc_hd__fill_2
Xclkload6 clknet_leaf_0_CLK VGND VGND VPWR VPWR clkload6/Y sky130_fd_sc_hd__inv_6
X_6646_ _3061_ net396 _3232_ VGND VGND VPWR VPWR _3234_ sky130_fd_sc_hd__mux2_1
X_9365_ clknet_leaf_17_CLK _0598_ VGND VGND VPWR VPWR RF.reg_arr\[18\]\[23\] sky130_fd_sc_hd__dfxtp_1
XFILLER_0_61_447 VGND VGND VPWR VPWR sky130_fd_sc_hd__fill_1
X_6577_ _3197_ VGND VGND VPWR VPWR _0895_ sky130_fd_sc_hd__clkbuf_1
X_5528_ _2315_ _2316_ net3 VGND VGND VPWR VPWR _2317_ sky130_fd_sc_hd__mux2_1
X_8316_ _3702_ _3268_ VGND VGND VPWR VPWR _4137_ sky130_fd_sc_hd__nand2_4
X_9296_ clknet_leaf_106_CLK _0529_ VGND VGND VPWR VPWR RF.reg_arr\[25\]\[18\] sky130_fd_sc_hd__dfxtp_1
X_8247_ _4100_ VGND VGND VPWR VPWR _0638_ sky130_fd_sc_hd__clkbuf_1
X_5459_ _1604_ _2247_ _1844_ VGND VGND VPWR VPWR _2248_ sky130_fd_sc_hd__o21a_1
X_8178_ net359 _3385_ _4029_ VGND VGND VPWR VPWR _4064_ sky130_fd_sc_hd__mux2_1
X_7129_ _3506_ VGND VGND VPWR VPWR _0114_ sky130_fd_sc_hd__clkbuf_1
XTAP_TAPCELL_ROW_70_1087 VGND VPWR sky130_fd_sc_hd__tapvpwrvgnd_1
XFILLER_0_69_569 VGND VGND VPWR VPWR sky130_fd_sc_hd__fill_2
XFILLER_0_69_558 VGND VGND VPWR VPWR sky130_fd_sc_hd__fill_2
XTAP_TAPCELL_ROW_25_553 VGND VPWR sky130_fd_sc_hd__tapvpwrvgnd_1
XTAP_TAPCELL_ROW_53_884 VGND VPWR sky130_fd_sc_hd__tapvpwrvgnd_1
XFILLER_0_107_376 VGND VGND VPWR VPWR sky130_fd_sc_hd__decap_6
Xclkbuf_leaf_70_CLK clknet_3_5__leaf_CLK VGND VGND VPWR VPWR clknet_leaf_70_CLK sky130_fd_sc_hd__clkbuf_8
XTAP_TAPCELL_ROW_88_1304 VGND VPWR sky130_fd_sc_hd__tapvpwrvgnd_1
XFILLER_0_1_27 VPWR VGND VPWR VGND sky130_ef_sc_hd__decap_12
X_4830_ _1618_ VGND VGND VPWR VPWR _1619_ sky130_fd_sc_hd__buf_4
XFILLER_0_75_517 VGND VGND VPWR VPWR sky130_fd_sc_hd__decap_6
X_4761_ _1517_ _1533_ net83 VGND VGND VPWR VPWR _1550_ sky130_fd_sc_hd__nor3b_4
XFILLER_0_83_561 VPWR VGND VPWR VGND sky130_ef_sc_hd__decap_12
XTAP_TAPCELL_ROW_99_1444 VGND VPWR sky130_fd_sc_hd__tapvpwrvgnd_1
XFILLER_0_83_594 VGND VGND VPWR VPWR sky130_fd_sc_hd__fill_1
X_7480_ _3693_ VGND VGND VPWR VPWR _0278_ sky130_fd_sc_hd__clkbuf_1
X_6500_ net119 VGND VGND VPWR VPWR _3155_ sky130_fd_sc_hd__clkbuf_1
X_4692_ _1479_ _1480_ _1281_ VGND VGND VPWR VPWR _1481_ sky130_fd_sc_hd__mux2_1
XFILLER_0_16_628 VGND VGND VPWR VPWR sky130_fd_sc_hd__fill_2
X_6431_ net35 VGND VGND VPWR VPWR _3119_ sky130_fd_sc_hd__clkbuf_2
Xclkload101 clknet_leaf_61_CLK VGND VGND VPWR VPWR clkload101/Y sky130_fd_sc_hd__clkinvlp_4
XFILLER_0_3_500 VGND VGND VPWR VPWR sky130_fd_sc_hd__decap_4
XFILLER_0_43_447 VGND VGND VPWR VPWR sky130_fd_sc_hd__fill_1
XFILLER_0_113_335 VGND VGND VPWR VPWR sky130_fd_sc_hd__fill_1
X_6362_ _3072_ VGND VGND VPWR VPWR _0805_ sky130_fd_sc_hd__clkbuf_1
X_9150_ clknet_leaf_72_CLK _0383_ VGND VGND VPWR VPWR RF.reg_arr\[9\]\[0\] sky130_fd_sc_hd__dfxtp_1
X_8101_ _4023_ VGND VGND VPWR VPWR _0569_ sky130_fd_sc_hd__clkbuf_1
Xclkbuf_leaf_61_CLK clknet_3_7__leaf_CLK VGND VGND VPWR VPWR clknet_leaf_61_CLK sky130_fd_sc_hd__clkbuf_8
XFILLER_0_11_333 VGND VGND VPWR VPWR sky130_fd_sc_hd__decap_3
X_5313_ _2096_ _2098_ _2101_ _1635_ _1585_ VGND VGND VPWR VPWR _2102_ sky130_fd_sc_hd__a221o_1
X_9081_ clknet_leaf_39_CLK _0314_ VGND VGND VPWR VPWR RF.reg_arr\[28\]\[27\] sky130_fd_sc_hd__dfxtp_1
XFILLER_0_87_65 VGND VGND VPWR VPWR sky130_fd_sc_hd__fill_1
X_6293_ net382 _3027_ _3019_ VGND VGND VPWR VPWR _3028_ sky130_fd_sc_hd__mux2_1
X_8032_ _2982_ net1080 _3980_ VGND VGND VPWR VPWR _3987_ sky130_fd_sc_hd__mux2_1
XFILLER_0_11_399 VGND VGND VPWR VPWR sky130_fd_sc_hd__fill_1
X_5244_ RF.reg_arr\[28\]\[0\] RF.reg_arr\[29\]\[0\] RF.reg_arr\[30\]\[0\] RF.reg_arr\[31\]\[0\]
+ _1622_ _1595_ VGND VGND VPWR VPWR _2033_ sky130_fd_sc_hd__mux4_1
Xhold29 RF.reg_arr\[0\]\[29\] VGND VGND VPWR VPWR net111 sky130_fd_sc_hd__dlygate4sd3_1
Xhold18 RF.reg_arr\[0\]\[23\] VGND VGND VPWR VPWR net100 sky130_fd_sc_hd__dlygate4sd3_1
X_5175_ _1643_ _1955_ _1959_ _1963_ VGND VGND VPWR VPWR _1964_ sky130_fd_sc_hd__a2bb2o_4
XFILLER_0_39_3 VGND VGND VPWR VPWR sky130_fd_sc_hd__fill_1
X_8934_ clknet_leaf_82_CLK _0167_ VGND VGND VPWR VPWR RF.reg_arr\[29\]\[8\] sky130_fd_sc_hd__dfxtp_1
XTAP_TAPCELL_ROW_108_1551 VGND VPWR sky130_fd_sc_hd__tapvpwrvgnd_1
X_8865_ clknet_leaf_61_CLK _0098_ VGND VGND VPWR VPWR RF.reg_arr\[3\]\[3\] sky130_fd_sc_hd__dfxtp_1
X_7816_ _3872_ VGND VGND VPWR VPWR _0435_ sky130_fd_sc_hd__clkbuf_1
X_8796_ clknet_leaf_22_CLK _0029_ VGND VGND VPWR VPWR RF.reg_arr\[5\]\[30\] sky130_fd_sc_hd__dfxtp_1
X_4959_ _1619_ _1747_ VGND VGND VPWR VPWR _1748_ sky130_fd_sc_hd__nor2_1
X_7747_ net168 _3430_ _3835_ VGND VGND VPWR VPWR _3836_ sky130_fd_sc_hd__mux2_1
XTAP_TAPCELL_ROW_22_512 VGND VPWR sky130_fd_sc_hd__tapvpwrvgnd_1
X_7678_ _3776_ VGND VGND VPWR VPWR _3799_ sky130_fd_sc_hd__clkbuf_8
XTAP_TAPCELL_ROW_50_854 VGND VPWR sky130_fd_sc_hd__tapvpwrvgnd_1
XFILLER_0_116_162 VGND VGND VPWR VPWR sky130_fd_sc_hd__decap_3
X_6629_ _3224_ VGND VGND VPWR VPWR _0920_ sky130_fd_sc_hd__clkbuf_1
X_9417_ clknet_leaf_13_CLK _0650_ VGND VGND VPWR VPWR RF.reg_arr\[17\]\[11\] sky130_fd_sc_hd__dfxtp_1
XFILLER_0_34_458 VGND VGND VPWR VPWR sky130_fd_sc_hd__fill_2
Xclkbuf_leaf_52_CLK clknet_3_6__leaf_CLK VGND VGND VPWR VPWR clknet_leaf_52_CLK sky130_fd_sc_hd__clkbuf_8
XFILLER_0_104_357 VGND VGND VPWR VPWR sky130_fd_sc_hd__decap_6
X_9348_ clknet_leaf_83_CLK _0581_ VGND VGND VPWR VPWR RF.reg_arr\[18\]\[6\] sky130_fd_sc_hd__dfxtp_1
XTAP_TAPCELL_ROW_72_1116 VGND VPWR sky130_fd_sc_hd__tapvpwrvgnd_1
X_9279_ clknet_leaf_56_CLK _0512_ VGND VGND VPWR VPWR RF.reg_arr\[25\]\[1\] sky130_fd_sc_hd__dfxtp_1
XFILLER_0_30_653 VGND VGND VPWR VPWR sky130_fd_sc_hd__decap_6
XFILLER_0_100_530 VGND VGND VPWR VPWR sky130_fd_sc_hd__fill_2
XFILLER_0_100_585 VGND VGND VPWR VPWR sky130_fd_sc_hd__decap_3
XTAP_TAPCELL_ROW_58_943 VGND VPWR sky130_fd_sc_hd__tapvpwrvgnd_1
XTAP_TAPCELL_ROW_2_270 VGND VPWR sky130_fd_sc_hd__tapvpwrvgnd_1
XTAP_TAPCELL_ROW_2_281 VGND VPWR sky130_fd_sc_hd__tapvpwrvgnd_1
XTAP_TAPCELL_ROW_83_1245 VGND VPWR sky130_fd_sc_hd__tapvpwrvgnd_1
XFILLER_0_69_366 VGND VGND VPWR VPWR sky130_fd_sc_hd__fill_2
XFILLER_0_84_325 VGND VGND VPWR VPWR sky130_fd_sc_hd__decap_6
XFILLER_0_32_27 VGND VGND VPWR VPWR sky130_fd_sc_hd__fill_1
XFILLER_0_32_38 VGND VGND VPWR VPWR sky130_fd_sc_hd__decap_4
XFILLER_0_37_252 VGND VGND VPWR VPWR sky130_fd_sc_hd__decap_4
XFILLER_0_108_641 VGND VGND VPWR VPWR sky130_fd_sc_hd__decap_3
XFILLER_0_25_458 VGND VGND VPWR VPWR sky130_fd_sc_hd__fill_1
XFILLER_0_80_564 VPWR VGND VPWR VGND sky130_ef_sc_hd__decap_12
Xclkbuf_leaf_43_CLK clknet_3_3__leaf_CLK VGND VGND VPWR VPWR clknet_leaf_43_CLK sky130_fd_sc_hd__clkbuf_8
XFILLER_0_0_503 VGND VGND VPWR VPWR sky130_fd_sc_hd__fill_1
XTAP_TAPCELL_ROW_94_1374 VGND VPWR sky130_fd_sc_hd__tapvpwrvgnd_1
XTAP_TAPCELL_ROW_94_1385 VGND VPWR sky130_fd_sc_hd__tapvpwrvgnd_1
XFILLER_0_0_558 VGND VGND VPWR VPWR sky130_fd_sc_hd__fill_2
XFILLER_0_20_174 VGND VGND VPWR VPWR sky130_fd_sc_hd__fill_1
XFILLER_0_73_12 VGND VGND VPWR VPWR sky130_fd_sc_hd__fill_1
XFILLER_0_73_34 VGND VGND VPWR VPWR sky130_fd_sc_hd__fill_1
X_6980_ net22 VGND VGND VPWR VPWR _3424_ sky130_fd_sc_hd__buf_2
X_5931_ _2394_ _2398_ VGND VGND VPWR VPWR _2705_ sky130_fd_sc_hd__nand2_1
XFILLER_0_88_675 VGND VGND VPWR VPWR sky130_fd_sc_hd__fill_2
X_5862_ _2067_ _2623_ VGND VGND VPWR VPWR _2640_ sky130_fd_sc_hd__or2b_1
X_8650_ clknet_leaf_84_CLK _0907_ VGND VGND VPWR VPWR RF.reg_arr\[8\]\[12\] sky130_fd_sc_hd__dfxtp_1
XFILLER_0_90_306 VGND VGND VPWR VPWR sky130_fd_sc_hd__fill_2
X_5793_ _2572_ _2573_ VGND VGND VPWR VPWR _2574_ sky130_fd_sc_hd__or2_1
X_4813_ RF.reg_arr\[28\]\[31\] RF.reg_arr\[29\]\[31\] RF.reg_arr\[30\]\[31\] RF.reg_arr\[31\]\[31\]
+ _1593_ _1600_ VGND VGND VPWR VPWR _1602_ sky130_fd_sc_hd__mux4_1
XFILLER_0_8_625 VGND VGND VPWR VPWR sky130_fd_sc_hd__fill_2
XFILLER_0_7_113 VGND VGND VPWR VPWR sky130_fd_sc_hd__decap_4
X_7601_ _3758_ VGND VGND VPWR VPWR _0334_ sky130_fd_sc_hd__clkbuf_1
X_8581_ clknet_leaf_88_CLK _0838_ VGND VGND VPWR VPWR RF.reg_arr\[0\]\[7\] sky130_fd_sc_hd__dfxtp_1
XTAP_TAPCELL_ROW_103_1492 VGND VPWR sky130_fd_sc_hd__tapvpwrvgnd_1
X_7532_ net1079 _3420_ _3716_ VGND VGND VPWR VPWR _3722_ sky130_fd_sc_hd__mux2_1
X_4744_ _1116_ _1524_ _1528_ _1532_ VGND VGND VPWR VPWR _1533_ sky130_fd_sc_hd__o22a_4
XFILLER_0_98_20 VGND VGND VPWR VPWR sky130_fd_sc_hd__decap_8
X_4675_ RF.reg_arr\[0\]\[31\] RF.reg_arr\[1\]\[31\] RF.reg_arr\[2\]\[31\] RF.reg_arr\[3\]\[31\]
+ _1303_ _1305_ VGND VGND VPWR VPWR _1464_ sky130_fd_sc_hd__mux4_1
X_9202_ clknet_leaf_15_CLK _0435_ VGND VGND VPWR VPWR RF.reg_arr\[24\]\[20\] sky130_fd_sc_hd__dfxtp_1
X_7463_ _3684_ VGND VGND VPWR VPWR _0270_ sky130_fd_sc_hd__clkbuf_1
Xclkbuf_leaf_34_CLK clknet_3_3__leaf_CLK VGND VGND VPWR VPWR clknet_leaf_34_CLK sky130_fd_sc_hd__clkbuf_8
X_6414_ _3107_ net1083 _3101_ VGND VGND VPWR VPWR _3108_ sky130_fd_sc_hd__mux2_1
XFILLER_0_12_620 VPWR VGND VPWR VGND sky130_ef_sc_hd__decap_12
X_7394_ _3647_ VGND VGND VPWR VPWR _0238_ sky130_fd_sc_hd__clkbuf_1
XFILLER_0_113_187 VGND VGND VPWR VPWR sky130_fd_sc_hd__fill_1
X_6345_ net25 VGND VGND VPWR VPWR _3061_ sky130_fd_sc_hd__clkbuf_2
X_9133_ clknet_leaf_105_CLK _0366_ VGND VGND VPWR VPWR RF.reg_arr\[30\]\[15\] sky130_fd_sc_hd__dfxtp_1
X_9064_ clknet_leaf_11_CLK _0297_ VGND VGND VPWR VPWR RF.reg_arr\[28\]\[10\] sky130_fd_sc_hd__dfxtp_1
X_6276_ net45 VGND VGND VPWR VPWR _3016_ sky130_fd_sc_hd__clkbuf_4
X_8015_ _3035_ net1015 _3969_ VGND VGND VPWR VPWR _3978_ sky130_fd_sc_hd__mux2_1
X_5227_ _1077_ _2015_ VGND VGND VPWR VPWR _2016_ sky130_fd_sc_hd__nand2_1
X_5158_ _1589_ VGND VGND VPWR VPWR _1947_ sky130_fd_sc_hd__clkbuf_8
X_5089_ _1835_ VGND VGND VPWR VPWR _1878_ sky130_fd_sc_hd__clkbuf_4
X_8917_ clknet_leaf_41_CLK _0150_ VGND VGND VPWR VPWR RF.reg_arr\[7\]\[23\] sky130_fd_sc_hd__dfxtp_1
XTAP_TAPCELL_ROW_55_913 VGND VPWR sky130_fd_sc_hd__tapvpwrvgnd_1
XFILLER_0_93_122 VGND VGND VPWR VPWR sky130_fd_sc_hd__fill_1
XFILLER_0_66_336 VGND VGND VPWR VPWR sky130_fd_sc_hd__fill_2
X_8848_ clknet_leaf_0_CLK _0081_ VGND VGND VPWR VPWR RF.reg_arr\[19\]\[18\] sky130_fd_sc_hd__dfxtp_1
XFILLER_0_66_369 VGND VGND VPWR VPWR sky130_fd_sc_hd__fill_1
XTAP_TAPCELL_ROW_35_670 VGND VPWR sky130_fd_sc_hd__tapvpwrvgnd_1
X_8779_ clknet_leaf_88_CLK _0012_ VGND VGND VPWR VPWR RF.reg_arr\[5\]\[13\] sky130_fd_sc_hd__dfxtp_1
XFILLER_0_93_166 VGND VGND VPWR VPWR sky130_fd_sc_hd__fill_2
XFILLER_0_19_263 VGND VGND VPWR VPWR sky130_fd_sc_hd__decap_6
XFILLER_0_34_211 VGND VGND VPWR VPWR sky130_fd_sc_hd__fill_2
XFILLER_0_22_417 VGND VGND VPWR VPWR sky130_fd_sc_hd__decap_3
XFILLER_0_105_677 VGND VGND VPWR VPWR sky130_fd_sc_hd__fill_2
Xclkbuf_leaf_25_CLK clknet_3_2__leaf_CLK VGND VGND VPWR VPWR clknet_leaf_25_CLK sky130_fd_sc_hd__clkbuf_8
XTAP_TAPCELL_ROW_7_340 VGND VPWR sky130_fd_sc_hd__tapvpwrvgnd_1
XFILLER_0_100_393 VGND VGND VPWR VPWR sky130_fd_sc_hd__fill_1
XFILLER_0_97_461 VGND VGND VPWR VPWR sky130_fd_sc_hd__decap_6
XFILLER_0_85_656 VGND VGND VPWR VPWR sky130_fd_sc_hd__fill_1
XTAP_TAPCELL_ROW_96_1403 VGND VPWR sky130_fd_sc_hd__tapvpwrvgnd_1
Xclkbuf_leaf_16_CLK clknet_3_3__leaf_CLK VGND VGND VPWR VPWR clknet_leaf_16_CLK sky130_fd_sc_hd__clkbuf_8
XFILLER_0_7_15 VPWR VGND VPWR VGND sky130_ef_sc_hd__decap_12
X_4460_ _1041_ _1248_ VGND VGND VPWR VPWR _1249_ sky130_fd_sc_hd__or2_1
Xhold307 RF.reg_arr\[3\]\[10\] VGND VGND VPWR VPWR net389 sky130_fd_sc_hd__dlygate4sd3_1
Xhold329 RF.reg_arr\[4\]\[23\] VGND VGND VPWR VPWR net411 sky130_fd_sc_hd__dlygate4sd3_1
Xhold318 RF.reg_arr\[28\]\[3\] VGND VGND VPWR VPWR net400 sky130_fd_sc_hd__dlygate4sd3_1
X_4391_ _1133_ _1179_ _1158_ VGND VGND VPWR VPWR _1180_ sky130_fd_sc_hd__o21a_1
X_6130_ _2862_ _2873_ VGND VGND VPWR VPWR _2893_ sky130_fd_sc_hd__or2b_1
XFILLER_0_110_157 VGND VGND VPWR VPWR sky130_fd_sc_hd__fill_2
XFILLER_0_68_89 VGND VGND VPWR VPWR sky130_fd_sc_hd__fill_1
X_6061_ _1384_ VGND VGND VPWR VPWR _2827_ sky130_fd_sc_hd__inv_2
X_5012_ _1613_ _1800_ VGND VGND VPWR VPWR _1801_ sky130_fd_sc_hd__and2_1
Xhold1007 RF.reg_arr\[30\]\[31\] VGND VGND VPWR VPWR net1089 sky130_fd_sc_hd__dlygate4sd3_1
Xhold1018 RF.reg_arr\[12\]\[14\] VGND VGND VPWR VPWR net1100 sky130_fd_sc_hd__dlygate4sd3_1
Xhold1029 RF.reg_arr\[23\]\[19\] VGND VGND VPWR VPWR net1111 sky130_fd_sc_hd__dlygate4sd3_1
XFILLER_0_84_66 VGND VGND VPWR VPWR sky130_fd_sc_hd__fill_1
XTAP_TAPCELL_ROW_105_1510 VGND VPWR sky130_fd_sc_hd__tapvpwrvgnd_1
XFILLER_0_76_601 VGND VGND VPWR VPWR sky130_fd_sc_hd__fill_1
X_6963_ net230 _3412_ _3410_ VGND VGND VPWR VPWR _3413_ sky130_fd_sc_hd__mux2_1
X_5914_ _2525_ _2688_ _2022_ VGND VGND VPWR VPWR _2689_ sky130_fd_sc_hd__mux2_1
X_6894_ net233 _3039_ _3366_ VGND VGND VPWR VPWR _3367_ sky130_fd_sc_hd__mux2_1
X_8702_ clknet_leaf_71_CLK _0959_ VGND VGND VPWR VPWR RF.reg_arr\[14\]\[0\] sky130_fd_sc_hd__dfxtp_1
X_8633_ clknet_leaf_37_CLK _0890_ VGND VGND VPWR VPWR RF.reg_arr\[16\]\[27\] sky130_fd_sc_hd__dfxtp_1
X_5845_ _2067_ _2623_ VGND VGND VPWR VPWR _2624_ sky130_fd_sc_hd__xnor2_2
XFILLER_0_29_550 VGND VGND VPWR VPWR sky130_fd_sc_hd__fill_1
XFILLER_0_48_347 VGND VGND VPWR VPWR sky130_fd_sc_hd__fill_1
XTAP_TAPCELL_ROW_32_640 VGND VPWR sky130_fd_sc_hd__tapvpwrvgnd_1
XFILLER_0_106_419 VGND VGND VPWR VPWR sky130_fd_sc_hd__fill_1
X_5776_ _2463_ _2489_ _2557_ _2022_ VGND VGND VPWR VPWR _2558_ sky130_fd_sc_hd__a2bb2o_1
X_8564_ clknet_leaf_60_CLK _0821_ VGND VGND VPWR VPWR RF.reg_arr\[23\]\[22\] sky130_fd_sc_hd__dfxtp_1
XTAP_TAPCELL_ROW_60_971 VGND VPWR sky130_fd_sc_hd__tapvpwrvgnd_1
X_8495_ _4231_ VGND VGND VPWR VPWR _0755_ sky130_fd_sc_hd__clkbuf_1
X_4727_ _1159_ _1507_ _1511_ _1515_ VGND VGND VPWR VPWR _1516_ sky130_fd_sc_hd__a22o_1
X_7515_ net1040 _3403_ _3705_ VGND VGND VPWR VPWR _3713_ sky130_fd_sc_hd__mux2_1
XFILLER_0_44_553 VGND VGND VPWR VPWR sky130_fd_sc_hd__decap_4
XFILLER_0_114_430 VGND VGND VPWR VPWR sky130_fd_sc_hd__decap_3
X_4658_ _1432_ _1446_ VGND VGND VPWR VPWR _1447_ sky130_fd_sc_hd__nand2_1
XFILLER_0_71_383 VGND VGND VPWR VPWR sky130_fd_sc_hd__fill_1
XFILLER_0_4_661 VPWR VGND VPWR VGND sky130_ef_sc_hd__decap_12
X_7446_ _3675_ VGND VGND VPWR VPWR _0262_ sky130_fd_sc_hd__clkbuf_1
XFILLER_0_31_225 VGND VGND VPWR VPWR sky130_fd_sc_hd__decap_8
XTAP_TAPCELL_ROW_116_1661 VGND VPWR sky130_fd_sc_hd__tapvpwrvgnd_1
XTAP_TAPCELL_ROW_116_1650 VGND VPWR sky130_fd_sc_hd__tapvpwrvgnd_1
XFILLER_0_102_625 VGND VGND VPWR VPWR sky130_fd_sc_hd__decap_8
XFILLER_0_102_614 VGND VGND VPWR VPWR sky130_fd_sc_hd__fill_2
Xhold830 RF.reg_arr\[31\]\[7\] VGND VGND VPWR VPWR net912 sky130_fd_sc_hd__dlygate4sd3_1
XFILLER_0_102_669 VGND VGND VPWR VPWR sky130_fd_sc_hd__decap_8
X_9116_ clknet_leaf_23_CLK _0349_ VGND VGND VPWR VPWR RF.reg_arr\[2\]\[30\] sky130_fd_sc_hd__dfxtp_1
X_4589_ _1126_ _1377_ VGND VGND VPWR VPWR _1378_ sky130_fd_sc_hd__nand2_1
Xhold852 RF.reg_arr\[16\]\[4\] VGND VGND VPWR VPWR net934 sky130_fd_sc_hd__dlygate4sd3_1
X_7377_ _3638_ VGND VGND VPWR VPWR _0230_ sky130_fd_sc_hd__clkbuf_1
Xhold863 RF.reg_arr\[26\]\[0\] VGND VGND VPWR VPWR net945 sky130_fd_sc_hd__dlygate4sd3_1
Xhold841 RF.reg_arr\[31\]\[18\] VGND VGND VPWR VPWR net923 sky130_fd_sc_hd__dlygate4sd3_1
X_6328_ _3050_ VGND VGND VPWR VPWR _0793_ sky130_fd_sc_hd__clkbuf_1
Xhold896 RF.reg_arr\[13\]\[21\] VGND VGND VPWR VPWR net978 sky130_fd_sc_hd__dlygate4sd3_1
Xhold874 RF.reg_arr\[12\]\[23\] VGND VGND VPWR VPWR net956 sky130_fd_sc_hd__dlygate4sd3_1
Xhold885 RF.reg_arr\[15\]\[5\] VGND VGND VPWR VPWR net967 sky130_fd_sc_hd__dlygate4sd3_1
XFILLER_0_110_691 VGND VGND VPWR VPWR sky130_fd_sc_hd__fill_1
X_9047_ clknet_leaf_31_CLK _0280_ VGND VGND VPWR VPWR RF.reg_arr\[26\]\[25\] sky130_fd_sc_hd__dfxtp_1
X_6259_ net241 _3004_ _2998_ VGND VGND VPWR VPWR _3005_ sky130_fd_sc_hd__mux2_1
XFILLER_0_98_214 VGND VGND VPWR VPWR sky130_fd_sc_hd__fill_1
XFILLER_0_98_247 VGND VGND VPWR VPWR sky130_fd_sc_hd__fill_2
XFILLER_0_98_269 VGND VGND VPWR VPWR sky130_fd_sc_hd__decap_4
XTAP_TAPCELL_ROW_67_1059 VGND VPWR sky130_fd_sc_hd__tapvpwrvgnd_1
XTAP_TAPCELL_ROW_80_1215 VGND VPWR sky130_fd_sc_hd__tapvpwrvgnd_1
XPHY_EDGE_ROW_11_Right_11 VGND VGND VPWR VPWR sky130_fd_sc_hd__decap_3
XFILLER_0_94_475 VGND VGND VPWR VPWR sky130_fd_sc_hd__fill_1
XFILLER_0_82_637 VGND VGND VPWR VPWR sky130_fd_sc_hd__fill_1
XFILLER_0_47_391 VGND VGND VPWR VPWR sky130_fd_sc_hd__fill_1
XFILLER_0_90_670 VGND VGND VPWR VPWR sky130_fd_sc_hd__decap_6
XFILLER_0_81_169 VGND VGND VPWR VPWR sky130_fd_sc_hd__decap_6
XTAP_TAPCELL_ROW_10_367 VGND VPWR sky130_fd_sc_hd__tapvpwrvgnd_1
XFILLER_0_10_409 VGND VGND VPWR VPWR sky130_fd_sc_hd__decap_3
XTAP_TAPCELL_ROW_78_1188 VGND VPWR sky130_fd_sc_hd__tapvpwrvgnd_1
XTAP_TAPCELL_ROW_91_1344 VGND VPWR sky130_fd_sc_hd__tapvpwrvgnd_1
XPHY_EDGE_ROW_20_Right_20 VGND VGND VPWR VPWR sky130_fd_sc_hd__decap_3
XFILLER_0_89_203 VGND VGND VPWR VPWR sky130_fd_sc_hd__decap_4
Xclkbuf_leaf_5_CLK clknet_3_0__leaf_CLK VGND VGND VPWR VPWR clknet_leaf_5_CLK sky130_fd_sc_hd__clkbuf_8
XTAP_TAPCELL_ROW_18_467 VGND VPWR sky130_fd_sc_hd__tapvpwrvgnd_1
XFILLER_0_58_645 VGND VGND VPWR VPWR sky130_fd_sc_hd__decap_3
XTAP_TAPCELL_ROW_46_798 VGND VPWR sky130_fd_sc_hd__tapvpwrvgnd_1
XFILLER_0_73_637 VGND VGND VPWR VPWR sky130_fd_sc_hd__decap_8
XTAP_TAPCELL_ROW_100_1451 VGND VPWR sky130_fd_sc_hd__tapvpwrvgnd_1
X_5630_ _2340_ _2347_ _2417_ VGND VGND VPWR VPWR net60 sky130_fd_sc_hd__a21oi_1
X_5561_ _2348_ VGND VGND VPWR VPWR _2349_ sky130_fd_sc_hd__inv_2
XFILLER_0_60_309 VGND VGND VPWR VPWR sky130_fd_sc_hd__fill_2
XFILLER_0_5_447 VGND VGND VPWR VPWR sky130_fd_sc_hd__fill_1
XFILLER_0_26_542 VGND VGND VPWR VPWR sky130_fd_sc_hd__fill_1
X_4512_ _1297_ _1300_ _1282_ VGND VGND VPWR VPWR _1301_ sky130_fd_sc_hd__mux2_1
XFILLER_0_13_225 VPWR VGND VPWR VGND sky130_ef_sc_hd__decap_12
X_8280_ _4118_ VGND VGND VPWR VPWR _0653_ sky130_fd_sc_hd__clkbuf_1
XFILLER_0_26_586 VGND VGND VPWR VPWR sky130_fd_sc_hd__fill_2
X_7300_ _3065_ net718 _3594_ VGND VGND VPWR VPWR _3598_ sky130_fd_sc_hd__mux2_1
X_5492_ RF.reg_arr\[24\]\[3\] RF.reg_arr\[25\]\[3\] RF.reg_arr\[26\]\[3\] RF.reg_arr\[27\]\[3\]
+ _1588_ _1679_ VGND VGND VPWR VPWR _2281_ sky130_fd_sc_hd__mux4_1
Xhold104 RF.reg_arr\[5\]\[25\] VGND VGND VPWR VPWR net186 sky130_fd_sc_hd__dlygate4sd3_1
Xhold115 RF.reg_arr\[1\]\[8\] VGND VGND VPWR VPWR net197 sky130_fd_sc_hd__dlygate4sd3_1
Xhold126 RF.reg_arr\[13\]\[10\] VGND VGND VPWR VPWR net208 sky130_fd_sc_hd__dlygate4sd3_1
X_7231_ _3561_ VGND VGND VPWR VPWR _0161_ sky130_fd_sc_hd__clkbuf_1
Xhold137 RF.reg_arr\[10\]\[21\] VGND VGND VPWR VPWR net219 sky130_fd_sc_hd__dlygate4sd3_1
Xhold148 RF.reg_arr\[4\]\[11\] VGND VGND VPWR VPWR net230 sky130_fd_sc_hd__dlygate4sd3_1
XFILLER_0_1_653 VPWR VGND VPWR VGND sky130_ef_sc_hd__decap_12
X_4443_ _1041_ _1231_ VGND VGND VPWR VPWR _1232_ sky130_fd_sc_hd__or2_1
Xhold159 RF.reg_arr\[1\]\[3\] VGND VGND VPWR VPWR net241 sky130_fd_sc_hd__dlygate4sd3_1
X_7162_ _3524_ VGND VGND VPWR VPWR _0129_ sky130_fd_sc_hd__clkbuf_1
X_4374_ _1116_ VGND VGND VPWR VPWR _1163_ sky130_fd_sc_hd__buf_4
X_6113_ _1790_ _1809_ _1115_ VGND VGND VPWR VPWR _2877_ sky130_fd_sc_hd__mux2_1
X_7093_ net401 _3393_ _3485_ VGND VGND VPWR VPWR _3488_ sky130_fd_sc_hd__mux2_1
XTAP_TAPCELL_ROW_111_1580 VGND VPWR sky130_fd_sc_hd__tapvpwrvgnd_1
XFILLER_0_95_76 VPWR VGND VPWR VGND sky130_ef_sc_hd__decap_12
X_6044_ _1349_ _1367_ VGND VGND VPWR VPWR _2811_ sky130_fd_sc_hd__nand2_1
XFILLER_0_28_81 VGND VGND VPWR VPWR sky130_fd_sc_hd__decap_3
X_7995_ _3967_ VGND VGND VPWR VPWR _0519_ sky130_fd_sc_hd__clkbuf_1
X_6946_ net42 VGND VGND VPWR VPWR _3401_ sky130_fd_sc_hd__buf_2
X_6877_ net707 _3023_ _3355_ VGND VGND VPWR VPWR _3358_ sky130_fd_sc_hd__mux2_1
X_5828_ _2606_ _2607_ VGND VGND VPWR VPWR _2608_ sky130_fd_sc_hd__xnor2_1
X_8616_ clknet_leaf_10_CLK _0873_ VGND VGND VPWR VPWR RF.reg_arr\[16\]\[10\] sky130_fd_sc_hd__dfxtp_1
XFILLER_0_106_238 VGND VGND VPWR VPWR sky130_fd_sc_hd__fill_1
X_5759_ _2234_ _2516_ _2499_ VGND VGND VPWR VPWR _2542_ sky130_fd_sc_hd__o21bai_1
X_8547_ clknet_leaf_79_CLK _0804_ VGND VGND VPWR VPWR RF.reg_arr\[23\]\[5\] sky130_fd_sc_hd__dfxtp_1
X_8478_ net964 net17 _4222_ VGND VGND VPWR VPWR _4223_ sky130_fd_sc_hd__mux2_1
X_7429_ _3267_ _3665_ VGND VGND VPWR VPWR _3666_ sky130_fd_sc_hd__nand2_4
Xhold671 RF.reg_arr\[17\]\[2\] VGND VGND VPWR VPWR net753 sky130_fd_sc_hd__dlygate4sd3_1
Xhold660 RF.reg_arr\[8\]\[14\] VGND VGND VPWR VPWR net742 sky130_fd_sc_hd__dlygate4sd3_1
Xhold693 RF.reg_arr\[19\]\[8\] VGND VGND VPWR VPWR net775 sky130_fd_sc_hd__dlygate4sd3_1
Xhold682 RF.reg_arr\[15\]\[3\] VGND VGND VPWR VPWR net764 sky130_fd_sc_hd__dlygate4sd3_1
XFILLER_0_99_567 VGND VGND VPWR VPWR sky130_fd_sc_hd__fill_1
XTAP_TAPCELL_ROW_15_426 VGND VPWR sky130_fd_sc_hd__tapvpwrvgnd_1
XTAP_TAPCELL_ROW_15_437 VGND VPWR sky130_fd_sc_hd__tapvpwrvgnd_1
XTAP_TAPCELL_ROW_43_768 VGND VPWR sky130_fd_sc_hd__tapvpwrvgnd_1
XFILLER_0_42_309 VGND VGND VPWR VPWR sky130_fd_sc_hd__fill_1
XFILLER_0_54_147 VGND VGND VPWR VPWR sky130_fd_sc_hd__fill_1
XFILLER_0_63_681 VGND VGND VPWR VPWR sky130_fd_sc_hd__decap_8
XFILLER_0_4_27 VGND VGND VPWR VPWR sky130_fd_sc_hd__fill_1
XFILLER_0_65_57 VGND VGND VPWR VPWR sky130_fd_sc_hd__fill_2
X_6800_ _3316_ VGND VGND VPWR VPWR _0999_ sky130_fd_sc_hd__clkbuf_1
X_4992_ RF.reg_arr\[8\]\[24\] RF.reg_arr\[9\]\[24\] RF.reg_arr\[10\]\[24\] RF.reg_arr\[11\]\[24\]
+ _1678_ _1684_ VGND VGND VPWR VPWR _1781_ sky130_fd_sc_hd__mux4_1
X_7780_ _3853_ VGND VGND VPWR VPWR _0418_ sky130_fd_sc_hd__clkbuf_1
XFILLER_0_85_250 VGND VGND VPWR VPWR sky130_fd_sc_hd__fill_1
XFILLER_0_58_475 VGND VGND VPWR VPWR sky130_fd_sc_hd__fill_1
X_6731_ _3279_ VGND VGND VPWR VPWR _0967_ sky130_fd_sc_hd__clkbuf_1
XFILLER_0_18_306 VGND VGND VPWR VPWR sky130_fd_sc_hd__fill_2
XFILLER_0_18_317 VGND VGND VPWR VPWR sky130_fd_sc_hd__fill_2
X_9450_ clknet_leaf_97_CLK _0683_ VGND VGND VPWR VPWR RF.reg_arr\[12\]\[12\] sky130_fd_sc_hd__dfxtp_1
X_6662_ _3077_ net738 _3232_ VGND VGND VPWR VPWR _3242_ sky130_fd_sc_hd__mux2_1
X_5613_ _2393_ _2400_ _2197_ VGND VGND VPWR VPWR _2401_ sky130_fd_sc_hd__mux2_1
XFILLER_0_61_607 VGND VGND VPWR VPWR sky130_fd_sc_hd__decap_8
X_9381_ clknet_leaf_84_CLK _0614_ VGND VGND VPWR VPWR RF.reg_arr\[13\]\[7\] sky130_fd_sc_hd__dfxtp_1
X_8401_ _4182_ VGND VGND VPWR VPWR _0710_ sky130_fd_sc_hd__clkbuf_1
XFILLER_0_45_169 VGND VGND VPWR VPWR sky130_fd_sc_hd__decap_4
X_8332_ _3012_ net930 _4138_ VGND VGND VPWR VPWR _4146_ sky130_fd_sc_hd__mux2_1
X_6593_ _3205_ VGND VGND VPWR VPWR _0903_ sky130_fd_sc_hd__clkbuf_1
X_5544_ _2276_ _2312_ _2314_ _2332_ VGND VGND VPWR VPWR _2333_ sky130_fd_sc_hd__o211a_1
XFILLER_0_26_394 VGND VGND VPWR VPWR sky130_fd_sc_hd__fill_1
XFILLER_0_30_82 VGND VGND VPWR VPWR sky130_fd_sc_hd__fill_2
X_8263_ _4109_ VGND VGND VPWR VPWR _0645_ sky130_fd_sc_hd__clkbuf_1
X_5475_ RF.reg_arr\[12\]\[6\] RF.reg_arr\[13\]\[6\] RF.reg_arr\[14\]\[6\] RF.reg_arr\[15\]\[6\]
+ _1857_ _1860_ VGND VGND VPWR VPWR _2264_ sky130_fd_sc_hd__mux4_1
XFILLER_0_41_375 VGND VGND VPWR VPWR sky130_fd_sc_hd__decap_8
X_7214_ _3551_ VGND VGND VPWR VPWR _0154_ sky130_fd_sc_hd__clkbuf_1
XFILLER_0_69_3 VGND VGND VPWR VPWR sky130_fd_sc_hd__fill_1
X_8194_ _3010_ net844 _4066_ VGND VGND VPWR VPWR _4073_ sky130_fd_sc_hd__mux2_1
X_4426_ RF.reg_arr\[12\]\[8\] RF.reg_arr\[13\]\[8\] RF.reg_arr\[14\]\[8\] RF.reg_arr\[15\]\[8\]
+ net1126 _1069_ VGND VGND VPWR VPWR _1215_ sky130_fd_sc_hd__mux4_1
X_7145_ net231 _3377_ _3507_ VGND VGND VPWR VPWR _3515_ sky130_fd_sc_hd__mux2_1
X_4357_ _1144_ _1145_ _1128_ VGND VGND VPWR VPWR _1146_ sky130_fd_sc_hd__mux2_1
X_7076_ _3478_ VGND VGND VPWR VPWR _0089_ sky130_fd_sc_hd__clkbuf_1
X_4288_ _1055_ VGND VGND VPWR VPWR _1077_ sky130_fd_sc_hd__buf_4
X_6027_ _2789_ _2795_ VGND VGND VPWR VPWR _2796_ sky130_fd_sc_hd__xnor2_1
XTAP_TAPCELL_ROW_64_1018 VGND VPWR sky130_fd_sc_hd__tapvpwrvgnd_1
X_7978_ _2994_ net1034 _3958_ VGND VGND VPWR VPWR _3959_ sky130_fd_sc_hd__mux2_1
XFILLER_0_76_250 VGND VGND VPWR VPWR sky130_fd_sc_hd__fill_2
X_6929_ net450 _3387_ _3389_ VGND VGND VPWR VPWR _3390_ sky130_fd_sc_hd__mux2_1
XFILLER_0_107_503 VGND VGND VPWR VPWR sky130_fd_sc_hd__fill_1
XFILLER_0_91_220 VGND VGND VPWR VPWR sky130_fd_sc_hd__decap_4
XFILLER_0_76_294 VGND VGND VPWR VPWR sky130_fd_sc_hd__fill_1
XTAP_TAPCELL_ROW_40_727 VGND VPWR sky130_fd_sc_hd__tapvpwrvgnd_1
XFILLER_0_24_309 VGND VGND VPWR VPWR sky130_fd_sc_hd__fill_1
XFILLER_0_32_320 VGND VGND VPWR VPWR sky130_fd_sc_hd__decap_3
XTAP_TAPCELL_ROW_20_495 VGND VPWR sky130_fd_sc_hd__tapvpwrvgnd_1
XTAP_TAPCELL_ROW_75_1147 VGND VPWR sky130_fd_sc_hd__tapvpwrvgnd_1
Xhold490 RF.reg_arr\[25\]\[29\] VGND VGND VPWR VPWR net572 sky130_fd_sc_hd__dlygate4sd3_1
XTAP_TAPCELL_ROW_48_827 VGND VPWR sky130_fd_sc_hd__tapvpwrvgnd_1
XFILLER_0_99_353 VPWR VGND VPWR VGND sky130_ef_sc_hd__decap_12
XFILLER_0_87_548 VGND VGND VPWR VPWR sky130_fd_sc_hd__fill_2
XTAP_TAPCELL_ROW_86_1287 VGND VPWR sky130_fd_sc_hd__tapvpwrvgnd_1
XTAP_TAPCELL_ROW_28_584 VGND VPWR sky130_fd_sc_hd__tapvpwrvgnd_1
XFILLER_0_95_570 VGND VGND VPWR VPWR sky130_fd_sc_hd__decap_8
XFILLER_0_95_592 VGND VGND VPWR VPWR sky130_fd_sc_hd__decap_3
XFILLER_0_82_253 VGND VGND VPWR VPWR sky130_fd_sc_hd__decap_3
XFILLER_0_27_169 VGND VGND VPWR VPWR sky130_fd_sc_hd__decap_4
XFILLER_0_82_297 VGND VGND VPWR VPWR sky130_fd_sc_hd__decap_8
XFILLER_0_82_286 VGND VGND VPWR VPWR sky130_fd_sc_hd__decap_3
Xclkload35 clknet_leaf_25_CLK VGND VGND VPWR VPWR clkload35/Y sky130_fd_sc_hd__clkinv_4
Xclkload24 clknet_leaf_95_CLK VGND VGND VPWR VPWR clkload24/Y sky130_fd_sc_hd__inv_6
Xclkload13 clknet_leaf_8_CLK VGND VGND VPWR VPWR clkload13/Y sky130_fd_sc_hd__clkinv_8
Xclkload46 clknet_leaf_34_CLK VGND VGND VPWR VPWR clkload46/Y sky130_fd_sc_hd__clkinvlp_4
Xclkload57 clknet_leaf_86_CLK VGND VGND VPWR VPWR clkload57/Y sky130_fd_sc_hd__inv_6
Xclkload68 clknet_leaf_70_CLK VGND VGND VPWR VPWR clkload68/Y sky130_fd_sc_hd__inv_6
XFILLER_0_2_269 VGND VGND VPWR VPWR sky130_fd_sc_hd__fill_1
Xclkload79 clknet_leaf_81_CLK VGND VGND VPWR VPWR clkload79/Y sky130_fd_sc_hd__clkinv_4
XFILLER_0_50_183 VGND VGND VPWR VPWR sky130_fd_sc_hd__decap_4
X_5260_ _1063_ _2008_ _2012_ _2016_ _2020_ VGND VGND VPWR VPWR _2049_ sky130_fd_sc_hd__a32oi_4
XFILLER_0_11_559 VGND VGND VPWR VPWR sky130_fd_sc_hd__fill_1
X_5191_ _1587_ _1971_ _1975_ _1979_ VGND VGND VPWR VPWR _1980_ sky130_fd_sc_hd__o2bb2a_4
XFILLER_0_76_89 VGND VGND VPWR VPWR sky130_fd_sc_hd__decap_3
XFILLER_0_48_8 VGND VGND VPWR VPWR sky130_fd_sc_hd__fill_1
X_8950_ clknet_leaf_51_CLK _0183_ VGND VGND VPWR VPWR RF.reg_arr\[29\]\[24\] sky130_fd_sc_hd__dfxtp_1
X_7901_ _3917_ VGND VGND VPWR VPWR _0475_ sky130_fd_sc_hd__clkbuf_1
X_8881_ clknet_leaf_8_CLK _0114_ VGND VGND VPWR VPWR RF.reg_arr\[3\]\[19\] sky130_fd_sc_hd__dfxtp_1
X_7832_ _3880_ VGND VGND VPWR VPWR _0443_ sky130_fd_sc_hd__clkbuf_1
XFILLER_0_78_548 VGND VGND VPWR VPWR sky130_fd_sc_hd__fill_2
XFILLER_0_116_95 VGND VGND VPWR VPWR sky130_fd_sc_hd__fill_1
X_7763_ net343 _3379_ _3835_ VGND VGND VPWR VPWR _3844_ sky130_fd_sc_hd__mux2_1
X_4975_ RF.reg_arr\[4\]\[27\] RF.reg_arr\[5\]\[27\] RF.reg_arr\[6\]\[27\] RF.reg_arr\[7\]\[27\]
+ _1626_ _1628_ VGND VGND VPWR VPWR _1764_ sky130_fd_sc_hd__mux4_1
XFILLER_0_93_518 VPWR VGND VPWR VGND sky130_ef_sc_hd__decap_12
XFILLER_0_19_615 VGND VGND VPWR VPWR sky130_fd_sc_hd__fill_1
X_6714_ _3056_ net1008 _3270_ VGND VGND VPWR VPWR _3271_ sky130_fd_sc_hd__mux2_1
X_9502_ clknet_leaf_67_CLK _0735_ VGND VGND VPWR VPWR RF.reg_arr\[10\]\[0\] sky130_fd_sc_hd__dfxtp_1
X_7694_ _3807_ VGND VGND VPWR VPWR _0378_ sky130_fd_sc_hd__clkbuf_1
X_9433_ clknet_leaf_38_CLK _0666_ VGND VGND VPWR VPWR RF.reg_arr\[17\]\[27\] sky130_fd_sc_hd__dfxtp_1
XFILLER_0_46_467 VGND VGND VPWR VPWR sky130_fd_sc_hd__fill_2
XFILLER_0_6_531 VGND VGND VPWR VPWR sky130_fd_sc_hd__fill_1
Xclkload7 clknet_leaf_1_CLK VGND VGND VPWR VPWR clkload7/Y sky130_fd_sc_hd__clkinv_4
XFILLER_0_27_670 VGND VGND VPWR VPWR sky130_fd_sc_hd__fill_2
XFILLER_0_33_128 VGND VGND VPWR VPWR sky130_fd_sc_hd__decap_3
X_6645_ _3233_ VGND VGND VPWR VPWR _0927_ sky130_fd_sc_hd__clkbuf_1
X_9364_ clknet_leaf_61_CLK _0597_ VGND VGND VPWR VPWR RF.reg_arr\[18\]\[22\] sky130_fd_sc_hd__dfxtp_1
X_6576_ net635 _2994_ _3196_ VGND VGND VPWR VPWR _3197_ sky130_fd_sc_hd__mux2_1
XFILLER_0_104_539 VGND VGND VPWR VPWR sky130_fd_sc_hd__fill_1
X_8315_ _4136_ VGND VGND VPWR VPWR _0670_ sky130_fd_sc_hd__clkbuf_1
X_5527_ RF.reg_arr\[28\]\[1\] RF.reg_arr\[29\]\[1\] RF.reg_arr\[30\]\[1\] RF.reg_arr\[31\]\[1\]
+ _1621_ _1594_ VGND VGND VPWR VPWR _2316_ sky130_fd_sc_hd__mux4_1
X_9295_ clknet_leaf_106_CLK _0528_ VGND VGND VPWR VPWR RF.reg_arr\[25\]\[17\] sky130_fd_sc_hd__dfxtp_1
X_8246_ _2992_ net986 _4065_ VGND VGND VPWR VPWR _4100_ sky130_fd_sc_hd__mux2_1
X_5458_ RF.reg_arr\[8\]\[7\] RF.reg_arr\[9\]\[7\] RF.reg_arr\[10\]\[7\] RF.reg_arr\[11\]\[7\]
+ _1624_ _1597_ VGND VGND VPWR VPWR _2247_ sky130_fd_sc_hd__mux4_1
X_8177_ _4063_ VGND VGND VPWR VPWR _0605_ sky130_fd_sc_hd__clkbuf_1
X_4409_ _1168_ _1197_ VGND VGND VPWR VPWR _1198_ sky130_fd_sc_hd__or2_1
X_5389_ RF.reg_arr\[28\]\[13\] RF.reg_arr\[29\]\[13\] RF.reg_arr\[30\]\[13\] RF.reg_arr\[31\]\[13\]
+ _2030_ _1858_ VGND VGND VPWR VPWR _2178_ sky130_fd_sc_hd__mux4_1
XFILLER_0_5_81 VGND VGND VPWR VPWR sky130_fd_sc_hd__fill_1
X_7128_ net319 _3428_ _3496_ VGND VGND VPWR VPWR _3506_ sky130_fd_sc_hd__mux2_1
XTAP_TAPCELL_ROW_70_1088 VGND VPWR sky130_fd_sc_hd__tapvpwrvgnd_1
X_7059_ _3469_ VGND VGND VPWR VPWR _0081_ sky130_fd_sc_hd__clkbuf_1
XFILLER_0_84_507 VGND VGND VPWR VPWR sky130_fd_sc_hd__decap_3
XFILLER_0_77_592 VGND VGND VPWR VPWR sky130_fd_sc_hd__decap_3
XTAP_TAPCELL_ROW_25_554 VGND VPWR sky130_fd_sc_hd__tapvpwrvgnd_1
XTAP_TAPCELL_ROW_53_885 VGND VPWR sky130_fd_sc_hd__tapvpwrvgnd_1
XFILLER_0_92_540 VGND VGND VPWR VPWR sky130_fd_sc_hd__fill_1
XFILLER_0_37_445 VGND VGND VPWR VPWR sky130_fd_sc_hd__decap_3
XFILLER_0_92_573 VGND VGND VPWR VPWR sky130_fd_sc_hd__decap_4
XFILLER_0_64_286 VGND VGND VPWR VPWR sky130_fd_sc_hd__fill_1
XFILLER_0_24_128 VGND VGND VPWR VPWR sky130_fd_sc_hd__fill_1
XFILLER_0_103_561 VGND VGND VPWR VPWR sky130_fd_sc_hd__decap_6
XFILLER_0_103_550 VGND VGND VPWR VPWR sky130_fd_sc_hd__fill_1
XTAP_TAPCELL_ROW_88_1305 VGND VPWR sky130_fd_sc_hd__tapvpwrvgnd_1
XFILLER_0_1_39 VPWR VGND VPWR VGND sky130_ef_sc_hd__decap_12
XFILLER_0_62_47 VGND VGND VPWR VPWR sky130_fd_sc_hd__fill_1
X_4760_ _1540_ _1116_ _1548_ VGND VGND VPWR VPWR _1549_ sky130_fd_sc_hd__o21ai_4
XPHY_EDGE_ROW_112_Right_112 VGND VGND VPWR VPWR sky130_fd_sc_hd__decap_3
XTAP_TAPCELL_ROW_99_1445 VGND VPWR sky130_fd_sc_hd__tapvpwrvgnd_1
XTAP_TAPCELL_ROW_99_1434 VGND VPWR sky130_fd_sc_hd__tapvpwrvgnd_1
XFILLER_0_83_573 VPWR VGND VPWR VGND sky130_ef_sc_hd__decap_12
X_4691_ RF.reg_arr\[0\]\[30\] RF.reg_arr\[1\]\[30\] RF.reg_arr\[2\]\[30\] RF.reg_arr\[3\]\[30\]
+ _1303_ _1305_ VGND VGND VPWR VPWR _1480_ sky130_fd_sc_hd__mux4_1
X_6430_ _3118_ VGND VGND VPWR VPWR _0827_ sky130_fd_sc_hd__clkbuf_1
Xclkload102 clknet_leaf_67_CLK VGND VGND VPWR VPWR clkload102/Y sky130_fd_sc_hd__clkinvlp_4
X_6361_ _3071_ net700 _3059_ VGND VGND VPWR VPWR _3072_ sky130_fd_sc_hd__mux2_1
X_8100_ _2982_ net1112 _4016_ VGND VGND VPWR VPWR _4023_ sky130_fd_sc_hd__mux2_1
X_5312_ _2099_ _2100_ _1603_ VGND VGND VPWR VPWR _2101_ sky130_fd_sc_hd__mux2_1
XPHY_EDGE_ROW_49_Right_49 VGND VGND VPWR VPWR sky130_fd_sc_hd__decap_3
X_9080_ clknet_leaf_35_CLK _0313_ VGND VGND VPWR VPWR RF.reg_arr\[28\]\[26\] sky130_fd_sc_hd__dfxtp_1
X_6292_ net19 VGND VGND VPWR VPWR _3027_ sky130_fd_sc_hd__buf_2
X_8031_ _3986_ VGND VGND VPWR VPWR _0536_ sky130_fd_sc_hd__clkbuf_1
X_5243_ RF.reg_arr\[16\]\[0\] RF.reg_arr\[17\]\[0\] RF.reg_arr\[18\]\[0\] RF.reg_arr\[19\]\[0\]
+ _1622_ _1595_ VGND VGND VPWR VPWR _2032_ sky130_fd_sc_hd__mux4_1
XFILLER_0_53_6 VGND VGND VPWR VPWR sky130_fd_sc_hd__fill_2
Xhold19 RF.reg_arr\[0\]\[21\] VGND VGND VPWR VPWR net101 sky130_fd_sc_hd__dlygate4sd3_1
X_5174_ _1618_ _1962_ _1586_ VGND VGND VPWR VPWR _1963_ sky130_fd_sc_hd__a21oi_1
XFILLER_0_78_312 VGND VGND VPWR VPWR sky130_fd_sc_hd__fill_1
XPHY_EDGE_ROW_58_Right_58 VGND VGND VPWR VPWR sky130_fd_sc_hd__decap_3
X_8933_ clknet_leaf_83_CLK _0166_ VGND VGND VPWR VPWR RF.reg_arr\[29\]\[7\] sky130_fd_sc_hd__dfxtp_1
XTAP_TAPCELL_ROW_108_1552 VGND VPWR sky130_fd_sc_hd__tapvpwrvgnd_1
X_8864_ clknet_leaf_60_CLK _0097_ VGND VGND VPWR VPWR RF.reg_arr\[3\]\[2\] sky130_fd_sc_hd__dfxtp_1
X_7815_ _3100_ net656 _3871_ VGND VGND VPWR VPWR _3872_ sky130_fd_sc_hd__mux2_1
X_8795_ clknet_leaf_25_CLK _0028_ VGND VGND VPWR VPWR RF.reg_arr\[5\]\[29\] sky130_fd_sc_hd__dfxtp_1
X_4958_ _1745_ _1746_ _1605_ VGND VGND VPWR VPWR _1747_ sky130_fd_sc_hd__mux2_1
X_7746_ _3812_ VGND VGND VPWR VPWR _3835_ sky130_fd_sc_hd__clkbuf_8
XFILLER_0_19_434 VGND VGND VPWR VPWR sky130_fd_sc_hd__fill_1
XTAP_TAPCELL_ROW_22_513 VGND VPWR sky130_fd_sc_hd__tapvpwrvgnd_1
X_4889_ _1677_ VGND VGND VPWR VPWR _1678_ sky130_fd_sc_hd__buf_4
X_7677_ _3798_ VGND VGND VPWR VPWR _0370_ sky130_fd_sc_hd__clkbuf_1
XFILLER_0_46_286 VGND VGND VPWR VPWR sky130_fd_sc_hd__decap_3
XTAP_TAPCELL_ROW_50_855 VGND VPWR sky130_fd_sc_hd__tapvpwrvgnd_1
XFILLER_0_116_141 VGND VGND VPWR VPWR sky130_fd_sc_hd__decap_6
X_6628_ net841 _2980_ _3218_ VGND VGND VPWR VPWR _3224_ sky130_fd_sc_hd__mux2_1
XFILLER_0_61_223 VGND VGND VPWR VPWR sky130_fd_sc_hd__fill_1
X_9416_ clknet_leaf_11_CLK _0649_ VGND VGND VPWR VPWR RF.reg_arr\[17\]\[10\] sky130_fd_sc_hd__dfxtp_1
XPHY_EDGE_ROW_67_Right_67 VGND VGND VPWR VPWR sky130_fd_sc_hd__decap_3
X_9347_ clknet_leaf_79_CLK _0580_ VGND VGND VPWR VPWR RF.reg_arr\[18\]\[5\] sky130_fd_sc_hd__dfxtp_1
X_6559_ _3187_ VGND VGND VPWR VPWR _0887_ sky130_fd_sc_hd__clkbuf_1
X_9278_ clknet_leaf_75_CLK _0511_ VGND VGND VPWR VPWR RF.reg_arr\[25\]\[0\] sky130_fd_sc_hd__dfxtp_1
XFILLER_0_30_643 VGND VGND VPWR VPWR sky130_fd_sc_hd__fill_1
X_8229_ _4091_ VGND VGND VPWR VPWR _0629_ sky130_fd_sc_hd__clkbuf_1
XTAP_TAPCELL_ROW_72_1117 VGND VPWR sky130_fd_sc_hd__tapvpwrvgnd_1
XFILLER_0_30_687 VGND VGND VPWR VPWR sky130_fd_sc_hd__fill_2
XPHY_EDGE_ROW_76_Right_76 VGND VGND VPWR VPWR sky130_fd_sc_hd__decap_3
XTAP_TAPCELL_ROW_58_944 VGND VPWR sky130_fd_sc_hd__tapvpwrvgnd_1
XFILLER_0_16_29 VGND VGND VPWR VPWR sky130_fd_sc_hd__fill_2
XFILLER_0_96_120 VGND VGND VPWR VPWR sky130_fd_sc_hd__decap_6
XTAP_TAPCELL_ROW_2_271 VGND VPWR sky130_fd_sc_hd__tapvpwrvgnd_1
XFILLER_0_96_197 VGND VGND VPWR VPWR sky130_fd_sc_hd__fill_2
XTAP_TAPCELL_ROW_83_1246 VGND VPWR sky130_fd_sc_hd__tapvpwrvgnd_1
XFILLER_0_107_152 VGND VGND VPWR VPWR sky130_fd_sc_hd__fill_1
XFILLER_0_107_130 VGND VGND VPWR VPWR sky130_fd_sc_hd__fill_1
XPHY_EDGE_ROW_85_Right_85 VGND VGND VPWR VPWR sky130_fd_sc_hd__decap_3
XFILLER_0_80_543 VGND VGND VPWR VPWR sky130_fd_sc_hd__fill_1
XFILLER_0_107_185 VGND VGND VPWR VPWR sky130_fd_sc_hd__fill_2
XFILLER_0_80_576 VPWR VGND VPWR VGND sky130_ef_sc_hd__decap_12
XTAP_TAPCELL_ROW_94_1375 VGND VPWR sky130_fd_sc_hd__tapvpwrvgnd_1
XFILLER_0_21_665 VGND VGND VPWR VPWR sky130_fd_sc_hd__decap_6
XFILLER_0_103_391 VGND VGND VPWR VPWR sky130_fd_sc_hd__fill_1
XFILLER_0_57_14 VGND VGND VPWR VPWR sky130_fd_sc_hd__fill_2
XPHY_EDGE_ROW_29_Left_146 VGND VGND VPWR VPWR sky130_fd_sc_hd__decap_3
XPHY_EDGE_ROW_94_Right_94 VGND VGND VPWR VPWR sky130_fd_sc_hd__decap_3
XFILLER_0_88_610 VGND VGND VPWR VPWR sky130_fd_sc_hd__fill_1
XFILLER_0_79_109 VGND VGND VPWR VPWR sky130_fd_sc_hd__decap_3
XFILLER_0_88_643 VGND VGND VPWR VPWR sky130_fd_sc_hd__fill_1
X_5930_ net91 _2703_ VGND VGND VPWR VPWR _2704_ sky130_fd_sc_hd__xor2_1
XFILLER_0_87_142 VGND VGND VPWR VPWR sky130_fd_sc_hd__fill_1
XFILLER_0_87_175 VGND VGND VPWR VPWR sky130_fd_sc_hd__fill_1
X_5861_ _2624_ VGND VGND VPWR VPWR _2639_ sky130_fd_sc_hd__inv_2
X_7600_ net295 _3420_ _3752_ VGND VGND VPWR VPWR _3758_ sky130_fd_sc_hd__mux2_1
X_5792_ _2103_ _2571_ VGND VGND VPWR VPWR _2573_ sky130_fd_sc_hd__and2_1
X_4812_ RF.reg_arr\[24\]\[31\] RF.reg_arr\[25\]\[31\] RF.reg_arr\[26\]\[31\] RF.reg_arr\[27\]\[31\]
+ _1593_ _1600_ VGND VGND VPWR VPWR _1601_ sky130_fd_sc_hd__mux4_1
X_8580_ clknet_leaf_86_CLK _0837_ VGND VGND VPWR VPWR RF.reg_arr\[0\]\[6\] sky130_fd_sc_hd__dfxtp_1
XPHY_EDGE_ROW_38_Left_155 VGND VGND VPWR VPWR sky130_fd_sc_hd__decap_3
XTAP_TAPCELL_ROW_103_1493 VGND VPWR sky130_fd_sc_hd__tapvpwrvgnd_1
XTAP_TAPCELL_ROW_103_1482 VGND VPWR sky130_fd_sc_hd__tapvpwrvgnd_1
X_7531_ _3721_ VGND VGND VPWR VPWR _0301_ sky130_fd_sc_hd__clkbuf_1
XFILLER_0_28_253 VGND VGND VPWR VPWR sky130_fd_sc_hd__decap_6
XFILLER_0_28_275 VGND VGND VPWR VPWR sky130_fd_sc_hd__decap_6
X_4743_ _1158_ _1531_ _1141_ VGND VGND VPWR VPWR _1532_ sky130_fd_sc_hd__a21o_1
XFILLER_0_114_601 VPWR VGND VPWR VGND sky130_ef_sc_hd__decap_12
XFILLER_0_7_169 VGND VGND VPWR VPWR sky130_fd_sc_hd__fill_2
XFILLER_0_7_158 VGND VGND VPWR VPWR sky130_fd_sc_hd__fill_2
X_7462_ _3090_ net801 _3678_ VGND VGND VPWR VPWR _3684_ sky130_fd_sc_hd__mux2_1
XFILLER_0_114_645 VPWR VGND VPWR VGND sky130_ef_sc_hd__decap_12
X_4674_ RF.reg_arr\[4\]\[31\] RF.reg_arr\[5\]\[31\] RF.reg_arr\[6\]\[31\] RF.reg_arr\[7\]\[31\]
+ _1303_ _1305_ VGND VGND VPWR VPWR _1463_ sky130_fd_sc_hd__mux4_1
X_6413_ net29 VGND VGND VPWR VPWR _3107_ sky130_fd_sc_hd__clkbuf_2
X_9201_ clknet_leaf_4_CLK _0434_ VGND VGND VPWR VPWR RF.reg_arr\[24\]\[19\] sky130_fd_sc_hd__dfxtp_1
XFILLER_0_31_418 VGND VGND VPWR VPWR sky130_fd_sc_hd__decap_4
XFILLER_0_98_65 VGND VGND VPWR VPWR sky130_fd_sc_hd__fill_2
X_7393_ _3090_ net483 _3641_ VGND VGND VPWR VPWR _3647_ sky130_fd_sc_hd__mux2_1
XFILLER_0_24_470 VGND VGND VPWR VPWR sky130_fd_sc_hd__fill_2
XFILLER_0_114_689 VGND VGND VPWR VPWR sky130_fd_sc_hd__decap_3
XFILLER_0_12_643 VGND VGND VPWR VPWR sky130_fd_sc_hd__fill_1
XFILLER_0_12_632 VGND VGND VPWR VPWR sky130_fd_sc_hd__decap_4
X_9132_ clknet_leaf_101_CLK _0365_ VGND VGND VPWR VPWR RF.reg_arr\[30\]\[14\] sky130_fd_sc_hd__dfxtp_1
X_6344_ _3060_ VGND VGND VPWR VPWR _0799_ sky130_fd_sc_hd__clkbuf_1
XFILLER_0_12_687 VGND VGND VPWR VPWR sky130_fd_sc_hd__decap_4
X_9063_ clknet_leaf_78_CLK _0296_ VGND VGND VPWR VPWR RF.reg_arr\[28\]\[9\] sky130_fd_sc_hd__dfxtp_1
X_6275_ _3015_ VGND VGND VPWR VPWR _0775_ sky130_fd_sc_hd__clkbuf_1
XPHY_EDGE_ROW_47_Left_164 VGND VGND VPWR VPWR sky130_fd_sc_hd__decap_3
X_8014_ _3977_ VGND VGND VPWR VPWR _0528_ sky130_fd_sc_hd__clkbuf_1
XFILLER_0_51_3 VGND VGND VPWR VPWR sky130_fd_sc_hd__fill_2
X_5226_ _2013_ _2014_ _1033_ VGND VGND VPWR VPWR _2015_ sky130_fd_sc_hd__mux2_1
X_5157_ _1895_ net82 _1667_ VGND VGND VPWR VPWR _1946_ sky130_fd_sc_hd__o21ai_1
X_5088_ _1873_ _1876_ _1618_ VGND VGND VPWR VPWR _1877_ sky130_fd_sc_hd__mux2_1
X_8916_ clknet_leaf_44_CLK _0149_ VGND VGND VPWR VPWR RF.reg_arr\[7\]\[22\] sky130_fd_sc_hd__dfxtp_1
XTAP_TAPCELL_ROW_55_914 VGND VPWR sky130_fd_sc_hd__tapvpwrvgnd_1
XFILLER_0_94_613 VGND VGND VPWR VPWR sky130_fd_sc_hd__decap_4
XFILLER_0_66_326 VGND VGND VPWR VPWR sky130_fd_sc_hd__fill_1
X_8847_ clknet_leaf_106_CLK _0080_ VGND VGND VPWR VPWR RF.reg_arr\[19\]\[17\] sky130_fd_sc_hd__dfxtp_1
XPHY_EDGE_ROW_56_Left_173 VGND VGND VPWR VPWR sky130_fd_sc_hd__decap_3
X_8778_ clknet_leaf_96_CLK _0011_ VGND VGND VPWR VPWR RF.reg_arr\[5\]\[12\] sky130_fd_sc_hd__dfxtp_1
XTAP_TAPCELL_ROW_35_671 VGND VPWR sky130_fd_sc_hd__tapvpwrvgnd_1
X_7729_ _3826_ VGND VGND VPWR VPWR _0394_ sky130_fd_sc_hd__clkbuf_1
XFILLER_0_19_297 VGND VGND VPWR VPWR sky130_fd_sc_hd__decap_4
XFILLER_0_7_681 VGND VGND VPWR VPWR sky130_fd_sc_hd__decap_8
XFILLER_0_62_587 VGND VGND VPWR VPWR sky130_fd_sc_hd__fill_1
XPHY_EDGE_ROW_65_Left_182 VGND VGND VPWR VPWR sky130_fd_sc_hd__decap_3
XTAP_TAPCELL_ROW_7_341 VGND VPWR sky130_fd_sc_hd__tapvpwrvgnd_1
XTAP_TAPCELL_ROW_7_330 VGND VPWR sky130_fd_sc_hd__tapvpwrvgnd_1
XPHY_EDGE_ROW_74_Left_191 VGND VGND VPWR VPWR sky130_fd_sc_hd__decap_3
XFILLER_0_85_679 VGND VGND VPWR VPWR sky130_fd_sc_hd__fill_1
XFILLER_0_84_123 VGND VGND VPWR VPWR sky130_fd_sc_hd__decap_3
XFILLER_0_72_318 VGND VGND VPWR VPWR sky130_fd_sc_hd__decap_8
XTAP_TAPCELL_ROW_96_1404 VGND VPWR sky130_fd_sc_hd__tapvpwrvgnd_1
Xhold308 RF.reg_arr\[26\]\[25\] VGND VGND VPWR VPWR net390 sky130_fd_sc_hd__dlygate4sd3_1
XFILLER_0_7_27 VGND VGND VPWR VPWR sky130_fd_sc_hd__decap_3
XFILLER_0_111_615 VGND VGND VPWR VPWR sky130_fd_sc_hd__fill_1
Xhold319 RF.reg_arr\[3\]\[2\] VGND VGND VPWR VPWR net401 sky130_fd_sc_hd__dlygate4sd3_1
X_4390_ RF.reg_arr\[0\]\[19\] RF.reg_arr\[1\]\[19\] RF.reg_arr\[2\]\[19\] RF.reg_arr\[3\]\[19\]
+ _1175_ _1176_ VGND VGND VPWR VPWR _1179_ sky130_fd_sc_hd__mux4_1
X_6060_ _2568_ _2819_ _2824_ _2826_ VGND VGND VPWR VPWR net63 sky130_fd_sc_hd__o22a_1
Xhold1008 RF.reg_arr\[27\]\[25\] VGND VGND VPWR VPWR net1090 sky130_fd_sc_hd__dlygate4sd3_1
X_5011_ RF.reg_arr\[8\]\[25\] RF.reg_arr\[9\]\[25\] RF.reg_arr\[10\]\[25\] RF.reg_arr\[11\]\[25\]
+ _1592_ _1599_ VGND VGND VPWR VPWR _1800_ sky130_fd_sc_hd__mux4_1
Xhold1019 RF.reg_arr\[26\]\[7\] VGND VGND VPWR VPWR net1101 sky130_fd_sc_hd__dlygate4sd3_1
XFILLER_0_108_85 VGND VGND VPWR VPWR sky130_fd_sc_hd__decap_8
XTAP_TAPCELL_ROW_105_1511 VGND VPWR sky130_fd_sc_hd__tapvpwrvgnd_1
X_6962_ net16 VGND VGND VPWR VPWR _3412_ sky130_fd_sc_hd__buf_2
X_5913_ _2617_ _2687_ _2361_ VGND VGND VPWR VPWR _2688_ sky130_fd_sc_hd__mux2_1
X_8701_ clknet_leaf_24_CLK _0958_ VGND VGND VPWR VPWR RF.reg_arr\[15\]\[31\] sky130_fd_sc_hd__dfxtp_1
X_6893_ _3343_ VGND VGND VPWR VPWR _3366_ sky130_fd_sc_hd__buf_4
X_8632_ clknet_leaf_36_CLK _0889_ VGND VGND VPWR VPWR RF.reg_arr\[16\]\[26\] sky130_fd_sc_hd__dfxtp_1
X_5844_ _1255_ _2622_ VGND VGND VPWR VPWR _2623_ sky130_fd_sc_hd__xnor2_1
XFILLER_0_75_123 VGND VGND VPWR VPWR sky130_fd_sc_hd__decap_3
X_8563_ clknet_leaf_48_CLK _0820_ VGND VGND VPWR VPWR RF.reg_arr\[23\]\[21\] sky130_fd_sc_hd__dfxtp_1
XTAP_TAPCELL_ROW_32_630 VGND VPWR sky130_fd_sc_hd__tapvpwrvgnd_1
XTAP_TAPCELL_ROW_32_641 VGND VPWR sky130_fd_sc_hd__tapvpwrvgnd_1
XFILLER_0_33_82 VGND VGND VPWR VPWR sky130_fd_sc_hd__decap_4
X_5775_ _2462_ _2467_ _2361_ VGND VGND VPWR VPWR _2557_ sky130_fd_sc_hd__mux2_1
XFILLER_0_99_3 VPWR VGND VPWR VGND sky130_ef_sc_hd__decap_12
XTAP_TAPCELL_ROW_60_972 VGND VPWR sky130_fd_sc_hd__tapvpwrvgnd_1
XFILLER_0_8_456 VGND VGND VPWR VPWR sky130_fd_sc_hd__fill_1
X_7514_ _3712_ VGND VGND VPWR VPWR _0293_ sky130_fd_sc_hd__clkbuf_1
XFILLER_0_44_510 VGND VGND VPWR VPWR sky130_fd_sc_hd__decap_4
XFILLER_0_56_381 VGND VGND VPWR VPWR sky130_fd_sc_hd__fill_1
X_8494_ net918 net26 _4222_ VGND VGND VPWR VPWR _4231_ sky130_fd_sc_hd__mux2_1
X_4726_ _1110_ _1514_ _1141_ VGND VGND VPWR VPWR _1515_ sky130_fd_sc_hd__a21oi_1
X_4657_ _1437_ _1272_ _1445_ VGND VGND VPWR VPWR _1446_ sky130_fd_sc_hd__a21oi_2
XFILLER_0_4_651 VGND VGND VPWR VPWR sky130_fd_sc_hd__fill_1
X_7445_ _3073_ net1101 _3667_ VGND VGND VPWR VPWR _3675_ sky130_fd_sc_hd__mux2_1
XFILLER_0_44_587 VGND VGND VPWR VPWR sky130_fd_sc_hd__fill_1
XTAP_TAPCELL_ROW_116_1651 VGND VPWR sky130_fd_sc_hd__tapvpwrvgnd_1
XTAP_TAPCELL_ROW_116_1640 VGND VPWR sky130_fd_sc_hd__tapvpwrvgnd_1
XFILLER_0_4_673 VPWR VGND VPWR VGND sky130_ef_sc_hd__decap_12
X_7376_ _3073_ net1065 _3630_ VGND VGND VPWR VPWR _3638_ sky130_fd_sc_hd__mux2_1
Xhold820 RF.reg_arr\[27\]\[0\] VGND VGND VPWR VPWR net902 sky130_fd_sc_hd__dlygate4sd3_1
X_6327_ net270 _2982_ _3040_ VGND VGND VPWR VPWR _3050_ sky130_fd_sc_hd__mux2_1
Xhold864 RF.reg_arr\[22\]\[27\] VGND VGND VPWR VPWR net946 sky130_fd_sc_hd__dlygate4sd3_1
X_9115_ clknet_leaf_26_CLK _0348_ VGND VGND VPWR VPWR RF.reg_arr\[2\]\[29\] sky130_fd_sc_hd__dfxtp_1
X_4588_ _1375_ _1376_ _1049_ VGND VGND VPWR VPWR _1377_ sky130_fd_sc_hd__mux2_1
Xhold831 RF.reg_arr\[30\]\[9\] VGND VGND VPWR VPWR net913 sky130_fd_sc_hd__dlygate4sd3_1
Xhold842 RF.reg_arr\[25\]\[6\] VGND VGND VPWR VPWR net924 sky130_fd_sc_hd__dlygate4sd3_1
Xhold853 RF.reg_arr\[27\]\[16\] VGND VGND VPWR VPWR net935 sky130_fd_sc_hd__dlygate4sd3_1
Xhold886 RF.reg_arr\[20\]\[29\] VGND VGND VPWR VPWR net968 sky130_fd_sc_hd__dlygate4sd3_1
Xhold875 RF.reg_arr\[25\]\[12\] VGND VGND VPWR VPWR net957 sky130_fd_sc_hd__dlygate4sd3_1
Xhold897 RF.reg_arr\[26\]\[11\] VGND VGND VPWR VPWR net979 sky130_fd_sc_hd__dlygate4sd3_1
X_9046_ clknet_leaf_51_CLK _0279_ VGND VGND VPWR VPWR RF.reg_arr\[26\]\[24\] sky130_fd_sc_hd__dfxtp_1
XTAP_TAPCELL_ROW_4_300 VGND VPWR sky130_fd_sc_hd__tapvpwrvgnd_1
X_6258_ net39 VGND VGND VPWR VPWR _3004_ sky130_fd_sc_hd__buf_2
X_6189_ _2050_ _2822_ _2884_ _2430_ VGND VGND VPWR VPWR _2948_ sky130_fd_sc_hd__a22o_1
X_5209_ _1895_ _1997_ _1756_ VGND VGND VPWR VPWR _1998_ sky130_fd_sc_hd__o21ai_2
XFILLER_0_98_226 VGND VGND VPWR VPWR sky130_fd_sc_hd__decap_3
XFILLER_0_94_421 VGND VGND VPWR VPWR sky130_fd_sc_hd__fill_1
XFILLER_0_94_410 VGND VGND VPWR VPWR sky130_fd_sc_hd__fill_2
XTAP_TAPCELL_ROW_80_1216 VGND VPWR sky130_fd_sc_hd__tapvpwrvgnd_1
XFILLER_0_109_225 VGND VGND VPWR VPWR sky130_fd_sc_hd__fill_1
XFILLER_0_54_318 VGND VGND VPWR VPWR sky130_fd_sc_hd__decap_3
XFILLER_0_35_565 VGND VGND VPWR VPWR sky130_fd_sc_hd__fill_1
XFILLER_0_62_362 VGND VGND VPWR VPWR sky130_fd_sc_hd__fill_2
XTAP_TAPCELL_ROW_10_368 VGND VPWR sky130_fd_sc_hd__tapvpwrvgnd_1
XTAP_TAPCELL_ROW_78_1189 VGND VPWR sky130_fd_sc_hd__tapvpwrvgnd_1
XTAP_TAPCELL_ROW_91_1345 VGND VPWR sky130_fd_sc_hd__tapvpwrvgnd_1
XFILLER_0_101_681 VGND VGND VPWR VPWR sky130_fd_sc_hd__decap_8
XTAP_TAPCELL_ROW_18_468 VGND VPWR sky130_fd_sc_hd__tapvpwrvgnd_1
XFILLER_0_97_292 VGND VGND VPWR VPWR sky130_fd_sc_hd__fill_2
XFILLER_0_97_281 VGND VGND VPWR VPWR sky130_fd_sc_hd__fill_2
XFILLER_0_85_443 VGND VGND VPWR VPWR sky130_fd_sc_hd__decap_4
XTAP_TAPCELL_ROW_46_799 VGND VPWR sky130_fd_sc_hd__tapvpwrvgnd_1
XFILLER_0_57_167 VGND VGND VPWR VPWR sky130_fd_sc_hd__fill_1
XTAP_TAPCELL_ROW_100_1452 VGND VPWR sky130_fd_sc_hd__tapvpwrvgnd_1
XFILLER_0_72_126 VGND VGND VPWR VPWR sky130_fd_sc_hd__decap_4
XFILLER_0_26_510 VGND VGND VPWR VPWR sky130_fd_sc_hd__fill_1
X_5560_ _1113_ _1647_ VGND VGND VPWR VPWR _2348_ sky130_fd_sc_hd__and2_1
XFILLER_0_53_340 VGND VGND VPWR VPWR sky130_fd_sc_hd__fill_2
X_4511_ _1298_ _1299_ _1296_ VGND VGND VPWR VPWR _1300_ sky130_fd_sc_hd__mux2_1
XFILLER_0_26_598 VGND VGND VPWR VPWR sky130_fd_sc_hd__fill_2
X_5491_ RF.reg_arr\[28\]\[3\] RF.reg_arr\[29\]\[3\] RF.reg_arr\[30\]\[3\] RF.reg_arr\[31\]\[3\]
+ _1588_ _1679_ VGND VGND VPWR VPWR _2280_ sky130_fd_sc_hd__mux4_1
Xhold105 RF.reg_arr\[10\]\[29\] VGND VGND VPWR VPWR net187 sky130_fd_sc_hd__dlygate4sd3_1
X_4442_ RF.reg_arr\[12\]\[9\] RF.reg_arr\[13\]\[9\] RF.reg_arr\[14\]\[9\] RF.reg_arr\[15\]\[9\]
+ _1229_ _1230_ VGND VGND VPWR VPWR _1231_ sky130_fd_sc_hd__mux4_1
X_7230_ _3063_ net840 _3558_ VGND VGND VPWR VPWR _3561_ sky130_fd_sc_hd__mux2_1
Xhold116 RF.reg_arr\[10\]\[9\] VGND VGND VPWR VPWR net198 sky130_fd_sc_hd__dlygate4sd3_1
Xhold149 RF.reg_arr\[3\]\[27\] VGND VGND VPWR VPWR net231 sky130_fd_sc_hd__dlygate4sd3_1
Xhold127 RF.reg_arr\[2\]\[31\] VGND VGND VPWR VPWR net209 sky130_fd_sc_hd__dlygate4sd3_1
Xhold138 RF.reg_arr\[8\]\[2\] VGND VGND VPWR VPWR net220 sky130_fd_sc_hd__dlygate4sd3_1
XFILLER_0_95_11 VGND VGND VPWR VPWR sky130_fd_sc_hd__fill_2
X_4373_ _1143_ _1161_ VGND VGND VPWR VPWR _1162_ sky130_fd_sc_hd__nor2_1
X_7161_ net451 _3393_ _3521_ VGND VGND VPWR VPWR _3524_ sky130_fd_sc_hd__mux2_1
XFILLER_0_1_665 VGND VGND VPWR VPWR sky130_fd_sc_hd__decap_6
XFILLER_0_21_281 VGND VGND VPWR VPWR sky130_fd_sc_hd__decap_8
X_6112_ _2874_ _2875_ VGND VGND VPWR VPWR _2876_ sky130_fd_sc_hd__xnor2_1
X_7092_ _3487_ VGND VGND VPWR VPWR _0096_ sky130_fd_sc_hd__clkbuf_1
XTAP_TAPCELL_ROW_111_1581 VGND VPWR sky130_fd_sc_hd__tapvpwrvgnd_1
XFILLER_0_95_88 VGND VGND VPWR VPWR sky130_fd_sc_hd__decap_4
X_6043_ _2585_ _2507_ _2805_ _2810_ VGND VGND VPWR VPWR net62 sky130_fd_sc_hd__a211o_1
XTAP_TAPCELL_ROW_37_700 VGND VPWR sky130_fd_sc_hd__tapvpwrvgnd_1
XFILLER_0_14_3 VPWR VGND VPWR VGND sky130_ef_sc_hd__decap_12
X_7994_ _3014_ net823 _3958_ VGND VGND VPWR VPWR _3967_ sky130_fd_sc_hd__mux2_1
XFILLER_0_88_270 VGND VGND VPWR VPWR sky130_fd_sc_hd__decap_3
X_6945_ _3400_ VGND VGND VPWR VPWR _0036_ sky130_fd_sc_hd__clkbuf_1
XFILLER_0_49_635 VGND VGND VPWR VPWR sky130_fd_sc_hd__decap_3
X_6876_ _3357_ VGND VGND VPWR VPWR _0010_ sky130_fd_sc_hd__clkbuf_1
XFILLER_0_36_318 VGND VGND VPWR VPWR sky130_fd_sc_hd__decap_4
XFILLER_0_48_156 VGND VGND VPWR VPWR sky130_fd_sc_hd__fill_1
XFILLER_0_76_498 VGND VGND VPWR VPWR sky130_fd_sc_hd__fill_2
X_5827_ _1223_ _1416_ net89 _2534_ _2535_ VGND VGND VPWR VPWR _2607_ sky130_fd_sc_hd__o41a_1
X_8615_ clknet_leaf_78_CLK _0872_ VGND VGND VPWR VPWR RF.reg_arr\[16\]\[9\] sky130_fd_sc_hd__dfxtp_1
X_5758_ _2501_ _2517_ VGND VGND VPWR VPWR _2541_ sky130_fd_sc_hd__and2b_1
X_8546_ clknet_leaf_75_CLK _0803_ VGND VGND VPWR VPWR RF.reg_arr\[23\]\[4\] sky130_fd_sc_hd__dfxtp_1
X_8477_ _2977_ VGND VGND VPWR VPWR _4222_ sky130_fd_sc_hd__clkbuf_8
X_4709_ _1126_ _1493_ _1495_ _1497_ _1141_ VGND VGND VPWR VPWR _1498_ sky130_fd_sc_hd__a221o_1
X_5689_ _2389_ _2399_ _2028_ VGND VGND VPWR VPWR _2475_ sky130_fd_sc_hd__mux2_1
X_7428_ _2973_ _2974_ _2972_ _2975_ VGND VGND VPWR VPWR _3665_ sky130_fd_sc_hd__and4b_2
Xhold650 RF.reg_arr\[23\]\[22\] VGND VGND VPWR VPWR net732 sky130_fd_sc_hd__dlygate4sd3_1
X_7359_ _3628_ VGND VGND VPWR VPWR _0222_ sky130_fd_sc_hd__clkbuf_1
Xhold661 RF.reg_arr\[4\]\[17\] VGND VGND VPWR VPWR net743 sky130_fd_sc_hd__dlygate4sd3_1
Xhold672 RF.reg_arr\[11\]\[19\] VGND VGND VPWR VPWR net754 sky130_fd_sc_hd__dlygate4sd3_1
Xhold694 RF.reg_arr\[23\]\[31\] VGND VGND VPWR VPWR net776 sky130_fd_sc_hd__dlygate4sd3_1
Xhold683 RF.reg_arr\[17\]\[0\] VGND VGND VPWR VPWR net765 sky130_fd_sc_hd__dlygate4sd3_1
X_9029_ clknet_leaf_83_CLK _0262_ VGND VGND VPWR VPWR RF.reg_arr\[26\]\[7\] sky130_fd_sc_hd__dfxtp_1
XFILLER_0_24_29 VGND VGND VPWR VPWR sky130_fd_sc_hd__fill_2
XTAP_TAPCELL_ROW_15_427 VGND VPWR sky130_fd_sc_hd__tapvpwrvgnd_1
XTAP_TAPCELL_ROW_43_769 VGND VPWR sky130_fd_sc_hd__tapvpwrvgnd_1
XFILLER_0_94_284 VGND VGND VPWR VPWR sky130_fd_sc_hd__fill_1
XFILLER_0_2_418 VGND VGND VPWR VPWR sky130_fd_sc_hd__fill_2
XFILLER_0_50_332 VGND VGND VPWR VPWR sky130_fd_sc_hd__fill_1
XFILLER_0_50_354 VGND VGND VPWR VPWR sky130_fd_sc_hd__fill_2
XFILLER_0_58_410 VGND VGND VPWR VPWR sky130_fd_sc_hd__fill_2
X_4991_ _1776_ _1777_ _1778_ _1779_ _1614_ _1637_ VGND VGND VPWR VPWR _1780_ sky130_fd_sc_hd__mux4_1
X_6730_ _3075_ net835 _3270_ VGND VGND VPWR VPWR _3279_ sky130_fd_sc_hd__mux2_1
X_6661_ _3241_ VGND VGND VPWR VPWR _0935_ sky130_fd_sc_hd__clkbuf_1
X_5612_ _2396_ _2399_ _1737_ VGND VGND VPWR VPWR _2400_ sky130_fd_sc_hd__mux2_1
X_9380_ clknet_leaf_86_CLK _0613_ VGND VGND VPWR VPWR RF.reg_arr\[13\]\[6\] sky130_fd_sc_hd__dfxtp_1
X_6592_ net665 _3014_ _3196_ VGND VGND VPWR VPWR _3205_ sky130_fd_sc_hd__mux2_1
X_8400_ net357 _3403_ _4174_ VGND VGND VPWR VPWR _4182_ sky130_fd_sc_hd__mux2_1
X_5543_ _2028_ _1115_ _2331_ VGND VGND VPWR VPWR _2332_ sky130_fd_sc_hd__or3_1
X_8331_ _4145_ VGND VGND VPWR VPWR _0677_ sky130_fd_sc_hd__clkbuf_1
X_8262_ net290 _3401_ _4102_ VGND VGND VPWR VPWR _4109_ sky130_fd_sc_hd__mux2_1
X_5474_ RF.reg_arr\[8\]\[6\] RF.reg_arr\[9\]\[6\] RF.reg_arr\[10\]\[6\] RF.reg_arr\[11\]\[6\]
+ _1857_ _1860_ VGND VGND VPWR VPWR _2263_ sky130_fd_sc_hd__mux4_1
XTAP_TAPCELL_ROW_113_1610 VGND VPWR sky130_fd_sc_hd__tapvpwrvgnd_1
X_7213_ net182 _3377_ _3543_ VGND VGND VPWR VPWR _3551_ sky130_fd_sc_hd__mux2_1
X_4425_ _1039_ _1213_ VGND VGND VPWR VPWR _1214_ sky130_fd_sc_hd__nand2_2
X_8193_ _4072_ VGND VGND VPWR VPWR _0612_ sky130_fd_sc_hd__clkbuf_1
X_7144_ _3514_ VGND VGND VPWR VPWR _0121_ sky130_fd_sc_hd__clkbuf_1
X_4356_ RF.reg_arr\[16\]\[17\] RF.reg_arr\[17\]\[17\] RF.reg_arr\[18\]\[17\] RF.reg_arr\[19\]\[17\]
+ _1117_ _1118_ VGND VGND VPWR VPWR _1145_ sky130_fd_sc_hd__mux4_1
X_7075_ net354 _3375_ _3471_ VGND VGND VPWR VPWR _3478_ sky130_fd_sc_hd__mux2_1
X_4287_ _1073_ _1074_ _1075_ VGND VGND VPWR VPWR _1076_ sky130_fd_sc_hd__mux2_1
X_6026_ _2792_ _2794_ VGND VGND VPWR VPWR _2795_ sky130_fd_sc_hd__or2_1
XTAP_TAPCELL_ROW_64_1019 VGND VPWR sky130_fd_sc_hd__tapvpwrvgnd_1
X_7977_ _3957_ VGND VGND VPWR VPWR _3958_ sky130_fd_sc_hd__clkbuf_8
XFILLER_0_76_262 VGND VGND VPWR VPWR sky130_fd_sc_hd__fill_2
X_6928_ _3388_ VGND VGND VPWR VPWR _3389_ sky130_fd_sc_hd__buf_4
XFILLER_0_76_273 VGND VGND VPWR VPWR sky130_fd_sc_hd__decap_4
XFILLER_0_49_487 VGND VGND VPWR VPWR sky130_fd_sc_hd__decap_4
X_6859_ _3348_ VGND VGND VPWR VPWR _0002_ sky130_fd_sc_hd__clkbuf_1
XFILLER_0_107_526 VPWR VGND VPWR VGND sky130_ef_sc_hd__decap_12
XTAP_TAPCELL_ROW_40_728 VGND VPWR sky130_fd_sc_hd__tapvpwrvgnd_1
X_8529_ clknet_leaf_8_CLK _0786_ VGND VGND VPWR VPWR RF.reg_arr\[1\]\[19\] sky130_fd_sc_hd__dfxtp_1
XTAP_TAPCELL_ROW_20_496 VGND VPWR sky130_fd_sc_hd__tapvpwrvgnd_1
XFILLER_0_102_253 VGND VGND VPWR VPWR sky130_fd_sc_hd__decap_4
XFILLER_0_102_231 VGND VGND VPWR VPWR sky130_fd_sc_hd__decap_8
XTAP_TAPCELL_ROW_75_1148 VGND VPWR sky130_fd_sc_hd__tapvpwrvgnd_1
XFILLER_0_3_3 VPWR VGND VPWR VGND sky130_ef_sc_hd__decap_12
Xhold480 RF.reg_arr\[7\]\[18\] VGND VGND VPWR VPWR net562 sky130_fd_sc_hd__dlygate4sd3_1
Xhold491 RF.reg_arr\[28\]\[21\] VGND VGND VPWR VPWR net573 sky130_fd_sc_hd__dlygate4sd3_1
XFILLER_0_35_28 VGND VGND VPWR VPWR sky130_fd_sc_hd__decap_3
XTAP_TAPCELL_ROW_48_828 VGND VPWR sky130_fd_sc_hd__tapvpwrvgnd_1
XFILLER_0_99_365 VGND VGND VPWR VPWR sky130_fd_sc_hd__decap_8
XFILLER_0_87_505 VGND VGND VPWR VPWR sky130_fd_sc_hd__decap_4
XTAP_TAPCELL_ROW_86_1288 VGND VPWR sky130_fd_sc_hd__tapvpwrvgnd_1
XTAP_TAPCELL_ROW_28_585 VGND VPWR sky130_fd_sc_hd__tapvpwrvgnd_1
XFILLER_0_82_210 VGND VGND VPWR VPWR sky130_fd_sc_hd__fill_1
XFILLER_0_51_38 VGND VGND VPWR VPWR sky130_fd_sc_hd__fill_1
XFILLER_0_82_265 VPWR VGND VPWR VGND sky130_ef_sc_hd__decap_12
XFILLER_0_113_518 VGND VGND VPWR VPWR sky130_fd_sc_hd__fill_2
Xclkload25 clknet_leaf_100_CLK VGND VGND VPWR VPWR clkload25/Y sky130_fd_sc_hd__clkinv_4
Xclkload14 clknet_leaf_9_CLK VGND VGND VPWR VPWR clkload14/Y sky130_fd_sc_hd__inv_8
Xclkload47 clknet_leaf_36_CLK VGND VGND VPWR VPWR clkload47/X sky130_fd_sc_hd__clkbuf_4
Xclkload36 clknet_leaf_26_CLK VGND VGND VPWR VPWR clkload36/Y sky130_fd_sc_hd__clkinvlp_2
XFILLER_0_11_505 VPWR VGND VPWR VGND sky130_ef_sc_hd__decap_12
Xclkload69 clknet_leaf_71_CLK VGND VGND VPWR VPWR clkload69/Y sky130_fd_sc_hd__clkinv_4
Xclkload58 clknet_leaf_88_CLK VGND VGND VPWR VPWR clkload58/Y sky130_fd_sc_hd__clkinv_4
XPHY_EDGE_ROW_10_Left_127 VGND VGND VPWR VPWR sky130_fd_sc_hd__decap_3
X_5190_ _1845_ _1978_ _1642_ VGND VGND VPWR VPWR _1979_ sky130_fd_sc_hd__o21ai_1
X_7900_ _3117_ net723 _3908_ VGND VGND VPWR VPWR _3917_ sky130_fd_sc_hd__mux2_1
XFILLER_0_116_41 VPWR VGND VPWR VGND sky130_ef_sc_hd__decap_12
XFILLER_0_92_56 VPWR VGND VPWR VGND sky130_ef_sc_hd__decap_12
XFILLER_0_78_505 VGND VGND VPWR VPWR sky130_fd_sc_hd__fill_2
X_8880_ clknet_leaf_2_CLK _0113_ VGND VGND VPWR VPWR RF.reg_arr\[3\]\[18\] sky130_fd_sc_hd__dfxtp_1
XFILLER_0_116_85 VGND VGND VPWR VPWR sky130_fd_sc_hd__fill_1
X_7831_ _3117_ net1051 _3871_ VGND VGND VPWR VPWR _3880_ sky130_fd_sc_hd__mux2_1
XFILLER_0_92_89 VGND VGND VPWR VPWR sky130_fd_sc_hd__fill_1
X_4974_ _1759_ _1762_ _1636_ VGND VGND VPWR VPWR _1763_ sky130_fd_sc_hd__mux2_1
X_7762_ _3843_ VGND VGND VPWR VPWR _0410_ sky130_fd_sc_hd__clkbuf_1
X_7693_ _3115_ net619 _3799_ VGND VGND VPWR VPWR _3807_ sky130_fd_sc_hd__mux2_1
X_9501_ clknet_leaf_24_CLK _0734_ VGND VGND VPWR VPWR RF.reg_arr\[11\]\[31\] sky130_fd_sc_hd__dfxtp_1
XFILLER_0_58_273 VGND VGND VPWR VPWR sky130_fd_sc_hd__fill_2
X_6713_ _3269_ VGND VGND VPWR VPWR _3270_ sky130_fd_sc_hd__clkbuf_8
XFILLER_0_116_312 VGND VGND VPWR VPWR sky130_fd_sc_hd__fill_1
X_9432_ clknet_leaf_37_CLK _0665_ VGND VGND VPWR VPWR RF.reg_arr\[17\]\[26\] sky130_fd_sc_hd__dfxtp_1
X_6644_ _3056_ net812 _3232_ VGND VGND VPWR VPWR _3233_ sky130_fd_sc_hd__mux2_1
XFILLER_0_73_276 VGND VGND VPWR VPWR sky130_fd_sc_hd__fill_1
Xclkload8 clknet_leaf_3_CLK VGND VGND VPWR VPWR clkload8/Y sky130_fd_sc_hd__clkinv_4
X_9363_ clknet_leaf_46_CLK _0596_ VGND VGND VPWR VPWR RF.reg_arr\[18\]\[21\] sky130_fd_sc_hd__dfxtp_1
X_6575_ _3195_ VGND VGND VPWR VPWR _3196_ sky130_fd_sc_hd__clkbuf_8
X_8314_ net682 _3385_ _4101_ VGND VGND VPWR VPWR _4136_ sky130_fd_sc_hd__mux2_1
X_5526_ RF.reg_arr\[24\]\[1\] RF.reg_arr\[25\]\[1\] RF.reg_arr\[26\]\[1\] RF.reg_arr\[27\]\[1\]
+ _1621_ _1594_ VGND VGND VPWR VPWR _2315_ sky130_fd_sc_hd__mux4_1
XFILLER_0_14_365 VPWR VGND VPWR VGND sky130_ef_sc_hd__decap_12
X_9294_ clknet_leaf_7_CLK _0527_ VGND VGND VPWR VPWR RF.reg_arr\[25\]\[16\] sky130_fd_sc_hd__dfxtp_1
XFILLER_0_112_551 VPWR VGND VPWR VGND sky130_ef_sc_hd__decap_12
X_8245_ _4099_ VGND VGND VPWR VPWR _0637_ sky130_fd_sc_hd__clkbuf_1
X_5457_ _1942_ _2245_ VGND VGND VPWR VPWR _2246_ sky130_fd_sc_hd__or2_1
X_4408_ RF.reg_arr\[4\]\[18\] RF.reg_arr\[5\]\[18\] RF.reg_arr\[6\]\[18\] RF.reg_arr\[7\]\[18\]
+ _1164_ _1165_ VGND VGND VPWR VPWR _1197_ sky130_fd_sc_hd__mux4_1
X_8176_ net287 _3383_ _4029_ VGND VGND VPWR VPWR _4063_ sky130_fd_sc_hd__mux2_1
XFILLER_0_1_281 VGND VGND VPWR VPWR sky130_fd_sc_hd__fill_2
X_5388_ RF.reg_arr\[24\]\[13\] RF.reg_arr\[25\]\[13\] RF.reg_arr\[26\]\[13\] RF.reg_arr\[27\]\[13\]
+ _2030_ _1858_ VGND VGND VPWR VPWR _2177_ sky130_fd_sc_hd__mux4_1
XFILLER_0_5_71 VGND VGND VPWR VPWR sky130_fd_sc_hd__fill_1
X_7127_ _3505_ VGND VGND VPWR VPWR _0113_ sky130_fd_sc_hd__clkbuf_1
X_4339_ _1034_ VGND VGND VPWR VPWR _1128_ sky130_fd_sc_hd__buf_4
XTAP_TAPCELL_ROW_70_1089 VGND VPWR sky130_fd_sc_hd__tapvpwrvgnd_1
X_7058_ net412 _3426_ _3460_ VGND VGND VPWR VPWR _3469_ sky130_fd_sc_hd__mux2_1
X_6009_ _2474_ _2746_ _2778_ _2381_ VGND VGND VPWR VPWR _2779_ sky130_fd_sc_hd__o22a_1
XFILLER_0_69_505 VGND VGND VPWR VPWR sky130_fd_sc_hd__fill_2
XTAP_TAPCELL_ROW_25_555 VGND VPWR sky130_fd_sc_hd__tapvpwrvgnd_1
XFILLER_0_49_273 VGND VGND VPWR VPWR sky130_fd_sc_hd__decap_6
XTAP_TAPCELL_ROW_53_886 VGND VPWR sky130_fd_sc_hd__tapvpwrvgnd_1
XFILLER_0_92_585 VGND VGND VPWR VPWR sky130_fd_sc_hd__decap_3
XFILLER_0_20_357 VGND VGND VPWR VPWR sky130_fd_sc_hd__decap_6
XTAP_TAPCELL_ROW_88_1306 VGND VPWR sky130_fd_sc_hd__tapvpwrvgnd_1
XTAP_TAPCELL_ROW_99_1435 VGND VPWR sky130_fd_sc_hd__tapvpwrvgnd_1
X_4690_ RF.reg_arr\[4\]\[30\] RF.reg_arr\[5\]\[30\] RF.reg_arr\[6\]\[30\] RF.reg_arr\[7\]\[30\]
+ _1303_ _1305_ VGND VGND VPWR VPWR _1479_ sky130_fd_sc_hd__mux4_1
Xclkload103 clknet_leaf_68_CLK VGND VGND VPWR VPWR clkload103/Y sky130_fd_sc_hd__clkinvlp_4
XFILLER_0_113_337 VGND VGND VPWR VPWR sky130_fd_sc_hd__decap_4
X_6360_ net42 VGND VGND VPWR VPWR _3071_ sky130_fd_sc_hd__clkbuf_2
XFILLER_0_3_557 VGND VGND VPWR VPWR sky130_fd_sc_hd__decap_3
X_5311_ RF.reg_arr\[12\]\[8\] RF.reg_arr\[13\]\[8\] RF.reg_arr\[14\]\[8\] RF.reg_arr\[15\]\[8\]
+ _2087_ _1859_ VGND VGND VPWR VPWR _2100_ sky130_fd_sc_hd__mux4_1
X_8030_ _2980_ net872 _3980_ VGND VGND VPWR VPWR _3986_ sky130_fd_sc_hd__mux2_1
X_6291_ _3026_ VGND VGND VPWR VPWR _0780_ sky130_fd_sc_hd__clkbuf_1
X_5242_ RF.reg_arr\[20\]\[0\] RF.reg_arr\[21\]\[0\] RF.reg_arr\[22\]\[0\] RF.reg_arr\[23\]\[0\]
+ _2030_ _1858_ VGND VGND VPWR VPWR _2031_ sky130_fd_sc_hd__mux4_1
X_5173_ _1960_ _1961_ _1865_ VGND VGND VPWR VPWR _1962_ sky130_fd_sc_hd__mux2_1
Xinput1 A1[0] VGND VGND VPWR VPWR net1 sky130_fd_sc_hd__dlymetal6s2s_1
X_8932_ clknet_leaf_82_CLK _0165_ VGND VGND VPWR VPWR RF.reg_arr\[29\]\[6\] sky130_fd_sc_hd__dfxtp_1
XTAP_TAPCELL_ROW_108_1553 VGND VPWR sky130_fd_sc_hd__tapvpwrvgnd_1
XTAP_TAPCELL_ROW_108_1542 VGND VPWR sky130_fd_sc_hd__tapvpwrvgnd_1
X_8863_ clknet_leaf_58_CLK _0096_ VGND VGND VPWR VPWR RF.reg_arr\[3\]\[1\] sky130_fd_sc_hd__dfxtp_1
X_7814_ _3848_ VGND VGND VPWR VPWR _3871_ sky130_fd_sc_hd__clkbuf_8
XFILLER_0_66_508 VGND VGND VPWR VPWR sky130_fd_sc_hd__fill_1
X_8794_ clknet_leaf_31_CLK _0027_ VGND VGND VPWR VPWR RF.reg_arr\[5\]\[28\] sky130_fd_sc_hd__dfxtp_1
XFILLER_0_93_316 VGND VGND VPWR VPWR sky130_fd_sc_hd__decap_8
X_4957_ RF.reg_arr\[12\]\[26\] RF.reg_arr\[13\]\[26\] RF.reg_arr\[14\]\[26\] RF.reg_arr\[15\]\[26\]
+ _1678_ _1684_ VGND VGND VPWR VPWR _1746_ sky130_fd_sc_hd__mux4_1
XFILLER_0_74_530 VGND VGND VPWR VPWR sky130_fd_sc_hd__fill_2
XTAP_TAPCELL_ROW_22_514 VGND VPWR sky130_fd_sc_hd__tapvpwrvgnd_1
X_7745_ _3834_ VGND VGND VPWR VPWR _0402_ sky130_fd_sc_hd__clkbuf_1
X_4888_ _1676_ VGND VGND VPWR VPWR _1677_ sky130_fd_sc_hd__buf_4
XFILLER_0_74_585 VGND VGND VPWR VPWR sky130_fd_sc_hd__decap_3
X_7676_ _3098_ net1102 _3788_ VGND VGND VPWR VPWR _3798_ sky130_fd_sc_hd__mux2_1
XTAP_TAPCELL_ROW_50_856 VGND VPWR sky130_fd_sc_hd__tapvpwrvgnd_1
X_6627_ _3223_ VGND VGND VPWR VPWR _0919_ sky130_fd_sc_hd__clkbuf_1
X_9415_ clknet_leaf_78_CLK _0648_ VGND VGND VPWR VPWR RF.reg_arr\[17\]\[9\] sky130_fd_sc_hd__dfxtp_1
XFILLER_0_6_362 VGND VGND VPWR VPWR sky130_fd_sc_hd__fill_2
X_6558_ net365 _2970_ _3182_ VGND VGND VPWR VPWR _3187_ sky130_fd_sc_hd__mux2_1
X_9346_ clknet_leaf_77_CLK _0579_ VGND VGND VPWR VPWR RF.reg_arr\[18\]\[4\] sky130_fd_sc_hd__dfxtp_1
XFILLER_0_42_460 VGND VGND VPWR VPWR sky130_fd_sc_hd__decap_8
X_6489_ _3149_ VGND VGND VPWR VPWR _0855_ sky130_fd_sc_hd__clkbuf_1
X_9277_ clknet_leaf_17_CLK _0510_ VGND VGND VPWR VPWR RF.reg_arr\[21\]\[31\] sky130_fd_sc_hd__dfxtp_1
X_5509_ RF.reg_arr\[24\]\[2\] RF.reg_arr\[25\]\[2\] RF.reg_arr\[26\]\[2\] RF.reg_arr\[27\]\[2\]
+ _1588_ _1679_ VGND VGND VPWR VPWR _2298_ sky130_fd_sc_hd__mux4_1
XTAP_TAPCELL_ROW_72_1118 VGND VPWR sky130_fd_sc_hd__tapvpwrvgnd_1
X_8228_ _3044_ net608 _4088_ VGND VGND VPWR VPWR _4091_ sky130_fd_sc_hd__mux2_1
X_8159_ _4054_ VGND VGND VPWR VPWR _0596_ sky130_fd_sc_hd__clkbuf_1
XTAP_TAPCELL_ROW_58_945 VGND VPWR sky130_fd_sc_hd__tapvpwrvgnd_1
XFILLER_0_69_313 VGND VGND VPWR VPWR sky130_fd_sc_hd__fill_1
XTAP_TAPCELL_ROW_2_272 VGND VPWR sky130_fd_sc_hd__tapvpwrvgnd_1
XTAP_TAPCELL_ROW_83_1247 VGND VPWR sky130_fd_sc_hd__tapvpwrvgnd_1
XFILLER_0_37_243 VGND VGND VPWR VPWR sky130_fd_sc_hd__decap_6
XFILLER_0_80_511 VGND VGND VPWR VPWR sky130_fd_sc_hd__fill_2
XFILLER_0_80_533 VGND VGND VPWR VPWR sky130_fd_sc_hd__fill_1
XFILLER_0_110_307 VGND VGND VPWR VPWR sky130_fd_sc_hd__fill_1
XFILLER_0_0_516 VGND VGND VPWR VPWR sky130_fd_sc_hd__decap_6
XFILLER_0_103_381 VGND VGND VPWR VPWR sky130_fd_sc_hd__decap_6
XTAP_TAPCELL_ROW_94_1376 VGND VPWR sky130_fd_sc_hd__tapvpwrvgnd_1
XFILLER_0_87_121 VGND VGND VPWR VPWR sky130_fd_sc_hd__decap_4
X_5860_ _2083_ _2637_ VGND VGND VPWR VPWR _2638_ sky130_fd_sc_hd__xor2_1
X_4811_ _1599_ VGND VGND VPWR VPWR _1600_ sky130_fd_sc_hd__clkbuf_4
X_5791_ _2103_ _2571_ VGND VGND VPWR VPWR _2572_ sky130_fd_sc_hd__nor2_1
XTAP_TAPCELL_ROW_103_1483 VGND VPWR sky130_fd_sc_hd__tapvpwrvgnd_1
XFILLER_0_7_148 VGND VGND VPWR VPWR sky130_fd_sc_hd__fill_2
X_7530_ net408 _3418_ _3716_ VGND VGND VPWR VPWR _3721_ sky130_fd_sc_hd__mux2_1
X_4742_ _1529_ _1530_ _1128_ VGND VGND VPWR VPWR _1531_ sky130_fd_sc_hd__mux2_1
XFILLER_0_56_563 VGND VGND VPWR VPWR sky130_fd_sc_hd__decap_3
X_4673_ _1284_ _1461_ VGND VGND VPWR VPWR _1462_ sky130_fd_sc_hd__nor2_1
X_7461_ _3683_ VGND VGND VPWR VPWR _0269_ sky130_fd_sc_hd__clkbuf_1
XFILLER_0_114_613 VPWR VGND VPWR VGND sky130_ef_sc_hd__decap_12
X_6412_ _3106_ VGND VGND VPWR VPWR _0821_ sky130_fd_sc_hd__clkbuf_1
XFILLER_0_71_577 VGND VGND VPWR VPWR sky130_fd_sc_hd__fill_2
X_9200_ clknet_leaf_0_CLK _0433_ VGND VGND VPWR VPWR RF.reg_arr\[24\]\[18\] sky130_fd_sc_hd__dfxtp_1
XFILLER_0_114_657 VPWR VGND VPWR VGND sky130_ef_sc_hd__decap_12
X_7392_ _3646_ VGND VGND VPWR VPWR _0237_ sky130_fd_sc_hd__clkbuf_1
XFILLER_0_113_167 VGND VGND VPWR VPWR sky130_fd_sc_hd__fill_1
X_6343_ _3056_ net561 _3059_ VGND VGND VPWR VPWR _3060_ sky130_fd_sc_hd__mux2_1
X_9131_ clknet_leaf_94_CLK _0364_ VGND VGND VPWR VPWR RF.reg_arr\[30\]\[13\] sky130_fd_sc_hd__dfxtp_1
X_9062_ clknet_leaf_82_CLK _0295_ VGND VGND VPWR VPWR RF.reg_arr\[28\]\[8\] sky130_fd_sc_hd__dfxtp_1
X_6274_ net197 _3014_ _2998_ VGND VGND VPWR VPWR _3015_ sky130_fd_sc_hd__mux2_1
X_5225_ RF.reg_arr\[0\]\[3\] RF.reg_arr\[1\]\[3\] RF.reg_arr\[2\]\[3\] RF.reg_arr\[3\]\[3\]
+ _1043_ _1083_ VGND VGND VPWR VPWR _2014_ sky130_fd_sc_hd__mux4_1
X_8013_ _3033_ net1055 _3969_ VGND VGND VPWR VPWR _3977_ sky130_fd_sc_hd__mux2_1
XFILLER_0_44_3 VGND VGND VPWR VPWR sky130_fd_sc_hd__decap_8
X_5156_ _1643_ _1935_ _1944_ VGND VGND VPWR VPWR _1945_ sky130_fd_sc_hd__o21ai_1
XFILLER_0_98_419 VGND VGND VPWR VPWR sky130_fd_sc_hd__fill_1
X_5087_ _1874_ _1875_ _1865_ VGND VGND VPWR VPWR _1876_ sky130_fd_sc_hd__mux2_1
XFILLER_0_79_622 VGND VGND VPWR VPWR sky130_fd_sc_hd__decap_3
X_8915_ clknet_leaf_45_CLK _0148_ VGND VGND VPWR VPWR RF.reg_arr\[7\]\[21\] sky130_fd_sc_hd__dfxtp_1
XTAP_TAPCELL_ROW_55_915 VGND VPWR sky130_fd_sc_hd__tapvpwrvgnd_1
XFILLER_0_79_655 VGND VGND VPWR VPWR sky130_fd_sc_hd__fill_1
XTAP_TAPCELL_ROW_69_1080 VGND VPWR sky130_fd_sc_hd__tapvpwrvgnd_1
XFILLER_0_2_83 VGND VGND VPWR VPWR sky130_fd_sc_hd__fill_1
XFILLER_0_93_102 VGND VGND VPWR VPWR sky130_fd_sc_hd__fill_2
XFILLER_0_78_187 VGND VGND VPWR VPWR sky130_fd_sc_hd__decap_8
X_8846_ clknet_leaf_21_CLK _0079_ VGND VGND VPWR VPWR RF.reg_arr\[19\]\[16\] sky130_fd_sc_hd__dfxtp_1
X_5989_ _1162_ _1550_ net1123 _2759_ VGND VGND VPWR VPWR _2760_ sky130_fd_sc_hd__a31o_1
X_8777_ clknet_leaf_63_CLK _0010_ VGND VGND VPWR VPWR RF.reg_arr\[5\]\[11\] sky130_fd_sc_hd__dfxtp_1
XTAP_TAPCELL_ROW_35_672 VGND VPWR sky130_fd_sc_hd__tapvpwrvgnd_1
X_7728_ net340 _3412_ _3824_ VGND VGND VPWR VPWR _3826_ sky130_fd_sc_hd__mux2_1
XFILLER_0_74_382 VGND VGND VPWR VPWR sky130_fd_sc_hd__decap_4
XFILLER_0_105_624 VPWR VGND VPWR VGND sky130_ef_sc_hd__decap_12
XFILLER_0_7_671 VGND VGND VPWR VPWR sky130_fd_sc_hd__fill_1
X_7659_ _3789_ VGND VGND VPWR VPWR _0361_ sky130_fd_sc_hd__clkbuf_1
XFILLER_0_105_668 VGND VGND VPWR VPWR sky130_fd_sc_hd__decap_4
XFILLER_0_6_192 VGND VGND VPWR VPWR sky130_fd_sc_hd__decap_4
X_9329_ clknet_leaf_3_CLK _0562_ VGND VGND VPWR VPWR RF.reg_arr\[20\]\[19\] sky130_fd_sc_hd__dfxtp_1
XFILLER_0_30_474 VGND VGND VPWR VPWR sky130_fd_sc_hd__fill_2
XTAP_TAPCELL_ROW_7_331 VGND VPWR sky130_fd_sc_hd__tapvpwrvgnd_1
Xclkbuf_leaf_102_CLK clknet_3_1__leaf_CLK VGND VGND VPWR VPWR clknet_leaf_102_CLK
+ sky130_fd_sc_hd__clkbuf_8
XFILLER_0_84_157 VGND VGND VPWR VPWR sky130_fd_sc_hd__decap_6
XTAP_TAPCELL_ROW_96_1405 VGND VPWR sky130_fd_sc_hd__tapvpwrvgnd_1
XFILLER_0_4_118 VGND VGND VPWR VPWR sky130_fd_sc_hd__decap_8
XFILLER_0_53_577 VGND VGND VPWR VPWR sky130_fd_sc_hd__fill_2
XFILLER_0_40_205 VGND VGND VPWR VPWR sky130_fd_sc_hd__fill_2
XFILLER_0_40_216 VPWR VGND VPWR VGND sky130_ef_sc_hd__decap_12
XFILLER_0_111_627 VGND VGND VPWR VPWR sky130_fd_sc_hd__decap_4
XFILLER_0_111_605 VGND VGND VPWR VPWR sky130_fd_sc_hd__decap_3
Xhold309 RF.reg_arr\[6\]\[28\] VGND VGND VPWR VPWR net391 sky130_fd_sc_hd__dlygate4sd3_1
XFILLER_0_33_290 VGND VGND VPWR VPWR sky130_fd_sc_hd__fill_2
XFILLER_0_111_638 VGND VGND VPWR VPWR sky130_fd_sc_hd__fill_2
XFILLER_0_68_69 VGND VGND VPWR VPWR sky130_fd_sc_hd__decap_6
XFILLER_0_0_324 VGND VGND VPWR VPWR sky130_fd_sc_hd__fill_2
XFILLER_0_21_463 VGND VGND VPWR VPWR sky130_fd_sc_hd__fill_2
X_5010_ _1795_ _1798_ _1636_ VGND VGND VPWR VPWR _1799_ sky130_fd_sc_hd__mux2_1
Xhold1009 RF.reg_arr\[15\]\[19\] VGND VGND VPWR VPWR net1091 sky130_fd_sc_hd__dlygate4sd3_1
XFILLER_0_84_79 VGND VGND VPWR VPWR sky130_fd_sc_hd__fill_2
XFILLER_0_108_64 VGND VGND VPWR VPWR sky130_fd_sc_hd__decap_8
XTAP_TAPCELL_ROW_105_1512 VGND VPWR sky130_fd_sc_hd__tapvpwrvgnd_1
XFILLER_0_88_430 VGND VGND VPWR VPWR sky130_fd_sc_hd__decap_4
X_8700_ clknet_leaf_24_CLK _0957_ VGND VGND VPWR VPWR RF.reg_arr\[15\]\[30\] sky130_fd_sc_hd__dfxtp_1
X_6961_ _3411_ VGND VGND VPWR VPWR _0041_ sky130_fd_sc_hd__clkbuf_1
X_5912_ _2658_ _2686_ _2434_ VGND VGND VPWR VPWR _2687_ sky130_fd_sc_hd__mux2_1
XFILLER_0_76_625 VGND VGND VPWR VPWR sky130_fd_sc_hd__decap_6
X_6892_ _3365_ VGND VGND VPWR VPWR _0018_ sky130_fd_sc_hd__clkbuf_1
X_8631_ clknet_leaf_39_CLK _0888_ VGND VGND VPWR VPWR RF.reg_arr\[16\]\[25\] sky130_fd_sc_hd__dfxtp_1
XFILLER_0_75_135 VGND VGND VPWR VPWR sky130_fd_sc_hd__decap_4
XFILLER_0_75_113 VGND VGND VPWR VPWR sky130_fd_sc_hd__fill_1
X_5843_ _2621_ _1416_ _2533_ _2534_ _2535_ VGND VGND VPWR VPWR _2622_ sky130_fd_sc_hd__o41a_1
XFILLER_0_33_50 VGND VGND VPWR VPWR sky130_fd_sc_hd__decap_6
X_8562_ clknet_leaf_15_CLK _0819_ VGND VGND VPWR VPWR RF.reg_arr\[23\]\[20\] sky130_fd_sc_hd__dfxtp_1
XTAP_TAPCELL_ROW_32_631 VGND VPWR sky130_fd_sc_hd__tapvpwrvgnd_1
X_5774_ _2553_ _2555_ VGND VGND VPWR VPWR _2556_ sky130_fd_sc_hd__xnor2_1
XTAP_TAPCELL_ROW_60_973 VGND VPWR sky130_fd_sc_hd__tapvpwrvgnd_1
X_7513_ net610 _3401_ _3705_ VGND VGND VPWR VPWR _3712_ sky130_fd_sc_hd__mux2_1
XFILLER_0_44_533 VGND VGND VPWR VPWR sky130_fd_sc_hd__decap_4
X_4725_ _1512_ _1513_ _1042_ VGND VGND VPWR VPWR _1514_ sky130_fd_sc_hd__mux2_1
X_8493_ _4230_ VGND VGND VPWR VPWR _0754_ sky130_fd_sc_hd__clkbuf_1
X_4656_ _1439_ _1441_ _1444_ _1158_ _1163_ VGND VGND VPWR VPWR _1445_ sky130_fd_sc_hd__o221a_1
X_7444_ _3674_ VGND VGND VPWR VPWR _0261_ sky130_fd_sc_hd__clkbuf_1
XTAP_TAPCELL_ROW_116_1652 VGND VPWR sky130_fd_sc_hd__tapvpwrvgnd_1
XTAP_TAPCELL_ROW_116_1641 VGND VPWR sky130_fd_sc_hd__tapvpwrvgnd_1
X_4587_ RF.reg_arr\[12\]\[22\] RF.reg_arr\[13\]\[22\] RF.reg_arr\[14\]\[22\] RF.reg_arr\[15\]\[22\]
+ _1357_ _1358_ VGND VGND VPWR VPWR _1376_ sky130_fd_sc_hd__mux4_1
Xhold821 RF.reg_arr\[7\]\[19\] VGND VGND VPWR VPWR net903 sky130_fd_sc_hd__dlygate4sd3_1
Xhold810 RF.reg_arr\[16\]\[16\] VGND VGND VPWR VPWR net892 sky130_fd_sc_hd__dlygate4sd3_1
XFILLER_0_4_685 VGND VGND VPWR VPWR sky130_fd_sc_hd__decap_6
X_7375_ _3637_ VGND VGND VPWR VPWR _0229_ sky130_fd_sc_hd__clkbuf_1
XPHY_EDGE_ROW_2_Left_119 VGND VGND VPWR VPWR sky130_fd_sc_hd__decap_3
Xhold832 RF.reg_arr\[15\]\[27\] VGND VGND VPWR VPWR net914 sky130_fd_sc_hd__dlygate4sd3_1
X_9114_ clknet_leaf_28_CLK _0347_ VGND VGND VPWR VPWR RF.reg_arr\[2\]\[28\] sky130_fd_sc_hd__dfxtp_1
X_6326_ _3049_ VGND VGND VPWR VPWR _0792_ sky130_fd_sc_hd__clkbuf_1
Xhold843 RF.reg_arr\[17\]\[12\] VGND VGND VPWR VPWR net925 sky130_fd_sc_hd__dlygate4sd3_1
Xhold854 RF.reg_arr\[31\]\[0\] VGND VGND VPWR VPWR net936 sky130_fd_sc_hd__dlygate4sd3_1
Xhold865 RF.reg_arr\[20\]\[30\] VGND VGND VPWR VPWR net947 sky130_fd_sc_hd__dlygate4sd3_1
XFILLER_0_12_474 VGND VGND VPWR VPWR sky130_fd_sc_hd__fill_2
Xhold887 RF.reg_arr\[29\]\[8\] VGND VGND VPWR VPWR net969 sky130_fd_sc_hd__dlygate4sd3_1
Xhold876 RF.reg_arr\[12\]\[17\] VGND VGND VPWR VPWR net958 sky130_fd_sc_hd__dlygate4sd3_1
Xhold898 RF.reg_arr\[25\]\[16\] VGND VGND VPWR VPWR net980 sky130_fd_sc_hd__dlygate4sd3_1
X_9045_ clknet_leaf_25_CLK _0278_ VGND VGND VPWR VPWR RF.reg_arr\[26\]\[23\] sky130_fd_sc_hd__dfxtp_1
X_6257_ _3003_ VGND VGND VPWR VPWR _0769_ sky130_fd_sc_hd__clkbuf_1
X_6188_ _2340_ _2940_ _2941_ _2947_ VGND VGND VPWR VPWR net70 sky130_fd_sc_hd__a31o_1
XTAP_TAPCELL_ROW_4_301 VGND VPWR sky130_fd_sc_hd__tapvpwrvgnd_1
X_5208_ _1643_ _1988_ _1996_ VGND VGND VPWR VPWR _1997_ sky130_fd_sc_hd__o21ai_4
X_5139_ _1792_ _1927_ VGND VGND VPWR VPWR _1928_ sky130_fd_sc_hd__nand2_1
X_8829_ clknet_leaf_24_CLK _0062_ VGND VGND VPWR VPWR RF.reg_arr\[4\]\[31\] sky130_fd_sc_hd__dfxtp_1
XTAP_TAPCELL_ROW_80_1217 VGND VPWR sky130_fd_sc_hd__tapvpwrvgnd_1
XTAP_TAPCELL_ROW_80_1206 VGND VPWR sky130_fd_sc_hd__tapvpwrvgnd_1
XFILLER_0_67_669 VGND VGND VPWR VPWR sky130_fd_sc_hd__decap_3
XFILLER_0_66_135 VGND VGND VPWR VPWR sky130_fd_sc_hd__decap_4
XFILLER_0_82_617 VGND VGND VPWR VPWR sky130_fd_sc_hd__fill_1
XFILLER_0_47_393 VGND VGND VPWR VPWR sky130_fd_sc_hd__fill_2
XFILLER_0_90_661 VGND VGND VPWR VPWR sky130_fd_sc_hd__fill_2
XFILLER_0_7_490 VGND VGND VPWR VPWR sky130_fd_sc_hd__fill_2
XFILLER_0_22_205 VGND VGND VPWR VPWR sky130_fd_sc_hd__fill_2
XTAP_TAPCELL_ROW_10_369 VGND VPWR sky130_fd_sc_hd__tapvpwrvgnd_1
XTAP_TAPCELL_ROW_91_1346 VGND VPWR sky130_fd_sc_hd__tapvpwrvgnd_1
XFILLER_0_101_671 VGND VGND VPWR VPWR sky130_fd_sc_hd__fill_1
XFILLER_0_54_27 VGND VGND VPWR VPWR sky130_fd_sc_hd__fill_1
XTAP_TAPCELL_ROW_18_469 VGND VPWR sky130_fd_sc_hd__tapvpwrvgnd_1
XFILLER_0_57_124 VGND VGND VPWR VPWR sky130_fd_sc_hd__fill_1
XTAP_TAPCELL_ROW_100_1453 VGND VPWR sky130_fd_sc_hd__tapvpwrvgnd_1
X_4510_ RF.reg_arr\[24\]\[29\] RF.reg_arr\[25\]\[29\] RF.reg_arr\[26\]\[29\] RF.reg_arr\[27\]\[29\]
+ _1273_ _1275_ VGND VGND VPWR VPWR _1299_ sky130_fd_sc_hd__mux4_1
XFILLER_0_5_449 VGND VGND VPWR VPWR sky130_fd_sc_hd__decap_8
X_5490_ _2277_ _2278_ _1863_ VGND VGND VPWR VPWR _2279_ sky130_fd_sc_hd__mux2_1
Xhold117 RF.reg_arr\[28\]\[29\] VGND VGND VPWR VPWR net199 sky130_fd_sc_hd__dlygate4sd3_1
XFILLER_0_110_43 VGND VGND VPWR VPWR sky130_fd_sc_hd__fill_1
Xhold106 RF.reg_arr\[9\]\[24\] VGND VGND VPWR VPWR net188 sky130_fd_sc_hd__dlygate4sd3_1
XFILLER_0_102_3 VPWR VGND VPWR VGND sky130_ef_sc_hd__decap_12
XFILLER_0_79_57 VPWR VGND VPWR VGND sky130_ef_sc_hd__decap_12
XFILLER_0_41_536 VGND VGND VPWR VPWR sky130_fd_sc_hd__fill_1
X_4441_ A2[1] VGND VGND VPWR VPWR _1230_ sky130_fd_sc_hd__clkbuf_4
XFILLER_0_111_435 VGND VGND VPWR VPWR sky130_fd_sc_hd__fill_2
X_7160_ _3523_ VGND VGND VPWR VPWR _0128_ sky130_fd_sc_hd__clkbuf_1
XPHY_EDGE_ROW_9_Right_9 VGND VGND VPWR VPWR sky130_fd_sc_hd__decap_3
Xhold128 RF.reg_arr\[1\]\[0\] VGND VGND VPWR VPWR net210 sky130_fd_sc_hd__dlygate4sd3_1
Xhold139 RF.reg_arr\[9\]\[3\] VGND VGND VPWR VPWR net221 sky130_fd_sc_hd__dlygate4sd3_1
X_6111_ _2862_ _2865_ VGND VGND VPWR VPWR _2875_ sky130_fd_sc_hd__or2_1
XFILLER_0_111_479 VGND VGND VPWR VPWR sky130_fd_sc_hd__decap_6
X_4372_ _1116_ _1150_ _1160_ VGND VGND VPWR VPWR _1161_ sky130_fd_sc_hd__o21a_2
X_7091_ net277 _3391_ _3485_ VGND VGND VPWR VPWR _3487_ sky130_fd_sc_hd__mux2_1
XTAP_TAPCELL_ROW_111_1582 VGND VPWR sky130_fd_sc_hd__tapvpwrvgnd_1
XPHY_EDGE_ROW_107_Right_107 VGND VGND VPWR VPWR sky130_fd_sc_hd__decap_3
X_6042_ _2381_ _2808_ _2809_ VGND VGND VPWR VPWR _2810_ sky130_fd_sc_hd__o21ai_1
X_7993_ _3966_ VGND VGND VPWR VPWR _0518_ sky130_fd_sc_hd__clkbuf_1
XTAP_TAPCELL_ROW_37_701 VGND VPWR sky130_fd_sc_hd__tapvpwrvgnd_1
X_6944_ net879 _3399_ _3389_ VGND VGND VPWR VPWR _3400_ sky130_fd_sc_hd__mux2_1
XFILLER_0_49_625 VGND VGND VPWR VPWR sky130_fd_sc_hd__fill_1
XFILLER_0_49_647 VGND VGND VPWR VPWR sky130_fd_sc_hd__decap_6
XFILLER_0_76_477 VGND VGND VPWR VPWR sky130_fd_sc_hd__fill_1
XFILLER_0_64_617 VGND VGND VPWR VPWR sky130_fd_sc_hd__decap_8
X_6875_ net383 _3021_ _3355_ VGND VGND VPWR VPWR _3357_ sky130_fd_sc_hd__mux2_1
X_8614_ clknet_leaf_81_CLK _0871_ VGND VGND VPWR VPWR RF.reg_arr\[16\]\[8\] sky130_fd_sc_hd__dfxtp_1
X_5826_ _1116_ _1228_ _1238_ VGND VGND VPWR VPWR _2606_ sky130_fd_sc_hd__o21ai_1
XFILLER_0_91_447 VGND VGND VPWR VPWR sky130_fd_sc_hd__fill_1
X_5757_ _2538_ _2539_ VGND VGND VPWR VPWR _2540_ sky130_fd_sc_hd__nand2_1
XFILLER_0_8_276 VGND VGND VPWR VPWR sky130_fd_sc_hd__decap_4
XFILLER_0_29_393 VGND VGND VPWR VPWR sky130_fd_sc_hd__decap_6
X_8545_ clknet_leaf_69_CLK _0802_ VGND VGND VPWR VPWR RF.reg_arr\[23\]\[3\] sky130_fd_sc_hd__dfxtp_1
XFILLER_0_72_661 VGND VGND VPWR VPWR sky130_fd_sc_hd__fill_1
X_4708_ _1049_ _1496_ _1077_ VGND VGND VPWR VPWR _1497_ sky130_fd_sc_hd__o21a_1
X_8476_ _4221_ VGND VGND VPWR VPWR _0746_ sky130_fd_sc_hd__clkbuf_1
XFILLER_0_114_251 VGND VGND VPWR VPWR sky130_fd_sc_hd__fill_1
X_5688_ _2029_ _2472_ _2473_ VGND VGND VPWR VPWR _2474_ sky130_fd_sc_hd__o21ba_1
X_7427_ _3664_ VGND VGND VPWR VPWR _0254_ sky130_fd_sc_hd__clkbuf_1
X_4639_ RF.reg_arr\[4\]\[27\] RF.reg_arr\[5\]\[27\] RF.reg_arr\[6\]\[27\] RF.reg_arr\[7\]\[27\]
+ _1302_ _1322_ VGND VGND VPWR VPWR _1428_ sky130_fd_sc_hd__mux4_1
Xhold640 RF.reg_arr\[30\]\[29\] VGND VGND VPWR VPWR net722 sky130_fd_sc_hd__dlygate4sd3_1
Xhold662 RF.reg_arr\[12\]\[24\] VGND VGND VPWR VPWR net744 sky130_fd_sc_hd__dlygate4sd3_1
X_7358_ _3123_ net1104 _3593_ VGND VGND VPWR VPWR _3628_ sky130_fd_sc_hd__mux2_1
Xhold651 RF.reg_arr\[24\]\[2\] VGND VGND VPWR VPWR net733 sky130_fd_sc_hd__dlygate4sd3_1
Xhold695 RF.reg_arr\[25\]\[22\] VGND VGND VPWR VPWR net777 sky130_fd_sc_hd__dlygate4sd3_1
X_7289_ _3591_ VGND VGND VPWR VPWR _0189_ sky130_fd_sc_hd__clkbuf_1
Xhold684 RF.reg_arr\[23\]\[9\] VGND VGND VPWR VPWR net766 sky130_fd_sc_hd__dlygate4sd3_1
Xhold673 RF.reg_arr\[31\]\[13\] VGND VGND VPWR VPWR net755 sky130_fd_sc_hd__dlygate4sd3_1
X_6309_ _3038_ VGND VGND VPWR VPWR _0786_ sky130_fd_sc_hd__clkbuf_1
X_9028_ clknet_leaf_83_CLK _0261_ VGND VGND VPWR VPWR RF.reg_arr\[26\]\[6\] sky130_fd_sc_hd__dfxtp_1
XTAP_TAPCELL_ROW_15_428 VGND VPWR sky130_fd_sc_hd__tapvpwrvgnd_1
XFILLER_0_35_330 VGND VGND VPWR VPWR sky130_fd_sc_hd__decap_3
XFILLER_0_40_29 VGND VGND VPWR VPWR sky130_fd_sc_hd__decap_3
XFILLER_0_23_503 VGND VGND VPWR VPWR sky130_fd_sc_hd__fill_1
XFILLER_0_50_300 VGND VGND VPWR VPWR sky130_fd_sc_hd__decap_8
XFILLER_0_105_273 VGND VGND VPWR VPWR sky130_fd_sc_hd__decap_6
XFILLER_0_4_29 VGND VGND VPWR VPWR sky130_fd_sc_hd__decap_8
X_4990_ RF.reg_arr\[24\]\[24\] RF.reg_arr\[25\]\[24\] RF.reg_arr\[26\]\[24\] RF.reg_arr\[27\]\[24\]
+ _1668_ _1669_ VGND VGND VPWR VPWR _1779_ sky130_fd_sc_hd__mux4_1
XFILLER_0_105_54 VGND VGND VPWR VPWR sky130_fd_sc_hd__fill_2
XFILLER_0_58_477 VGND VGND VPWR VPWR sky130_fd_sc_hd__fill_2
XFILLER_0_46_606 VGND VGND VPWR VPWR sky130_fd_sc_hd__fill_1
XFILLER_0_14_85 VPWR VGND VPWR VGND sky130_ef_sc_hd__decap_12
X_6660_ _3075_ net746 _3232_ VGND VGND VPWR VPWR _3241_ sky130_fd_sc_hd__mux2_1
X_5611_ _2397_ _2398_ VGND VGND VPWR VPWR _2399_ sky130_fd_sc_hd__nand2_1
X_6591_ _3204_ VGND VGND VPWR VPWR _0902_ sky130_fd_sc_hd__clkbuf_1
X_5542_ _1649_ _2330_ VGND VGND VPWR VPWR _2331_ sky130_fd_sc_hd__or2_1
XFILLER_0_60_119 VGND VGND VPWR VPWR sky130_fd_sc_hd__decap_3
XFILLER_0_60_108 VGND VGND VPWR VPWR sky130_fd_sc_hd__fill_2
X_8330_ _3010_ net333 _4138_ VGND VGND VPWR VPWR _4145_ sky130_fd_sc_hd__mux2_1
Xclkbuf_leaf_91_CLK clknet_3_4__leaf_CLK VGND VGND VPWR VPWR clknet_leaf_91_CLK sky130_fd_sc_hd__clkbuf_8
X_5473_ _2258_ _2261_ _1842_ VGND VGND VPWR VPWR _2262_ sky130_fd_sc_hd__mux2_1
X_8261_ _4108_ VGND VGND VPWR VPWR _0644_ sky130_fd_sc_hd__clkbuf_1
XTAP_TAPCELL_ROW_113_1611 VGND VPWR sky130_fd_sc_hd__tapvpwrvgnd_1
X_7212_ _3550_ VGND VGND VPWR VPWR _0153_ sky130_fd_sc_hd__clkbuf_1
X_4424_ _1211_ _1212_ _1075_ VGND VGND VPWR VPWR _1213_ sky130_fd_sc_hd__mux2_1
X_8192_ _3008_ net884 _4066_ VGND VGND VPWR VPWR _4072_ sky130_fd_sc_hd__mux2_1
X_7143_ net666 _3375_ _3507_ VGND VGND VPWR VPWR _3514_ sky130_fd_sc_hd__mux2_1
XPHY_EDGE_ROW_92_Left_209 VGND VGND VPWR VPWR sky130_fd_sc_hd__decap_3
X_4355_ RF.reg_arr\[20\]\[17\] RF.reg_arr\[21\]\[17\] RF.reg_arr\[22\]\[17\] RF.reg_arr\[23\]\[17\]
+ _1129_ _1130_ VGND VGND VPWR VPWR _1144_ sky130_fd_sc_hd__mux4_1
X_7074_ _3477_ VGND VGND VPWR VPWR _0088_ sky130_fd_sc_hd__clkbuf_1
XFILLER_0_39_71 VGND VGND VPWR VPWR sky130_fd_sc_hd__decap_3
Xclkbuf_3_0__f_CLK clknet_0_CLK VGND VGND VPWR VPWR clknet_3_0__leaf_CLK sky130_fd_sc_hd__clkbuf_16
X_4286_ _1032_ VGND VGND VPWR VPWR _1075_ sky130_fd_sc_hd__buf_6
X_6025_ _2793_ _2736_ VGND VGND VPWR VPWR _2794_ sky130_fd_sc_hd__and2b_1
X_7976_ _2996_ _3665_ VGND VGND VPWR VPWR _3957_ sky130_fd_sc_hd__nand2_4
X_6927_ _3157_ _3305_ VGND VGND VPWR VPWR _3388_ sky130_fd_sc_hd__nor2_4
XFILLER_0_37_617 VGND VGND VPWR VPWR sky130_fd_sc_hd__fill_1
X_6858_ net315 _3004_ _3344_ VGND VGND VPWR VPWR _3348_ sky130_fd_sc_hd__mux2_1
XFILLER_0_107_505 VGND VGND VPWR VPWR sky130_fd_sc_hd__decap_6
X_5809_ _2584_ _2589_ VGND VGND VPWR VPWR _2590_ sky130_fd_sc_hd__nand2_1
XFILLER_0_9_596 VGND VGND VPWR VPWR sky130_fd_sc_hd__decap_4
XTAP_TAPCELL_ROW_40_729 VGND VPWR sky130_fd_sc_hd__tapvpwrvgnd_1
X_8528_ clknet_leaf_2_CLK _0785_ VGND VGND VPWR VPWR RF.reg_arr\[1\]\[18\] sky130_fd_sc_hd__dfxtp_1
X_6789_ net160 _3004_ _3307_ VGND VGND VPWR VPWR _3311_ sky130_fd_sc_hd__mux2_1
Xclkbuf_leaf_82_CLK clknet_3_5__leaf_CLK VGND VGND VPWR VPWR clknet_leaf_82_CLK sky130_fd_sc_hd__clkbuf_8
XTAP_TAPCELL_ROW_20_486 VGND VPWR sky130_fd_sc_hd__tapvpwrvgnd_1
XTAP_TAPCELL_ROW_20_497 VGND VPWR sky130_fd_sc_hd__tapvpwrvgnd_1
X_8459_ net774 net39 _4211_ VGND VGND VPWR VPWR _4213_ sky130_fd_sc_hd__mux2_1
XTAP_TAPCELL_ROW_75_1149 VGND VPWR sky130_fd_sc_hd__tapvpwrvgnd_1
XFILLER_0_32_377 VGND VGND VPWR VPWR sky130_fd_sc_hd__fill_1
Xhold470 RF.reg_arr\[13\]\[23\] VGND VGND VPWR VPWR net552 sky130_fd_sc_hd__dlygate4sd3_1
XFILLER_0_13_591 VGND VGND VPWR VPWR sky130_fd_sc_hd__fill_2
Xhold481 RF.reg_arr\[16\]\[9\] VGND VGND VPWR VPWR net563 sky130_fd_sc_hd__dlygate4sd3_1
Xhold492 RF.reg_arr\[4\]\[30\] VGND VGND VPWR VPWR net574 sky130_fd_sc_hd__dlygate4sd3_1
XTAP_TAPCELL_ROW_48_829 VGND VPWR sky130_fd_sc_hd__tapvpwrvgnd_1
XFILLER_0_87_517 VPWR VGND VPWR VGND sky130_ef_sc_hd__decap_12
XTAP_TAPCELL_ROW_86_1289 VGND VPWR sky130_fd_sc_hd__tapvpwrvgnd_1
XTAP_TAPCELL_ROW_86_1278 VGND VPWR sky130_fd_sc_hd__tapvpwrvgnd_1
XTAP_TAPCELL_ROW_28_586 VGND VPWR sky130_fd_sc_hd__tapvpwrvgnd_1
XFILLER_0_27_127 VGND VGND VPWR VPWR sky130_fd_sc_hd__decap_4
XFILLER_0_55_447 VGND VGND VPWR VPWR sky130_fd_sc_hd__fill_1
XFILLER_0_36_661 VGND VGND VPWR VPWR sky130_fd_sc_hd__decap_3
XFILLER_0_36_672 VGND VGND VPWR VPWR sky130_fd_sc_hd__decap_4
Xclkload15 clknet_leaf_18_CLK VGND VGND VPWR VPWR clkload15/Y sky130_fd_sc_hd__inv_6
Xclkload26 clknet_leaf_101_CLK VGND VGND VPWR VPWR clkload26/Y sky130_fd_sc_hd__clkinvlp_4
Xclkbuf_leaf_73_CLK clknet_3_5__leaf_CLK VGND VGND VPWR VPWR clknet_leaf_73_CLK sky130_fd_sc_hd__clkbuf_8
XFILLER_0_106_571 VGND VGND VPWR VPWR sky130_fd_sc_hd__decap_4
Xclkload48 clknet_leaf_37_CLK VGND VGND VPWR VPWR clkload48/Y sky130_fd_sc_hd__bufinv_16
Xclkload37 clknet_leaf_27_CLK VGND VGND VPWR VPWR clkload37/Y sky130_fd_sc_hd__clkinv_4
Xclkload59 clknet_leaf_89_CLK VGND VGND VPWR VPWR clkload59/Y sky130_fd_sc_hd__inv_6
XFILLER_0_50_141 VGND VGND VPWR VPWR sky130_fd_sc_hd__fill_1
XFILLER_0_51_664 VGND VGND VPWR VPWR sky130_fd_sc_hd__fill_2
XFILLER_0_11_517 VGND VGND VPWR VPWR sky130_fd_sc_hd__decap_4
XFILLER_0_50_174 VGND VGND VPWR VPWR sky130_fd_sc_hd__fill_2
XFILLER_0_92_24 VGND VGND VPWR VPWR sky130_fd_sc_hd__fill_1
X_7830_ _3879_ VGND VGND VPWR VPWR _0442_ sky130_fd_sc_hd__clkbuf_1
XFILLER_0_116_53 VGND VGND VPWR VPWR sky130_fd_sc_hd__decap_3
XFILLER_0_25_51 VGND VGND VPWR VPWR sky130_fd_sc_hd__decap_4
X_4973_ _1760_ _1761_ _1613_ VGND VGND VPWR VPWR _1762_ sky130_fd_sc_hd__mux2_1
X_7761_ net173 _3377_ _3835_ VGND VGND VPWR VPWR _3843_ sky130_fd_sc_hd__mux2_1
XFILLER_0_25_95 VGND VGND VPWR VPWR sky130_fd_sc_hd__fill_1
X_7692_ _3806_ VGND VGND VPWR VPWR _0377_ sky130_fd_sc_hd__clkbuf_1
X_9500_ clknet_leaf_24_CLK _0733_ VGND VGND VPWR VPWR RF.reg_arr\[11\]\[30\] sky130_fd_sc_hd__dfxtp_1
XFILLER_0_19_617 VGND VGND VPWR VPWR sky130_fd_sc_hd__decap_4
X_6712_ _3267_ _3268_ VGND VGND VPWR VPWR _3269_ sky130_fd_sc_hd__nand2_2
X_9431_ clknet_leaf_39_CLK _0664_ VGND VGND VPWR VPWR RF.reg_arr\[17\]\[25\] sky130_fd_sc_hd__dfxtp_1
X_6643_ _3231_ VGND VGND VPWR VPWR _3232_ sky130_fd_sc_hd__clkbuf_8
XFILLER_0_116_335 VGND VGND VPWR VPWR sky130_fd_sc_hd__fill_1
XFILLER_0_116_324 VGND VGND VPWR VPWR sky130_fd_sc_hd__decap_3
Xclkload9 clknet_leaf_4_CLK VGND VGND VPWR VPWR clkload9/Y sky130_fd_sc_hd__clkinvlp_4
X_6574_ _3157_ _2976_ VGND VGND VPWR VPWR _3195_ sky130_fd_sc_hd__nor2_2
X_9362_ clknet_leaf_15_CLK _0595_ VGND VGND VPWR VPWR RF.reg_arr\[18\]\[20\] sky130_fd_sc_hd__dfxtp_1
Xclkbuf_leaf_64_CLK clknet_3_6__leaf_CLK VGND VGND VPWR VPWR clknet_leaf_64_CLK sky130_fd_sc_hd__clkbuf_8
X_5525_ _2313_ _2027_ VGND VGND VPWR VPWR _2314_ sky130_fd_sc_hd__nor2_1
X_8313_ _4135_ VGND VGND VPWR VPWR _0669_ sky130_fd_sc_hd__clkbuf_1
X_9293_ clknet_leaf_104_CLK _0526_ VGND VGND VPWR VPWR RF.reg_arr\[25\]\[15\] sky130_fd_sc_hd__dfxtp_1
X_8244_ _2990_ net309 _4065_ VGND VGND VPWR VPWR _4099_ sky130_fd_sc_hd__mux2_1
XFILLER_0_74_3 VGND VGND VPWR VPWR sky130_fd_sc_hd__fill_1
XFILLER_0_14_377 VGND VGND VPWR VPWR sky130_fd_sc_hd__fill_1
X_5456_ RF.reg_arr\[12\]\[7\] RF.reg_arr\[13\]\[7\] RF.reg_arr\[14\]\[7\] RF.reg_arr\[15\]\[7\]
+ _1947_ _1948_ VGND VGND VPWR VPWR _2245_ sky130_fd_sc_hd__mux4_1
XFILLER_0_112_563 VPWR VGND VPWR VGND sky130_ef_sc_hd__decap_12
X_4407_ _1192_ _1195_ _1158_ VGND VGND VPWR VPWR _1196_ sky130_fd_sc_hd__mux2_1
X_8175_ _4062_ VGND VGND VPWR VPWR _0604_ sky130_fd_sc_hd__clkbuf_1
X_5387_ _1895_ _2175_ _1648_ VGND VGND VPWR VPWR _2176_ sky130_fd_sc_hd__o21ai_1
X_7126_ net242 _3426_ _3496_ VGND VGND VPWR VPWR _3505_ sky130_fd_sc_hd__mux2_1
X_4338_ _1122_ _1125_ _1126_ VGND VGND VPWR VPWR _1127_ sky130_fd_sc_hd__mux2_1
X_7057_ _3468_ VGND VGND VPWR VPWR _0080_ sky130_fd_sc_hd__clkbuf_1
X_4269_ RF.reg_arr\[12\]\[5\] RF.reg_arr\[13\]\[5\] RF.reg_arr\[14\]\[5\] RF.reg_arr\[15\]\[5\]
+ _1044_ _1046_ VGND VGND VPWR VPWR _1058_ sky130_fd_sc_hd__mux4_1
X_6008_ _2706_ _2777_ _2361_ VGND VGND VPWR VPWR _2778_ sky130_fd_sc_hd__mux2_1
X_7959_ _3948_ VGND VGND VPWR VPWR _0502_ sky130_fd_sc_hd__clkbuf_1
XFILLER_0_77_561 VPWR VGND VPWR VGND sky130_ef_sc_hd__decap_12
XTAP_TAPCELL_ROW_25_556 VGND VPWR sky130_fd_sc_hd__tapvpwrvgnd_1
XFILLER_0_92_553 VGND VGND VPWR VPWR sky130_fd_sc_hd__fill_2
XFILLER_0_64_233 VGND VGND VPWR VPWR sky130_fd_sc_hd__fill_2
XTAP_TAPCELL_ROW_53_887 VGND VPWR sky130_fd_sc_hd__tapvpwrvgnd_1
XFILLER_0_107_313 VGND VGND VPWR VPWR sky130_fd_sc_hd__fill_2
XFILLER_0_92_564 VGND VGND VPWR VPWR sky130_fd_sc_hd__fill_1
XFILLER_0_9_393 VGND VGND VPWR VPWR sky130_fd_sc_hd__fill_2
XFILLER_0_52_406 VGND VGND VPWR VPWR sky130_fd_sc_hd__fill_2
XFILLER_0_52_417 VGND VGND VPWR VPWR sky130_fd_sc_hd__decap_3
Xclkbuf_leaf_55_CLK clknet_3_7__leaf_CLK VGND VGND VPWR VPWR clknet_leaf_55_CLK sky130_fd_sc_hd__clkbuf_8
XFILLER_0_17_193 VGND VGND VPWR VPWR sky130_fd_sc_hd__fill_2
XFILLER_0_103_541 VGND VGND VPWR VPWR sky130_fd_sc_hd__decap_6
XTAP_TAPCELL_ROW_88_1307 VGND VPWR sky130_fd_sc_hd__tapvpwrvgnd_1
XFILLER_0_83_520 VGND VGND VPWR VPWR sky130_fd_sc_hd__fill_1
XTAP_TAPCELL_ROW_99_1436 VGND VPWR sky130_fd_sc_hd__tapvpwrvgnd_1
XFILLER_0_55_277 VGND VGND VPWR VPWR sky130_fd_sc_hd__decap_3
Xclkbuf_leaf_46_CLK clknet_3_6__leaf_CLK VGND VGND VPWR VPWR clknet_leaf_46_CLK sky130_fd_sc_hd__clkbuf_8
Xclkload104 clknet_leaf_69_CLK VGND VGND VPWR VPWR clkload104/Y sky130_fd_sc_hd__clkinvlp_2
XFILLER_0_102_66 VGND VGND VPWR VPWR sky130_fd_sc_hd__decap_4
XFILLER_0_3_514 VGND VGND VPWR VPWR sky130_fd_sc_hd__decap_6
X_5310_ RF.reg_arr\[8\]\[8\] RF.reg_arr\[9\]\[8\] RF.reg_arr\[10\]\[8\] RF.reg_arr\[11\]\[8\]
+ _2087_ _1859_ VGND VGND VPWR VPWR _2099_ sky130_fd_sc_hd__mux4_1
X_6290_ net227 _3025_ _3019_ VGND VGND VPWR VPWR _3026_ sky130_fd_sc_hd__mux2_1
XFILLER_0_87_57 VGND VGND VPWR VPWR sky130_fd_sc_hd__decap_8
XFILLER_0_23_185 VGND VGND VPWR VPWR sky130_fd_sc_hd__decap_6
X_5241_ _1621_ VGND VGND VPWR VPWR _2030_ sky130_fd_sc_hd__clkbuf_8
X_5172_ RF.reg_arr\[0\]\[19\] RF.reg_arr\[1\]\[19\] RF.reg_arr\[2\]\[19\] RF.reg_arr\[3\]\[19\]
+ _1857_ _1860_ VGND VGND VPWR VPWR _1961_ sky130_fd_sc_hd__mux4_1
Xinput2 A1[1] VGND VGND VPWR VPWR net2 sky130_fd_sc_hd__buf_1
X_8931_ clknet_leaf_75_CLK _0164_ VGND VGND VPWR VPWR RF.reg_arr\[29\]\[5\] sky130_fd_sc_hd__dfxtp_1
XTAP_TAPCELL_ROW_108_1543 VGND VPWR sky130_fd_sc_hd__tapvpwrvgnd_1
X_8862_ clknet_leaf_67_CLK _0095_ VGND VGND VPWR VPWR RF.reg_arr\[3\]\[0\] sky130_fd_sc_hd__dfxtp_1
X_8793_ clknet_leaf_48_CLK _0026_ VGND VGND VPWR VPWR RF.reg_arr\[5\]\[27\] sky130_fd_sc_hd__dfxtp_1
X_7813_ _3870_ VGND VGND VPWR VPWR _0434_ sky130_fd_sc_hd__clkbuf_1
XFILLER_0_59_561 VGND VGND VPWR VPWR sky130_fd_sc_hd__decap_4
X_7744_ net579 _3428_ _3824_ VGND VGND VPWR VPWR _3834_ sky130_fd_sc_hd__mux2_1
X_4956_ RF.reg_arr\[8\]\[26\] RF.reg_arr\[9\]\[26\] RF.reg_arr\[10\]\[26\] RF.reg_arr\[11\]\[26\]
+ _1678_ _1684_ VGND VGND VPWR VPWR _1745_ sky130_fd_sc_hd__mux4_1
XFILLER_0_19_447 VGND VGND VPWR VPWR sky130_fd_sc_hd__fill_1
XTAP_TAPCELL_ROW_22_515 VGND VPWR sky130_fd_sc_hd__tapvpwrvgnd_1
X_7675_ _3797_ VGND VGND VPWR VPWR _0369_ sky130_fd_sc_hd__clkbuf_1
X_4887_ _1675_ VGND VGND VPWR VPWR _1676_ sky130_fd_sc_hd__buf_4
XTAP_TAPCELL_ROW_50_846 VGND VPWR sky130_fd_sc_hd__tapvpwrvgnd_1
XTAP_TAPCELL_ROW_50_857 VGND VPWR sky130_fd_sc_hd__tapvpwrvgnd_1
X_6626_ net416 _2970_ _3218_ VGND VGND VPWR VPWR _3223_ sky130_fd_sc_hd__mux2_1
Xclkbuf_leaf_37_CLK clknet_3_3__leaf_CLK VGND VGND VPWR VPWR clknet_leaf_37_CLK sky130_fd_sc_hd__clkbuf_8
X_9414_ clknet_leaf_81_CLK _0647_ VGND VGND VPWR VPWR RF.reg_arr\[17\]\[8\] sky130_fd_sc_hd__dfxtp_1
XFILLER_0_6_330 VGND VGND VPWR VPWR sky130_fd_sc_hd__decap_3
X_6557_ _3186_ VGND VGND VPWR VPWR _0886_ sky130_fd_sc_hd__clkbuf_1
XFILLER_0_61_247 VGND VGND VPWR VPWR sky130_fd_sc_hd__fill_1
XFILLER_0_14_141 VGND VGND VPWR VPWR sky130_fd_sc_hd__decap_6
X_9345_ clknet_leaf_70_CLK _0578_ VGND VGND VPWR VPWR RF.reg_arr\[18\]\[3\] sky130_fd_sc_hd__dfxtp_1
X_5508_ RF.reg_arr\[28\]\[2\] RF.reg_arr\[29\]\[2\] RF.reg_arr\[30\]\[2\] RF.reg_arr\[31\]\[2\]
+ _1588_ _1679_ VGND VGND VPWR VPWR _2297_ sky130_fd_sc_hd__mux4_1
X_6488_ net104 VGND VGND VPWR VPWR _3149_ sky130_fd_sc_hd__clkbuf_1
X_9276_ clknet_leaf_22_CLK _0509_ VGND VGND VPWR VPWR RF.reg_arr\[21\]\[30\] sky130_fd_sc_hd__dfxtp_1
XFILLER_0_100_533 VGND VGND VPWR VPWR sky130_fd_sc_hd__decap_4
X_8227_ _4090_ VGND VGND VPWR VPWR _0628_ sky130_fd_sc_hd__clkbuf_1
XTAP_TAPCELL_ROW_72_1119 VGND VPWR sky130_fd_sc_hd__tapvpwrvgnd_1
X_5439_ _2226_ _2227_ _1864_ VGND VGND VPWR VPWR _2228_ sky130_fd_sc_hd__mux2_1
X_8158_ net153 _3433_ _4052_ VGND VGND VPWR VPWR _4054_ sky130_fd_sc_hd__mux2_1
X_7109_ _3484_ VGND VGND VPWR VPWR _3496_ sky130_fd_sc_hd__clkbuf_8
X_8089_ _4017_ VGND VGND VPWR VPWR _0563_ sky130_fd_sc_hd__clkbuf_1
XTAP_TAPCELL_ROW_58_946 VGND VPWR sky130_fd_sc_hd__tapvpwrvgnd_1
XTAP_TAPCELL_ROW_2_273 VGND VPWR sky130_fd_sc_hd__tapvpwrvgnd_1
XTAP_TAPCELL_ROW_83_1248 VGND VPWR sky130_fd_sc_hd__tapvpwrvgnd_1
XFILLER_0_32_19 VGND VGND VPWR VPWR sky130_fd_sc_hd__decap_8
XFILLER_0_108_633 VGND VGND VPWR VPWR sky130_fd_sc_hd__decap_8
Xclkbuf_leaf_28_CLK clknet_3_2__leaf_CLK VGND VGND VPWR VPWR clknet_leaf_28_CLK sky130_fd_sc_hd__clkbuf_8
XFILLER_0_80_556 VGND VGND VPWR VPWR sky130_fd_sc_hd__fill_1
XFILLER_0_52_236 VPWR VGND VPWR VGND sky130_ef_sc_hd__decap_12
XFILLER_0_80_589 VPWR VGND VPWR VGND sky130_ef_sc_hd__decap_12
XTAP_TAPCELL_ROW_94_1377 VGND VPWR sky130_fd_sc_hd__tapvpwrvgnd_1
XFILLER_0_88_645 VPWR VGND VPWR VGND sky130_ef_sc_hd__decap_12
XFILLER_0_87_111 VGND VGND VPWR VPWR sky130_fd_sc_hd__fill_1
XFILLER_0_88_667 VGND VGND VPWR VPWR sky130_fd_sc_hd__decap_8
X_4810_ _1598_ VGND VGND VPWR VPWR _1599_ sky130_fd_sc_hd__clkbuf_4
X_5790_ _2569_ _2570_ VGND VGND VPWR VPWR _2571_ sky130_fd_sc_hd__xnor2_1
XFILLER_0_113_54 VGND VGND VPWR VPWR sky130_fd_sc_hd__fill_2
XTAP_TAPCELL_ROW_103_1484 VGND VPWR sky130_fd_sc_hd__tapvpwrvgnd_1
X_4741_ RF.reg_arr\[0\]\[14\] RF.reg_arr\[1\]\[14\] RF.reg_arr\[2\]\[14\] RF.reg_arr\[3\]\[14\]
+ _1129_ _1130_ VGND VGND VPWR VPWR _1530_ sky130_fd_sc_hd__mux4_1
X_4672_ _1459_ _1460_ _1308_ VGND VGND VPWR VPWR _1461_ sky130_fd_sc_hd__mux2_1
XFILLER_0_71_512 VGND VGND VPWR VPWR sky130_fd_sc_hd__fill_1
Xclkbuf_leaf_19_CLK clknet_3_0__leaf_CLK VGND VGND VPWR VPWR clknet_leaf_19_CLK sky130_fd_sc_hd__clkbuf_8
X_7460_ _3088_ net1016 _3678_ VGND VGND VPWR VPWR _3683_ sky130_fd_sc_hd__mux2_1
XFILLER_0_114_625 VPWR VGND VPWR VGND sky130_ef_sc_hd__decap_12
XFILLER_0_71_556 VGND VGND VPWR VPWR sky130_fd_sc_hd__fill_1
X_6411_ _3105_ net732 _3101_ VGND VGND VPWR VPWR _3106_ sky130_fd_sc_hd__mux2_1
XFILLER_0_114_669 VPWR VGND VPWR VGND sky130_ef_sc_hd__decap_12
X_7391_ _3088_ net661 _3641_ VGND VGND VPWR VPWR _3646_ sky130_fd_sc_hd__mux2_1
X_9130_ clknet_leaf_100_CLK _0363_ VGND VGND VPWR VPWR RF.reg_arr\[30\]\[12\] sky130_fd_sc_hd__dfxtp_1
X_6342_ _3058_ VGND VGND VPWR VPWR _3059_ sky130_fd_sc_hd__clkbuf_8
X_9061_ clknet_leaf_99_CLK _0294_ VGND VGND VPWR VPWR RF.reg_arr\[28\]\[7\] sky130_fd_sc_hd__dfxtp_1
X_6273_ net44 VGND VGND VPWR VPWR _3014_ sky130_fd_sc_hd__buf_2
X_8012_ _3976_ VGND VGND VPWR VPWR _0527_ sky130_fd_sc_hd__clkbuf_1
X_5224_ RF.reg_arr\[4\]\[3\] RF.reg_arr\[5\]\[3\] RF.reg_arr\[6\]\[3\] RF.reg_arr\[7\]\[3\]
+ _1043_ _1083_ VGND VGND VPWR VPWR _2013_ sky130_fd_sc_hd__mux4_1
X_5155_ _1937_ _1939_ _1943_ _1618_ _1586_ VGND VGND VPWR VPWR _1944_ sky130_fd_sc_hd__a221o_1
XFILLER_0_37_3 VGND VGND VPWR VPWR sky130_fd_sc_hd__fill_1
X_5086_ RF.reg_arr\[16\]\[23\] RF.reg_arr\[17\]\[23\] RF.reg_arr\[18\]\[23\] RF.reg_arr\[19\]\[23\]
+ _1676_ _1682_ VGND VGND VPWR VPWR _1875_ sky130_fd_sc_hd__mux4_1
X_8914_ clknet_leaf_43_CLK _0147_ VGND VGND VPWR VPWR RF.reg_arr\[7\]\[20\] sky130_fd_sc_hd__dfxtp_1
XTAP_TAPCELL_ROW_55_916 VGND VPWR sky130_fd_sc_hd__tapvpwrvgnd_1
XFILLER_0_78_122 VGND VGND VPWR VPWR sky130_fd_sc_hd__decap_6
XTAP_TAPCELL_ROW_69_1081 VGND VPWR sky130_fd_sc_hd__tapvpwrvgnd_1
X_8845_ clknet_leaf_104_CLK _0078_ VGND VGND VPWR VPWR RF.reg_arr\[19\]\[15\] sky130_fd_sc_hd__dfxtp_1
XFILLER_0_66_306 VGND VGND VPWR VPWR sky130_fd_sc_hd__fill_2
X_5988_ _2447_ VGND VGND VPWR VPWR _2759_ sky130_fd_sc_hd__buf_2
XTAP_TAPCELL_ROW_35_673 VGND VPWR sky130_fd_sc_hd__tapvpwrvgnd_1
XFILLER_0_47_542 VGND VGND VPWR VPWR sky130_fd_sc_hd__fill_1
X_8776_ clknet_leaf_63_CLK _0009_ VGND VGND VPWR VPWR RF.reg_arr\[5\]\[10\] sky130_fd_sc_hd__dfxtp_1
XFILLER_0_93_169 VGND VGND VPWR VPWR sky130_fd_sc_hd__decap_3
X_4939_ RF.reg_arr\[4\]\[1\] RF.reg_arr\[5\]\[1\] RF.reg_arr\[6\]\[1\] RF.reg_arr\[7\]\[1\]
+ _1050_ _1052_ VGND VGND VPWR VPWR _1728_ sky130_fd_sc_hd__mux4_1
X_7727_ _3825_ VGND VGND VPWR VPWR _0393_ sky130_fd_sc_hd__clkbuf_1
XFILLER_0_7_661 VGND VGND VPWR VPWR sky130_fd_sc_hd__fill_1
XFILLER_0_19_277 VGND VGND VPWR VPWR sky130_fd_sc_hd__decap_3
X_7658_ _3079_ net762 _3788_ VGND VGND VPWR VPWR _3789_ sky130_fd_sc_hd__mux2_1
XFILLER_0_105_636 VGND VGND VPWR VPWR sky130_fd_sc_hd__decap_8
X_6609_ net452 _3031_ _3207_ VGND VGND VPWR VPWR _3214_ sky130_fd_sc_hd__mux2_1
X_7589_ _3740_ VGND VGND VPWR VPWR _3752_ sky130_fd_sc_hd__buf_4
X_9328_ clknet_leaf_106_CLK _0561_ VGND VGND VPWR VPWR RF.reg_arr\[20\]\[18\] sky130_fd_sc_hd__dfxtp_1
XFILLER_0_113_691 VGND VGND VPWR VPWR sky130_fd_sc_hd__fill_1
X_9259_ clknet_leaf_93_CLK _0492_ VGND VGND VPWR VPWR RF.reg_arr\[21\]\[13\] sky130_fd_sc_hd__dfxtp_1
XTAP_TAPCELL_ROW_7_332 VGND VPWR sky130_fd_sc_hd__tapvpwrvgnd_1
XFILLER_0_100_374 VGND VGND VPWR VPWR sky130_fd_sc_hd__decap_6
XFILLER_0_100_363 VGND VGND VPWR VPWR sky130_fd_sc_hd__fill_1
XFILLER_0_85_615 VGND VGND VPWR VPWR sky130_fd_sc_hd__fill_1
XFILLER_0_69_199 VGND VGND VPWR VPWR sky130_fd_sc_hd__fill_2
XFILLER_0_72_309 VGND VGND VPWR VPWR sky130_fd_sc_hd__fill_1
XFILLER_0_53_534 VGND VGND VPWR VPWR sky130_fd_sc_hd__decap_4
XFILLER_0_108_474 VGND VGND VPWR VPWR sky130_fd_sc_hd__fill_2
XTAP_TAPCELL_ROW_96_1406 VGND VPWR sky130_fd_sc_hd__tapvpwrvgnd_1
XFILLER_0_21_431 VGND VGND VPWR VPWR sky130_fd_sc_hd__decap_4
XFILLER_0_21_453 VGND VGND VPWR VPWR sky130_fd_sc_hd__fill_1
XFILLER_0_103_190 VGND VGND VPWR VPWR sky130_fd_sc_hd__decap_3
Xclkbuf_leaf_8_CLK clknet_3_0__leaf_CLK VGND VGND VPWR VPWR clknet_leaf_8_CLK sky130_fd_sc_hd__clkbuf_8
X_6960_ net705 _3409_ _3410_ VGND VGND VPWR VPWR _3411_ sky130_fd_sc_hd__mux2_1
XTAP_TAPCELL_ROW_105_1513 VGND VPWR sky130_fd_sc_hd__tapvpwrvgnd_1
X_5911_ _2141_ _2194_ VGND VGND VPWR VPWR _2686_ sky130_fd_sc_hd__nand2_1
X_6891_ net313 _3037_ _3355_ VGND VGND VPWR VPWR _3365_ sky130_fd_sc_hd__mux2_1
X_8630_ clknet_leaf_52_CLK _0887_ VGND VGND VPWR VPWR RF.reg_arr\[16\]\[24\] sky130_fd_sc_hd__dfxtp_1
X_5842_ _2569_ _2606_ VGND VGND VPWR VPWR _2621_ sky130_fd_sc_hd__nand2_1
X_5773_ _2538_ _2544_ _2554_ VGND VGND VPWR VPWR _2555_ sky130_fd_sc_hd__a21o_1
XTAP_TAPCELL_ROW_32_632 VGND VPWR sky130_fd_sc_hd__tapvpwrvgnd_1
X_8561_ clknet_leaf_4_CLK _0818_ VGND VGND VPWR VPWR RF.reg_arr\[23\]\[19\] sky130_fd_sc_hd__dfxtp_1
XTAP_TAPCELL_ROW_60_974 VGND VPWR sky130_fd_sc_hd__tapvpwrvgnd_1
X_7512_ _3711_ VGND VGND VPWR VPWR _0292_ sky130_fd_sc_hd__clkbuf_1
X_4724_ RF.reg_arr\[0\]\[13\] RF.reg_arr\[1\]\[13\] RF.reg_arr\[2\]\[13\] RF.reg_arr\[3\]\[13\]
+ _1342_ _1343_ VGND VGND VPWR VPWR _1513_ sky130_fd_sc_hd__mux4_1
X_8492_ net921 net24 _4222_ VGND VGND VPWR VPWR _4230_ sky130_fd_sc_hd__mux2_1
X_4655_ _1442_ _1443_ _1308_ VGND VGND VPWR VPWR _1444_ sky130_fd_sc_hd__mux2_1
X_7443_ _3071_ net1023 _3667_ VGND VGND VPWR VPWR _3674_ sky130_fd_sc_hd__mux2_1
XFILLER_0_44_589 VGND VGND VPWR VPWR sky130_fd_sc_hd__fill_2
XTAP_TAPCELL_ROW_116_1642 VGND VPWR sky130_fd_sc_hd__tapvpwrvgnd_1
X_4586_ RF.reg_arr\[8\]\[22\] RF.reg_arr\[9\]\[22\] RF.reg_arr\[10\]\[22\] RF.reg_arr\[11\]\[22\]
+ _1357_ _1358_ VGND VGND VPWR VPWR _1375_ sky130_fd_sc_hd__mux4_1
Xhold811 RF.reg_arr\[18\]\[14\] VGND VGND VPWR VPWR net893 sky130_fd_sc_hd__dlygate4sd3_1
X_7374_ _3071_ net800 _3630_ VGND VGND VPWR VPWR _3637_ sky130_fd_sc_hd__mux2_1
Xhold800 RF.reg_arr\[30\]\[5\] VGND VGND VPWR VPWR net882 sky130_fd_sc_hd__dlygate4sd3_1
XTAP_TAPCELL_ROW_116_1653 VGND VPWR sky130_fd_sc_hd__tapvpwrvgnd_1
XFILLER_0_102_639 VGND VGND VPWR VPWR sky130_fd_sc_hd__decap_4
X_9113_ clknet_leaf_48_CLK _0346_ VGND VGND VPWR VPWR RF.reg_arr\[2\]\[27\] sky130_fd_sc_hd__dfxtp_1
Xhold822 RF.reg_arr\[12\]\[31\] VGND VGND VPWR VPWR net904 sky130_fd_sc_hd__dlygate4sd3_1
X_6325_ net404 _2980_ _3040_ VGND VGND VPWR VPWR _3049_ sky130_fd_sc_hd__mux2_1
Xhold844 RF.reg_arr\[24\]\[21\] VGND VGND VPWR VPWR net926 sky130_fd_sc_hd__dlygate4sd3_1
Xhold833 RF.reg_arr\[14\]\[15\] VGND VGND VPWR VPWR net915 sky130_fd_sc_hd__dlygate4sd3_1
Xhold855 RF.reg_arr\[15\]\[10\] VGND VGND VPWR VPWR net937 sky130_fd_sc_hd__dlygate4sd3_1
Xhold888 RF.reg_arr\[29\]\[25\] VGND VGND VPWR VPWR net970 sky130_fd_sc_hd__dlygate4sd3_1
X_9044_ clknet_leaf_62_CLK _0277_ VGND VGND VPWR VPWR RF.reg_arr\[26\]\[22\] sky130_fd_sc_hd__dfxtp_1
Xhold866 RF.reg_arr\[8\]\[6\] VGND VGND VPWR VPWR net948 sky130_fd_sc_hd__dlygate4sd3_1
Xhold877 RF.reg_arr\[14\]\[14\] VGND VGND VPWR VPWR net959 sky130_fd_sc_hd__dlygate4sd3_1
X_6256_ net285 _3002_ _2998_ VGND VGND VPWR VPWR _3003_ sky130_fd_sc_hd__mux2_1
Xhold899 RF.reg_arr\[25\]\[7\] VGND VGND VPWR VPWR net981 sky130_fd_sc_hd__dlygate4sd3_1
X_6187_ _2680_ _2714_ _2928_ _2353_ _2946_ VGND VGND VPWR VPWR _2947_ sky130_fd_sc_hd__o221ai_2
XTAP_TAPCELL_ROW_4_302 VGND VPWR sky130_fd_sc_hd__tapvpwrvgnd_1
X_5207_ _1990_ _1992_ _1995_ _1845_ _1585_ VGND VGND VPWR VPWR _1996_ sky130_fd_sc_hd__a221o_1
X_5138_ _1833_ _1926_ VGND VGND VPWR VPWR _1927_ sky130_fd_sc_hd__or2_1
XFILLER_0_74_91 VGND VGND VPWR VPWR sky130_fd_sc_hd__fill_1
X_5069_ _1594_ VGND VGND VPWR VPWR _1858_ sky130_fd_sc_hd__buf_4
XFILLER_0_67_615 VGND VGND VPWR VPWR sky130_fd_sc_hd__fill_1
XFILLER_0_79_497 VGND VGND VPWR VPWR sky130_fd_sc_hd__decap_6
XTAP_TAPCELL_ROW_80_1207 VGND VPWR sky130_fd_sc_hd__tapvpwrvgnd_1
X_8828_ clknet_leaf_22_CLK _0061_ VGND VGND VPWR VPWR RF.reg_arr\[4\]\[30\] sky130_fd_sc_hd__dfxtp_1
XFILLER_0_109_216 VGND VGND VPWR VPWR sky130_fd_sc_hd__fill_2
X_8759_ clknet_leaf_37_CLK _1016_ VGND VGND VPWR VPWR RF.reg_arr\[6\]\[25\] sky130_fd_sc_hd__dfxtp_1
XFILLER_0_94_489 VGND VGND VPWR VPWR sky130_fd_sc_hd__decap_8
XFILLER_0_75_670 VGND VGND VPWR VPWR sky130_fd_sc_hd__fill_2
XFILLER_0_47_361 VGND VGND VPWR VPWR sky130_fd_sc_hd__fill_2
XFILLER_0_90_651 VGND VGND VPWR VPWR sky130_fd_sc_hd__fill_1
XPHY_EDGE_ROW_112_Left_229 VGND VGND VPWR VPWR sky130_fd_sc_hd__decap_3
XTAP_TAPCELL_ROW_91_1347 VGND VPWR sky130_fd_sc_hd__tapvpwrvgnd_1
XFILLER_0_70_27 VGND VGND VPWR VPWR sky130_fd_sc_hd__fill_1
XFILLER_0_38_383 VGND VGND VPWR VPWR sky130_fd_sc_hd__decap_4
XTAP_TAPCELL_ROW_100_1454 VGND VPWR sky130_fd_sc_hd__tapvpwrvgnd_1
XFILLER_0_5_417 VGND VGND VPWR VPWR sky130_fd_sc_hd__decap_3
XFILLER_0_53_353 VGND VGND VPWR VPWR sky130_fd_sc_hd__fill_2
XFILLER_0_53_375 VGND VGND VPWR VPWR sky130_fd_sc_hd__fill_1
XFILLER_0_79_69 VGND VGND VPWR VPWR sky130_fd_sc_hd__fill_2
XFILLER_0_1_601 VPWR VGND VPWR VGND sky130_ef_sc_hd__decap_12
Xhold107 RF.reg_arr\[2\]\[7\] VGND VGND VPWR VPWR net189 sky130_fd_sc_hd__dlygate4sd3_1
X_4440_ A2[0] VGND VGND VPWR VPWR _1229_ sky130_fd_sc_hd__buf_6
Xhold129 RF.reg_arr\[19\]\[28\] VGND VGND VPWR VPWR net211 sky130_fd_sc_hd__dlygate4sd3_1
Xhold118 RF.reg_arr\[8\]\[15\] VGND VGND VPWR VPWR net200 sky130_fd_sc_hd__dlygate4sd3_1
X_6110_ _2872_ _2873_ VGND VGND VPWR VPWR _2874_ sky130_fd_sc_hd__and2_1
X_4371_ _1152_ _1154_ _1157_ _1158_ _1159_ VGND VGND VPWR VPWR _1160_ sky130_fd_sc_hd__a221o_1
X_7090_ _3486_ VGND VGND VPWR VPWR _0095_ sky130_fd_sc_hd__clkbuf_1
X_6041_ _2510_ _2715_ _2718_ _2679_ VGND VGND VPWR VPWR _2809_ sky130_fd_sc_hd__o22a_1
XTAP_TAPCELL_ROW_111_1583 VGND VPWR sky130_fd_sc_hd__tapvpwrvgnd_1
X_7992_ _3012_ net981 _3958_ VGND VGND VPWR VPWR _3966_ sky130_fd_sc_hd__mux2_1
X_6943_ net41 VGND VGND VPWR VPWR _3399_ sky130_fd_sc_hd__buf_2
XTAP_TAPCELL_ROW_66_1040 VGND VPWR sky130_fd_sc_hd__tapvpwrvgnd_1
X_6874_ _3356_ VGND VGND VPWR VPWR _0009_ sky130_fd_sc_hd__clkbuf_1
X_5825_ _2362_ _2583_ _2586_ _2378_ _2604_ VGND VGND VPWR VPWR _2605_ sky130_fd_sc_hd__o221a_1
XFILLER_0_64_607 VGND VGND VPWR VPWR sky130_fd_sc_hd__fill_2
X_8613_ clknet_leaf_83_CLK _0870_ VGND VGND VPWR VPWR RF.reg_arr\[16\]\[7\] sky130_fd_sc_hd__dfxtp_1
XFILLER_0_36_309 VGND VGND VPWR VPWR sky130_fd_sc_hd__decap_6
XTAP_TAPCELL_ROW_45_790 VGND VPWR sky130_fd_sc_hd__tapvpwrvgnd_1
XFILLER_0_48_136 VGND VGND VPWR VPWR sky130_fd_sc_hd__decap_4
X_5756_ _2271_ _2537_ VGND VGND VPWR VPWR _2539_ sky130_fd_sc_hd__or2_1
X_8544_ clknet_leaf_56_CLK _0801_ VGND VGND VPWR VPWR RF.reg_arr\[23\]\[2\] sky130_fd_sc_hd__dfxtp_1
XFILLER_0_17_545 VGND VGND VPWR VPWR sky130_fd_sc_hd__fill_1
X_5687_ _2028_ _2383_ _2384_ VGND VGND VPWR VPWR _2473_ sky130_fd_sc_hd__and3_1
X_4707_ RF.reg_arr\[0\]\[12\] RF.reg_arr\[1\]\[12\] RF.reg_arr\[2\]\[12\] RF.reg_arr\[3\]\[12\]
+ _1342_ _1343_ VGND VGND VPWR VPWR _1496_ sky130_fd_sc_hd__mux4_1
X_8475_ net1097 net16 _4211_ VGND VGND VPWR VPWR _4221_ sky130_fd_sc_hd__mux2_1
X_4638_ _1284_ _1426_ VGND VGND VPWR VPWR _1427_ sky130_fd_sc_hd__nor2_1
X_7426_ _3123_ net633 _3629_ VGND VGND VPWR VPWR _3664_ sky130_fd_sc_hd__mux2_1
XFILLER_0_114_274 VGND VGND VPWR VPWR sky130_fd_sc_hd__fill_2
Xhold630 RF.reg_arr\[24\]\[3\] VGND VGND VPWR VPWR net712 sky130_fd_sc_hd__dlygate4sd3_1
Xhold641 RF.reg_arr\[22\]\[28\] VGND VGND VPWR VPWR net723 sky130_fd_sc_hd__dlygate4sd3_1
X_4569_ _1029_ VGND VGND VPWR VPWR _1358_ sky130_fd_sc_hd__buf_4
XTAP_TAPCELL_ROW_77_1180 VGND VPWR sky130_fd_sc_hd__tapvpwrvgnd_1
Xhold663 RF.reg_arr\[12\]\[20\] VGND VGND VPWR VPWR net745 sky130_fd_sc_hd__dlygate4sd3_1
X_7357_ _3627_ VGND VGND VPWR VPWR _0221_ sky130_fd_sc_hd__clkbuf_1
Xhold652 RF.reg_arr\[23\]\[14\] VGND VGND VPWR VPWR net734 sky130_fd_sc_hd__dlygate4sd3_1
Xhold685 RF.reg_arr\[25\]\[23\] VGND VGND VPWR VPWR net767 sky130_fd_sc_hd__dlygate4sd3_1
Xhold696 RF.reg_arr\[31\]\[22\] VGND VGND VPWR VPWR net778 sky130_fd_sc_hd__dlygate4sd3_1
X_7288_ _3121_ net787 _3557_ VGND VGND VPWR VPWR _3591_ sky130_fd_sc_hd__mux2_1
Xhold674 RF.reg_arr\[25\]\[14\] VGND VGND VPWR VPWR net756 sky130_fd_sc_hd__dlygate4sd3_1
X_6308_ net485 _3037_ _3019_ VGND VGND VPWR VPWR _3038_ sky130_fd_sc_hd__mux2_1
X_6239_ net37 VGND VGND VPWR VPWR _2990_ sky130_fd_sc_hd__buf_2
X_9027_ clknet_leaf_73_CLK _0260_ VGND VGND VPWR VPWR RF.reg_arr\[26\]\[5\] sky130_fd_sc_hd__dfxtp_1
XFILLER_0_86_209 VGND VGND VPWR VPWR sky130_fd_sc_hd__fill_1
XFILLER_0_79_272 VGND VGND VPWR VPWR sky130_fd_sc_hd__decap_4
XFILLER_0_39_125 VGND VGND VPWR VPWR sky130_fd_sc_hd__fill_1
XFILLER_0_94_253 VGND VGND VPWR VPWR sky130_fd_sc_hd__fill_1
XFILLER_0_67_445 VGND VGND VPWR VPWR sky130_fd_sc_hd__decap_3
XTAP_TAPCELL_ROW_15_429 VGND VPWR sky130_fd_sc_hd__tapvpwrvgnd_1
XFILLER_0_82_437 VGND VGND VPWR VPWR sky130_fd_sc_hd__fill_1
XFILLER_0_35_353 VGND VGND VPWR VPWR sky130_fd_sc_hd__fill_2
XFILLER_0_62_194 VGND VGND VPWR VPWR sky130_fd_sc_hd__fill_2
XFILLER_0_35_397 VGND VGND VPWR VPWR sky130_fd_sc_hd__fill_1
XFILLER_0_10_209 VGND VGND VPWR VPWR sky130_fd_sc_hd__decap_4
XFILLER_0_98_581 VGND VGND VPWR VPWR sky130_fd_sc_hd__decap_6
XFILLER_0_85_220 VGND VGND VPWR VPWR sky130_fd_sc_hd__decap_4
XFILLER_0_14_42 VGND VGND VPWR VPWR sky130_fd_sc_hd__fill_2
XFILLER_0_85_275 VGND VGND VPWR VPWR sky130_fd_sc_hd__fill_1
XFILLER_0_18_309 VGND VGND VPWR VPWR sky130_fd_sc_hd__decap_8
X_5610_ _1833_ _2140_ _1700_ VGND VGND VPWR VPWR _2398_ sky130_fd_sc_hd__o21ai_1
XFILLER_0_14_97 VPWR VGND VPWR VGND sky130_ef_sc_hd__decap_12
X_6590_ net651 _3012_ _3196_ VGND VGND VPWR VPWR _3204_ sky130_fd_sc_hd__mux2_1
XFILLER_0_38_191 VGND VGND VPWR VPWR sky130_fd_sc_hd__decap_4
XTAP_TAPCELL_ROW_42_760 VGND VPWR sky130_fd_sc_hd__tapvpwrvgnd_1
X_5541_ _1641_ _2321_ _2325_ _2329_ VGND VGND VPWR VPWR _2330_ sky130_fd_sc_hd__a2bb2o_1
XFILLER_0_14_515 VGND VGND VPWR VPWR sky130_fd_sc_hd__fill_2
XFILLER_0_5_269 VGND VGND VPWR VPWR sky130_fd_sc_hd__fill_2
X_8260_ net837 _3399_ _4102_ VGND VGND VPWR VPWR _4108_ sky130_fd_sc_hd__mux2_1
XFILLER_0_41_323 VGND VGND VPWR VPWR sky130_fd_sc_hd__fill_1
X_7211_ net453 _3375_ _3543_ VGND VGND VPWR VPWR _3550_ sky130_fd_sc_hd__mux2_1
X_5472_ _2259_ _2260_ _1611_ VGND VGND VPWR VPWR _2261_ sky130_fd_sc_hd__mux2_1
XFILLER_0_30_96 VGND VGND VPWR VPWR sky130_fd_sc_hd__decap_6
XTAP_TAPCELL_ROW_113_1612 VGND VPWR sky130_fd_sc_hd__tapvpwrvgnd_1
XFILLER_0_111_222 VGND VGND VPWR VPWR sky130_fd_sc_hd__fill_2
X_4423_ RF.reg_arr\[24\]\[8\] RF.reg_arr\[25\]\[8\] RF.reg_arr\[26\]\[8\] RF.reg_arr\[27\]\[8\]
+ net93 _1094_ VGND VGND VPWR VPWR _1212_ sky130_fd_sc_hd__mux4_1
X_8191_ _4071_ VGND VGND VPWR VPWR _0611_ sky130_fd_sc_hd__clkbuf_1
X_7142_ _3513_ VGND VGND VPWR VPWR _0120_ sky130_fd_sc_hd__clkbuf_1
X_4354_ _1116_ _1127_ _1142_ VGND VGND VPWR VPWR _1143_ sky130_fd_sc_hd__o21a_2
X_7073_ net467 _3373_ _3471_ VGND VGND VPWR VPWR _3477_ sky130_fd_sc_hd__mux2_1
X_6024_ _2727_ _2741_ _2762_ _2773_ VGND VGND VPWR VPWR _2793_ sky130_fd_sc_hd__or4_4
X_4285_ RF.reg_arr\[16\]\[4\] RF.reg_arr\[17\]\[4\] RF.reg_arr\[18\]\[4\] RF.reg_arr\[19\]\[4\]
+ net1126 _1069_ VGND VGND VPWR VPWR _1074_ sky130_fd_sc_hd__mux4_1
XFILLER_0_96_518 VGND VGND VPWR VPWR sky130_fd_sc_hd__decap_3
X_7975_ _3956_ VGND VGND VPWR VPWR _0510_ sky130_fd_sc_hd__clkbuf_1
X_6926_ net14 VGND VGND VPWR VPWR _3387_ sky130_fd_sc_hd__buf_2
X_6857_ _3347_ VGND VGND VPWR VPWR _0001_ sky130_fd_sc_hd__clkbuf_1
X_5808_ _2004_ _2586_ _2588_ _2199_ VGND VGND VPWR VPWR _2589_ sky130_fd_sc_hd__o22a_1
X_6788_ _3310_ VGND VGND VPWR VPWR _0993_ sky130_fd_sc_hd__clkbuf_1
XFILLER_0_36_139 VGND VGND VPWR VPWR sky130_fd_sc_hd__fill_1
XFILLER_0_45_640 VGND VGND VPWR VPWR sky130_fd_sc_hd__fill_2
X_5739_ _2046_ _2441_ _2434_ VGND VGND VPWR VPWR _2522_ sky130_fd_sc_hd__mux2_1
X_8527_ clknet_leaf_103_CLK _0784_ VGND VGND VPWR VPWR RF.reg_arr\[1\]\[17\] sky130_fd_sc_hd__dfxtp_1
XFILLER_0_45_673 VGND VGND VPWR VPWR sky130_fd_sc_hd__fill_2
XFILLER_0_115_561 VPWR VGND VPWR VGND sky130_ef_sc_hd__decap_12
XFILLER_0_60_654 VGND VGND VPWR VPWR sky130_fd_sc_hd__decap_6
X_8458_ _4212_ VGND VGND VPWR VPWR _0737_ sky130_fd_sc_hd__clkbuf_1
XTAP_TAPCELL_ROW_20_487 VGND VPWR sky130_fd_sc_hd__tapvpwrvgnd_1
XFILLER_0_32_345 VGND VGND VPWR VPWR sky130_fd_sc_hd__fill_2
X_7409_ _3655_ VGND VGND VPWR VPWR _0245_ sky130_fd_sc_hd__clkbuf_1
X_8389_ _4176_ VGND VGND VPWR VPWR _0704_ sky130_fd_sc_hd__clkbuf_1
Xhold471 RF.reg_arr\[17\]\[3\] VGND VGND VPWR VPWR net553 sky130_fd_sc_hd__dlygate4sd3_1
Xhold460 RF.reg_arr\[29\]\[16\] VGND VGND VPWR VPWR net542 sky130_fd_sc_hd__dlygate4sd3_1
Xhold493 RF.reg_arr\[29\]\[27\] VGND VGND VPWR VPWR net575 sky130_fd_sc_hd__dlygate4sd3_1
Xhold482 RF.reg_arr\[4\]\[26\] VGND VGND VPWR VPWR net564 sky130_fd_sc_hd__dlygate4sd3_1
XFILLER_0_87_529 VGND VGND VPWR VPWR sky130_fd_sc_hd__decap_6
XTAP_TAPCELL_ROW_86_1279 VGND VPWR sky130_fd_sc_hd__tapvpwrvgnd_1
XFILLER_0_67_220 VGND VGND VPWR VPWR sky130_fd_sc_hd__decap_4
XTAP_TAPCELL_ROW_28_587 VGND VPWR sky130_fd_sc_hd__tapvpwrvgnd_1
XFILLER_0_70_418 VGND VGND VPWR VPWR sky130_fd_sc_hd__fill_2
XFILLER_0_113_509 VGND VGND VPWR VPWR sky130_fd_sc_hd__fill_1
Xclkload16 clknet_leaf_19_CLK VGND VGND VPWR VPWR clkload16/Y sky130_fd_sc_hd__clkinv_8
Xclkload38 clknet_leaf_29_CLK VGND VGND VPWR VPWR clkload38/X sky130_fd_sc_hd__clkbuf_4
Xclkload49 clknet_leaf_38_CLK VGND VGND VPWR VPWR clkload49/Y sky130_fd_sc_hd__clkinv_4
Xclkload27 clknet_leaf_102_CLK VGND VGND VPWR VPWR clkload27/Y sky130_fd_sc_hd__clkinv_4
XFILLER_0_23_334 VGND VGND VPWR VPWR sky130_fd_sc_hd__fill_2
XFILLER_0_50_197 VGND VGND VPWR VPWR sky130_fd_sc_hd__fill_1
X_7760_ _3842_ VGND VGND VPWR VPWR _0409_ sky130_fd_sc_hd__clkbuf_1
X_4972_ RF.reg_arr\[24\]\[27\] RF.reg_arr\[25\]\[27\] RF.reg_arr\[26\]\[27\] RF.reg_arr\[27\]\[27\]
+ _1677_ _1683_ VGND VGND VPWR VPWR _1761_ sky130_fd_sc_hd__mux4_1
XTAP_TAPCELL_ROW_63_1010 VGND VPWR sky130_fd_sc_hd__tapvpwrvgnd_1
XFILLER_0_58_231 VGND VGND VPWR VPWR sky130_fd_sc_hd__decap_4
XFILLER_0_25_85 VGND VGND VPWR VPWR sky130_fd_sc_hd__fill_1
X_7691_ _3113_ net298 _3799_ VGND VGND VPWR VPWR _3806_ sky130_fd_sc_hd__mux2_1
XFILLER_0_86_584 VGND VGND VPWR VPWR sky130_fd_sc_hd__decap_4
X_6711_ _2972_ _2975_ _2973_ _2974_ VGND VGND VPWR VPWR _3268_ sky130_fd_sc_hd__and4b_2
XFILLER_0_19_629 VGND VGND VPWR VPWR sky130_fd_sc_hd__decap_4
X_9430_ clknet_leaf_52_CLK _0663_ VGND VGND VPWR VPWR RF.reg_arr\[17\]\[24\] sky130_fd_sc_hd__dfxtp_1
XFILLER_0_73_223 VGND VGND VPWR VPWR sky130_fd_sc_hd__fill_1
X_6642_ _2972_ _2975_ _2973_ _3057_ VGND VGND VPWR VPWR _3231_ sky130_fd_sc_hd__nand4b_4
XFILLER_0_46_459 VGND VGND VPWR VPWR sky130_fd_sc_hd__decap_8
XFILLER_0_27_662 VGND VGND VPWR VPWR sky130_fd_sc_hd__decap_8
X_9361_ clknet_leaf_4_CLK _0594_ VGND VGND VPWR VPWR RF.reg_arr\[18\]\[19\] sky130_fd_sc_hd__dfxtp_1
X_6573_ _3194_ VGND VGND VPWR VPWR _0894_ sky130_fd_sc_hd__clkbuf_1
X_8312_ net538 _3383_ _4101_ VGND VGND VPWR VPWR _4135_ sky130_fd_sc_hd__mux2_1
XFILLER_0_42_610 VGND VGND VPWR VPWR sky130_fd_sc_hd__decap_8
X_5524_ _2000_ _1115_ _2045_ VGND VGND VPWR VPWR _2313_ sky130_fd_sc_hd__and3_1
X_9292_ clknet_leaf_100_CLK _0525_ VGND VGND VPWR VPWR RF.reg_arr\[25\]\[14\] sky130_fd_sc_hd__dfxtp_1
XFILLER_0_26_194 VGND VGND VPWR VPWR sky130_fd_sc_hd__fill_2
XFILLER_0_112_531 VGND VGND VPWR VPWR sky130_fd_sc_hd__fill_1
X_8243_ _4098_ VGND VGND VPWR VPWR _0636_ sky130_fd_sc_hd__clkbuf_1
X_5455_ _2240_ _2243_ _1635_ VGND VGND VPWR VPWR _2244_ sky130_fd_sc_hd__mux2_1
XFILLER_0_41_164 VGND VGND VPWR VPWR sky130_fd_sc_hd__decap_4
XFILLER_0_112_575 VPWR VGND VPWR VGND sky130_ef_sc_hd__decap_12
X_8174_ net249 _3381_ _4052_ VGND VGND VPWR VPWR _4062_ sky130_fd_sc_hd__mux2_1
X_4406_ _1193_ _1194_ _1128_ VGND VGND VPWR VPWR _1195_ sky130_fd_sc_hd__mux2_1
X_7125_ _3504_ VGND VGND VPWR VPWR _0112_ sky130_fd_sc_hd__clkbuf_1
X_5386_ _1642_ _2166_ _2170_ _2174_ VGND VGND VPWR VPWR _2175_ sky130_fd_sc_hd__a2bb2o_4
X_4337_ _1039_ VGND VGND VPWR VPWR _1126_ sky130_fd_sc_hd__clkbuf_8
X_7056_ net566 _3424_ _3460_ VGND VGND VPWR VPWR _3468_ sky130_fd_sc_hd__mux2_1
X_4268_ RF.reg_arr\[8\]\[5\] RF.reg_arr\[9\]\[5\] RF.reg_arr\[10\]\[5\] RF.reg_arr\[11\]\[5\]
+ _1044_ _1046_ VGND VGND VPWR VPWR _1057_ sky130_fd_sc_hd__mux4_1
X_6007_ _2747_ _2776_ _2366_ VGND VGND VPWR VPWR _2777_ sky130_fd_sc_hd__mux2_1
XFILLER_0_96_326 VGND VGND VPWR VPWR sky130_fd_sc_hd__fill_1
XFILLER_0_82_80 VGND VGND VPWR VPWR sky130_fd_sc_hd__fill_1
XFILLER_0_77_551 VGND VGND VPWR VPWR sky130_fd_sc_hd__decap_8
XFILLER_0_77_540 VGND VGND VPWR VPWR sky130_fd_sc_hd__decap_4
X_7958_ _3046_ net878 _3944_ VGND VGND VPWR VPWR _3948_ sky130_fd_sc_hd__mux2_1
X_6909_ net519 _3375_ _3366_ VGND VGND VPWR VPWR _3376_ sky130_fd_sc_hd__mux2_1
XFILLER_0_77_584 VGND VGND VPWR VPWR sky130_fd_sc_hd__decap_8
XFILLER_0_77_573 VGND VGND VPWR VPWR sky130_fd_sc_hd__decap_8
X_7889_ _3911_ VGND VGND VPWR VPWR _0469_ sky130_fd_sc_hd__clkbuf_1
XTAP_TAPCELL_ROW_25_546 VGND VPWR sky130_fd_sc_hd__tapvpwrvgnd_1
XTAP_TAPCELL_ROW_25_557 VGND VPWR sky130_fd_sc_hd__tapvpwrvgnd_1
XTAP_TAPCELL_ROW_53_888 VGND VPWR sky130_fd_sc_hd__tapvpwrvgnd_1
XFILLER_0_33_665 VGND VGND VPWR VPWR sky130_fd_sc_hd__decap_6
XFILLER_0_32_153 VGND VGND VPWR VPWR sky130_fd_sc_hd__fill_1
XFILLER_0_103_586 VGND VGND VPWR VPWR sky130_fd_sc_hd__fill_2
Xhold290 RF.reg_arr\[17\]\[7\] VGND VGND VPWR VPWR net372 sky130_fd_sc_hd__dlygate4sd3_1
XFILLER_0_46_29 VGND VGND VPWR VPWR sky130_fd_sc_hd__fill_1
XTAP_TAPCELL_ROW_88_1308 VGND VPWR sky130_fd_sc_hd__tapvpwrvgnd_1
XFILLER_0_87_315 VGND VGND VPWR VPWR sky130_fd_sc_hd__fill_1
XFILLER_0_83_543 VGND VGND VPWR VPWR sky130_fd_sc_hd__fill_2
XTAP_TAPCELL_ROW_99_1437 VGND VPWR sky130_fd_sc_hd__tapvpwrvgnd_1
XFILLER_0_113_317 VGND VGND VPWR VPWR sky130_fd_sc_hd__fill_1
XFILLER_0_23_131 VGND VGND VPWR VPWR sky130_fd_sc_hd__fill_1
XFILLER_0_24_654 VGND VGND VPWR VPWR sky130_fd_sc_hd__fill_2
X_5240_ _2028_ VGND VGND VPWR VPWR _2029_ sky130_fd_sc_hd__clkbuf_4
XPHY_EDGE_ROW_18_Right_18 VGND VGND VPWR VPWR sky130_fd_sc_hd__decap_3
X_5171_ RF.reg_arr\[4\]\[19\] RF.reg_arr\[5\]\[19\] RF.reg_arr\[6\]\[19\] RF.reg_arr\[7\]\[19\]
+ _1857_ _1860_ VGND VGND VPWR VPWR _1960_ sky130_fd_sc_hd__mux4_1
X_8930_ clknet_leaf_77_CLK _0163_ VGND VGND VPWR VPWR RF.reg_arr\[29\]\[4\] sky130_fd_sc_hd__dfxtp_1
Xinput3 A1[2] VGND VGND VPWR VPWR net3 sky130_fd_sc_hd__buf_4
XTAP_TAPCELL_ROW_108_1544 VGND VPWR sky130_fd_sc_hd__tapvpwrvgnd_1
X_8861_ clknet_leaf_19_CLK _0094_ VGND VGND VPWR VPWR RF.reg_arr\[19\]\[31\] sky130_fd_sc_hd__dfxtp_1
X_8792_ clknet_leaf_49_CLK _0025_ VGND VGND VPWR VPWR RF.reg_arr\[5\]\[26\] sky130_fd_sc_hd__dfxtp_1
X_7812_ _3098_ net933 _3860_ VGND VGND VPWR VPWR _3870_ sky130_fd_sc_hd__mux2_1
X_4955_ _1740_ _1741_ _1742_ _1743_ _1614_ _1636_ VGND VGND VPWR VPWR _1744_ sky130_fd_sc_hd__mux4_1
XPHY_EDGE_ROW_27_Right_27 VGND VGND VPWR VPWR sky130_fd_sc_hd__decap_3
X_7743_ _3833_ VGND VGND VPWR VPWR _0401_ sky130_fd_sc_hd__clkbuf_1
XTAP_TAPCELL_ROW_22_516 VGND VPWR sky130_fd_sc_hd__tapvpwrvgnd_1
XFILLER_0_52_83 VGND VGND VPWR VPWR sky130_fd_sc_hd__fill_1
X_7674_ _3096_ net907 _3788_ VGND VGND VPWR VPWR _3797_ sky130_fd_sc_hd__mux2_1
X_4886_ _1674_ VGND VGND VPWR VPWR _1675_ sky130_fd_sc_hd__clkbuf_8
XTAP_TAPCELL_ROW_50_847 VGND VPWR sky130_fd_sc_hd__tapvpwrvgnd_1
X_6625_ _3222_ VGND VGND VPWR VPWR _0918_ sky130_fd_sc_hd__clkbuf_1
X_9413_ clknet_leaf_84_CLK _0646_ VGND VGND VPWR VPWR RF.reg_arr\[17\]\[7\] sky130_fd_sc_hd__dfxtp_1
XFILLER_0_116_188 VGND VGND VPWR VPWR sky130_fd_sc_hd__decap_8
X_6556_ net165 _3046_ _3182_ VGND VGND VPWR VPWR _3186_ sky130_fd_sc_hd__mux2_1
X_9344_ clknet_leaf_55_CLK _0577_ VGND VGND VPWR VPWR RF.reg_arr\[18\]\[2\] sky130_fd_sc_hd__dfxtp_1
XFILLER_0_15_643 VGND VGND VPWR VPWR sky130_fd_sc_hd__fill_2
X_9275_ clknet_leaf_34_CLK _0508_ VGND VGND VPWR VPWR RF.reg_arr\[21\]\[29\] sky130_fd_sc_hd__dfxtp_1
XFILLER_0_104_339 VGND VGND VPWR VPWR sky130_fd_sc_hd__fill_2
X_5507_ _2294_ _2295_ _1609_ VGND VGND VPWR VPWR _2296_ sky130_fd_sc_hd__mux2_1
X_8226_ _3042_ net978 _4088_ VGND VGND VPWR VPWR _4090_ sky130_fd_sc_hd__mux2_1
X_6487_ _3148_ VGND VGND VPWR VPWR _0854_ sky130_fd_sc_hd__clkbuf_1
XFILLER_0_14_197 VPWR VGND VPWR VGND sky130_ef_sc_hd__decap_12
X_5438_ RF.reg_arr\[8\]\[5\] RF.reg_arr\[9\]\[5\] RF.reg_arr\[10\]\[5\] RF.reg_arr\[11\]\[5\]
+ _1623_ _1596_ VGND VGND VPWR VPWR _2227_ sky130_fd_sc_hd__mux4_1
XPHY_EDGE_ROW_36_Right_36 VGND VGND VPWR VPWR sky130_fd_sc_hd__decap_3
XFILLER_0_100_556 VGND VGND VPWR VPWR sky130_fd_sc_hd__fill_1
X_5369_ _1895_ _2157_ _1756_ VGND VGND VPWR VPWR _2158_ sky130_fd_sc_hd__o21ai_1
X_8157_ _4053_ VGND VGND VPWR VPWR _0595_ sky130_fd_sc_hd__clkbuf_1
X_8088_ _3039_ net862 _4016_ VGND VGND VPWR VPWR _4017_ sky130_fd_sc_hd__mux2_1
X_7108_ _3495_ VGND VGND VPWR VPWR _0104_ sky130_fd_sc_hd__clkbuf_1
X_7039_ net353 _3407_ _3449_ VGND VGND VPWR VPWR _3459_ sky130_fd_sc_hd__mux2_1
XFILLER_0_97_602 VPWR VGND VPWR VGND sky130_ef_sc_hd__decap_12
XTAP_TAPCELL_ROW_58_947 VGND VPWR sky130_fd_sc_hd__tapvpwrvgnd_1
XTAP_TAPCELL_ROW_2_274 VGND VPWR sky130_fd_sc_hd__tapvpwrvgnd_1
XPHY_EDGE_ROW_45_Right_45 VGND VGND VPWR VPWR sky130_fd_sc_hd__decap_3
XTAP_TAPCELL_ROW_83_1249 VGND VPWR sky130_fd_sc_hd__tapvpwrvgnd_1
XFILLER_0_65_576 VGND VGND VPWR VPWR sky130_fd_sc_hd__fill_1
XFILLER_0_108_645 VGND VGND VPWR VPWR sky130_fd_sc_hd__decap_6
XFILLER_0_52_248 VGND VGND VPWR VPWR sky130_fd_sc_hd__decap_4
XFILLER_0_110_309 VGND VGND VPWR VPWR sky130_fd_sc_hd__decap_6
XPHY_EDGE_ROW_54_Right_54 VGND VGND VPWR VPWR sky130_fd_sc_hd__decap_3
XTAP_TAPCELL_ROW_94_1378 VGND VPWR sky130_fd_sc_hd__tapvpwrvgnd_1
XPHY_EDGE_ROW_63_Right_63 VGND VGND VPWR VPWR sky130_fd_sc_hd__decap_3
XFILLER_0_88_657 VGND VGND VPWR VPWR sky130_fd_sc_hd__decap_3
XTAP_TAPCELL_ROW_103_1485 VGND VPWR sky130_fd_sc_hd__tapvpwrvgnd_1
XFILLER_0_83_351 VGND VGND VPWR VPWR sky130_fd_sc_hd__fill_2
XFILLER_0_7_117 VGND VGND VPWR VPWR sky130_fd_sc_hd__fill_1
X_4740_ RF.reg_arr\[4\]\[14\] RF.reg_arr\[5\]\[14\] RF.reg_arr\[6\]\[14\] RF.reg_arr\[7\]\[14\]
+ _1129_ _1130_ VGND VGND VPWR VPWR _1529_ sky130_fd_sc_hd__mux4_1
X_4671_ RF.reg_arr\[12\]\[31\] RF.reg_arr\[13\]\[31\] RF.reg_arr\[14\]\[31\] RF.reg_arr\[15\]\[31\]
+ _1274_ _1276_ VGND VGND VPWR VPWR _1460_ sky130_fd_sc_hd__mux4_1
X_6410_ net28 VGND VGND VPWR VPWR _3105_ sky130_fd_sc_hd__clkbuf_2
XFILLER_0_22_97 VGND VGND VPWR VPWR sky130_fd_sc_hd__fill_2
X_7390_ _3645_ VGND VGND VPWR VPWR _0236_ sky130_fd_sc_hd__clkbuf_1
XFILLER_0_114_637 VGND VGND VPWR VPWR sky130_fd_sc_hd__decap_6
XPHY_EDGE_ROW_72_Right_72 VGND VGND VPWR VPWR sky130_fd_sc_hd__decap_3
X_6341_ _2975_ _2973_ _3057_ _2972_ VGND VGND VPWR VPWR _3058_ sky130_fd_sc_hd__nand4b_4
XFILLER_0_113_169 VGND VGND VPWR VPWR sky130_fd_sc_hd__decap_3
X_9060_ clknet_leaf_82_CLK _0293_ VGND VGND VPWR VPWR RF.reg_arr\[28\]\[6\] sky130_fd_sc_hd__dfxtp_1
XFILLER_0_3_389 VGND VGND VPWR VPWR sky130_fd_sc_hd__decap_3
X_6272_ _3013_ VGND VGND VPWR VPWR _0774_ sky130_fd_sc_hd__clkbuf_1
X_8011_ _3031_ net980 _3969_ VGND VGND VPWR VPWR _3976_ sky130_fd_sc_hd__mux2_1
X_5223_ _1055_ _2011_ VGND VGND VPWR VPWR _2012_ sky130_fd_sc_hd__nand2_1
XFILLER_0_20_690 VGND VGND VPWR VPWR sky130_fd_sc_hd__fill_2
X_5154_ _1940_ _1941_ _1942_ VGND VGND VPWR VPWR _1943_ sky130_fd_sc_hd__mux2_1
XPHY_EDGE_ROW_16_Left_133 VGND VGND VPWR VPWR sky130_fd_sc_hd__decap_3
XPHY_EDGE_ROW_81_Right_81 VGND VGND VPWR VPWR sky130_fd_sc_hd__decap_3
X_5085_ RF.reg_arr\[20\]\[23\] RF.reg_arr\[21\]\[23\] RF.reg_arr\[22\]\[23\] RF.reg_arr\[23\]\[23\]
+ _1676_ _1682_ VGND VGND VPWR VPWR _1874_ sky130_fd_sc_hd__mux4_1
XFILLER_0_2_41 VPWR VGND VPWR VGND sky130_ef_sc_hd__decap_12
XTAP_TAPCELL_ROW_55_906 VGND VPWR sky130_fd_sc_hd__tapvpwrvgnd_1
XTAP_TAPCELL_ROW_55_917 VGND VPWR sky130_fd_sc_hd__tapvpwrvgnd_1
X_8913_ clknet_leaf_8_CLK _0146_ VGND VGND VPWR VPWR RF.reg_arr\[7\]\[19\] sky130_fd_sc_hd__dfxtp_1
X_8844_ clknet_leaf_101_CLK _0077_ VGND VGND VPWR VPWR RF.reg_arr\[19\]\[14\] sky130_fd_sc_hd__dfxtp_1
XFILLER_0_2_85 VPWR VGND VPWR VGND sky130_ef_sc_hd__decap_12
XTAP_TAPCELL_ROW_69_1082 VGND VPWR sky130_fd_sc_hd__tapvpwrvgnd_1
X_5987_ _2521_ _2757_ VGND VGND VPWR VPWR _2758_ sky130_fd_sc_hd__nor2_1
XFILLER_0_93_137 VGND VGND VPWR VPWR sky130_fd_sc_hd__decap_4
XTAP_TAPCELL_ROW_35_674 VGND VPWR sky130_fd_sc_hd__tapvpwrvgnd_1
X_8775_ clknet_leaf_66_CLK _0008_ VGND VGND VPWR VPWR RF.reg_arr\[5\]\[9\] sky130_fd_sc_hd__dfxtp_1
X_4938_ _1039_ _1726_ VGND VGND VPWR VPWR _1727_ sky130_fd_sc_hd__nand2_1
X_7726_ net374 _3409_ _3824_ VGND VGND VPWR VPWR _3825_ sky130_fd_sc_hd__mux2_1
X_4869_ _1619_ _1657_ VGND VGND VPWR VPWR _1658_ sky130_fd_sc_hd__nor2_1
XPHY_EDGE_ROW_25_Left_142 VGND VGND VPWR VPWR sky130_fd_sc_hd__decap_3
X_7657_ _3776_ VGND VGND VPWR VPWR _3788_ sky130_fd_sc_hd__clkbuf_8
XFILLER_0_105_615 VGND VGND VPWR VPWR sky130_fd_sc_hd__fill_1
XPHY_EDGE_ROW_90_Right_90 VGND VGND VPWR VPWR sky130_fd_sc_hd__decap_3
X_6608_ _3213_ VGND VGND VPWR VPWR _0910_ sky130_fd_sc_hd__clkbuf_1
XFILLER_0_104_125 VGND VGND VPWR VPWR sky130_fd_sc_hd__decap_4
X_7588_ _3751_ VGND VGND VPWR VPWR _0328_ sky130_fd_sc_hd__clkbuf_1
X_9327_ clknet_leaf_106_CLK _0560_ VGND VGND VPWR VPWR RF.reg_arr\[20\]\[17\] sky130_fd_sc_hd__dfxtp_1
X_6539_ net631 _3029_ _3171_ VGND VGND VPWR VPWR _3177_ sky130_fd_sc_hd__mux2_1
XFILLER_0_30_421 VGND VGND VPWR VPWR sky130_fd_sc_hd__decap_6
XFILLER_0_113_670 VGND VGND VPWR VPWR sky130_fd_sc_hd__fill_2
X_9258_ clknet_leaf_98_CLK _0491_ VGND VGND VPWR VPWR RF.reg_arr\[21\]\[12\] sky130_fd_sc_hd__dfxtp_1
X_9189_ clknet_leaf_83_CLK _0422_ VGND VGND VPWR VPWR RF.reg_arr\[24\]\[7\] sky130_fd_sc_hd__dfxtp_1
X_8209_ _3025_ net858 _4077_ VGND VGND VPWR VPWR _4081_ sky130_fd_sc_hd__mux2_1
XTAP_TAPCELL_ROW_7_333 VGND VPWR sky130_fd_sc_hd__tapvpwrvgnd_1
XPHY_EDGE_ROW_34_Left_151 VGND VGND VPWR VPWR sky130_fd_sc_hd__decap_3
XFILLER_0_69_123 VGND VGND VPWR VPWR sky130_fd_sc_hd__fill_2
XFILLER_0_84_137 VGND VGND VPWR VPWR sky130_fd_sc_hd__decap_3
XPHY_EDGE_ROW_43_Left_160 VGND VGND VPWR VPWR sky130_fd_sc_hd__decap_3
XFILLER_0_108_431 VGND VGND VPWR VPWR sky130_fd_sc_hd__decap_6
XFILLER_0_38_587 VGND VGND VPWR VPWR sky130_fd_sc_hd__fill_1
XFILLER_0_108_486 VGND VGND VPWR VPWR sky130_fd_sc_hd__decap_4
XTAP_TAPCELL_ROW_96_1407 VGND VPWR sky130_fd_sc_hd__tapvpwrvgnd_1
XFILLER_0_0_337 VGND VGND VPWR VPWR sky130_fd_sc_hd__fill_2
XTAP_TAPCELL_ROW_105_1514 VGND VPWR sky130_fd_sc_hd__tapvpwrvgnd_1
X_5910_ _2529_ _2588_ _2684_ VGND VGND VPWR VPWR _2685_ sky130_fd_sc_hd__o21ai_1
X_6890_ _3364_ VGND VGND VPWR VPWR _0017_ sky130_fd_sc_hd__clkbuf_1
X_5841_ _2436_ _2583_ _2619_ _2521_ _2443_ VGND VGND VPWR VPWR _2620_ sky130_fd_sc_hd__o221a_1
XFILLER_0_75_104 VGND VGND VPWR VPWR sky130_fd_sc_hd__fill_2
XFILLER_0_29_521 VPWR VGND VPWR VGND sky130_ef_sc_hd__decap_12
X_5772_ _2271_ _2537_ VGND VGND VPWR VPWR _2554_ sky130_fd_sc_hd__nor2_1
X_8560_ clknet_leaf_0_CLK _0817_ VGND VGND VPWR VPWR RF.reg_arr\[23\]\[18\] sky130_fd_sc_hd__dfxtp_1
XTAP_TAPCELL_ROW_32_633 VGND VPWR sky130_fd_sc_hd__tapvpwrvgnd_1
XFILLER_0_84_671 VGND VGND VPWR VPWR sky130_fd_sc_hd__fill_1
XTAP_TAPCELL_ROW_60_975 VGND VPWR sky130_fd_sc_hd__tapvpwrvgnd_1
X_7511_ net817 _3399_ _3705_ VGND VGND VPWR VPWR _3711_ sky130_fd_sc_hd__mux2_1
X_8491_ _4229_ VGND VGND VPWR VPWR _0753_ sky130_fd_sc_hd__clkbuf_1
X_4723_ RF.reg_arr\[4\]\[13\] RF.reg_arr\[5\]\[13\] RF.reg_arr\[6\]\[13\] RF.reg_arr\[7\]\[13\]
+ _1342_ _1343_ VGND VGND VPWR VPWR _1512_ sky130_fd_sc_hd__mux4_1
XFILLER_0_56_362 VGND VGND VPWR VPWR sky130_fd_sc_hd__fill_2
X_7442_ _3673_ VGND VGND VPWR VPWR _0260_ sky130_fd_sc_hd__clkbuf_1
X_4654_ RF.reg_arr\[12\]\[26\] RF.reg_arr\[13\]\[26\] RF.reg_arr\[14\]\[26\] RF.reg_arr\[15\]\[26\]
+ _1327_ _1328_ VGND VGND VPWR VPWR _1443_ sky130_fd_sc_hd__mux4_1
XTAP_TAPCELL_ROW_12_390 VGND VPWR sky130_fd_sc_hd__tapvpwrvgnd_1
Xhold801 RF.reg_arr\[31\]\[24\] VGND VGND VPWR VPWR net883 sky130_fd_sc_hd__dlygate4sd3_1
XTAP_TAPCELL_ROW_116_1643 VGND VPWR sky130_fd_sc_hd__tapvpwrvgnd_1
Xhold812 RF.reg_arr\[16\]\[20\] VGND VGND VPWR VPWR net894 sky130_fd_sc_hd__dlygate4sd3_1
X_4585_ _1370_ _1373_ _1110_ VGND VGND VPWR VPWR _1374_ sky130_fd_sc_hd__mux2_1
X_7373_ _3636_ VGND VGND VPWR VPWR _0228_ sky130_fd_sc_hd__clkbuf_1
XTAP_TAPCELL_ROW_116_1654 VGND VPWR sky130_fd_sc_hd__tapvpwrvgnd_1
X_6324_ _3048_ VGND VGND VPWR VPWR _0791_ sky130_fd_sc_hd__clkbuf_1
X_9112_ clknet_leaf_50_CLK _0345_ VGND VGND VPWR VPWR RF.reg_arr\[2\]\[26\] sky130_fd_sc_hd__dfxtp_1
Xhold834 RF.reg_arr\[24\]\[17\] VGND VGND VPWR VPWR net916 sky130_fd_sc_hd__dlygate4sd3_1
Xhold845 RF.reg_arr\[17\]\[4\] VGND VGND VPWR VPWR net927 sky130_fd_sc_hd__dlygate4sd3_1
Xhold823 RF.reg_arr\[23\]\[16\] VGND VGND VPWR VPWR net905 sky130_fd_sc_hd__dlygate4sd3_1
Xhold878 RF.reg_arr\[26\]\[29\] VGND VGND VPWR VPWR net960 sky130_fd_sc_hd__dlygate4sd3_1
X_9043_ clknet_leaf_46_CLK _0276_ VGND VGND VPWR VPWR RF.reg_arr\[26\]\[21\] sky130_fd_sc_hd__dfxtp_1
X_6255_ net36 VGND VGND VPWR VPWR _3002_ sky130_fd_sc_hd__buf_2
XFILLER_0_12_498 VGND VGND VPWR VPWR sky130_fd_sc_hd__decap_3
Xhold867 RF.reg_arr\[20\]\[12\] VGND VGND VPWR VPWR net949 sky130_fd_sc_hd__dlygate4sd3_1
Xhold856 RF.reg_arr\[26\]\[13\] VGND VGND VPWR VPWR net938 sky130_fd_sc_hd__dlygate4sd3_1
Xhold889 RF.reg_arr\[12\]\[2\] VGND VGND VPWR VPWR net971 sky130_fd_sc_hd__dlygate4sd3_1
XFILLER_0_110_673 VPWR VGND VPWR VGND sky130_ef_sc_hd__decap_12
X_5206_ _1993_ _1994_ _1604_ VGND VGND VPWR VPWR _1995_ sky130_fd_sc_hd__mux2_1
X_6186_ _2485_ _2808_ _2944_ _2945_ VGND VGND VPWR VPWR _2946_ sky130_fd_sc_hd__a211o_1
XTAP_TAPCELL_ROW_4_303 VGND VPWR sky130_fd_sc_hd__tapvpwrvgnd_1
X_5137_ _1644_ _1917_ _1925_ VGND VGND VPWR VPWR _1926_ sky130_fd_sc_hd__o21ai_4
X_5068_ _1623_ VGND VGND VPWR VPWR _1857_ sky130_fd_sc_hd__clkbuf_8
XFILLER_0_79_432 VGND VGND VPWR VPWR sky130_fd_sc_hd__decap_6
X_8827_ clknet_leaf_31_CLK _0060_ VGND VGND VPWR VPWR RF.reg_arr\[4\]\[29\] sky130_fd_sc_hd__dfxtp_1
XTAP_TAPCELL_ROW_80_1208 VGND VPWR sky130_fd_sc_hd__tapvpwrvgnd_1
XPHY_EDGE_ROW_0_Right_0 VGND VGND VPWR VPWR sky130_fd_sc_hd__decap_3
XFILLER_0_39_318 VGND VGND VPWR VPWR sky130_fd_sc_hd__fill_2
X_8758_ clknet_leaf_50_CLK _1015_ VGND VGND VPWR VPWR RF.reg_arr\[6\]\[24\] sky130_fd_sc_hd__dfxtp_1
XFILLER_0_94_446 VPWR VGND VPWR VGND sky130_ef_sc_hd__decap_12
XFILLER_0_47_340 VGND VGND VPWR VPWR sky130_fd_sc_hd__decap_4
XFILLER_0_75_660 VGND VGND VPWR VPWR sky130_fd_sc_hd__fill_1
X_7709_ net203 _3393_ _3813_ VGND VGND VPWR VPWR _3816_ sky130_fd_sc_hd__mux2_1
XFILLER_0_90_641 VGND VGND VPWR VPWR sky130_fd_sc_hd__decap_3
XFILLER_0_74_181 VGND VGND VPWR VPWR sky130_fd_sc_hd__decap_6
X_8689_ clknet_leaf_7_CLK _0946_ VGND VGND VPWR VPWR RF.reg_arr\[15\]\[19\] sky130_fd_sc_hd__dfxtp_1
XFILLER_0_62_376 VGND VGND VPWR VPWR sky130_fd_sc_hd__fill_2
XFILLER_0_50_527 VGND VGND VPWR VPWR sky130_fd_sc_hd__decap_4
XFILLER_0_101_673 VGND VGND VPWR VPWR sky130_fd_sc_hd__decap_4
XTAP_TAPCELL_ROW_91_1348 VGND VPWR sky130_fd_sc_hd__tapvpwrvgnd_1
XFILLER_0_100_194 VGND VGND VPWR VPWR sky130_fd_sc_hd__fill_2
XFILLER_0_89_207 VGND VGND VPWR VPWR sky130_fd_sc_hd__fill_1
XFILLER_0_38_340 VGND VGND VPWR VPWR sky130_fd_sc_hd__fill_1
XFILLER_0_66_682 VGND VGND VPWR VPWR sky130_fd_sc_hd__fill_2
XFILLER_0_38_362 VGND VGND VPWR VPWR sky130_fd_sc_hd__fill_2
XTAP_TAPCELL_ROW_100_1455 VGND VPWR sky130_fd_sc_hd__tapvpwrvgnd_1
XFILLER_0_5_429 VPWR VGND VPWR VGND sky130_ef_sc_hd__decap_12
XFILLER_0_13_207 VGND VGND VPWR VPWR sky130_fd_sc_hd__decap_3
XFILLER_0_41_516 VGND VGND VPWR VPWR sky130_fd_sc_hd__fill_1
Xhold108 RF.reg_arr\[1\]\[27\] VGND VGND VPWR VPWR net190 sky130_fd_sc_hd__dlygate4sd3_1
XFILLER_0_13_218 VGND VGND VPWR VPWR sky130_fd_sc_hd__decap_6
XFILLER_0_111_415 VPWR VGND VPWR VGND sky130_ef_sc_hd__decap_12
Xhold119 RF.reg_arr\[1\]\[31\] VGND VGND VPWR VPWR net201 sky130_fd_sc_hd__dlygate4sd3_1
XFILLER_0_1_613 VGND VGND VPWR VPWR sky130_fd_sc_hd__decap_3
X_4370_ _1141_ VGND VGND VPWR VPWR _1159_ sky130_fd_sc_hd__clkbuf_8
X_6040_ _2748_ _2807_ _2003_ VGND VGND VPWR VPWR _2808_ sky130_fd_sc_hd__mux2_1
XTAP_TAPCELL_ROW_111_1584 VGND VPWR sky130_fd_sc_hd__tapvpwrvgnd_1
XFILLER_0_28_63 VPWR VGND VPWR VGND sky130_ef_sc_hd__decap_12
XFILLER_0_28_96 VGND VGND VPWR VPWR sky130_fd_sc_hd__decap_6
X_7991_ _3965_ VGND VGND VPWR VPWR _0517_ sky130_fd_sc_hd__clkbuf_1
X_6942_ _3398_ VGND VGND VPWR VPWR _0035_ sky130_fd_sc_hd__clkbuf_1
XFILLER_0_76_435 VGND VGND VPWR VPWR sky130_fd_sc_hd__fill_1
XFILLER_0_76_424 VGND VGND VPWR VPWR sky130_fd_sc_hd__decap_8
XTAP_TAPCELL_ROW_66_1041 VGND VPWR sky130_fd_sc_hd__tapvpwrvgnd_1
X_6873_ net322 _3018_ _3355_ VGND VGND VPWR VPWR _3356_ sky130_fd_sc_hd__mux2_1
X_5824_ _2401_ _2588_ _1024_ VGND VGND VPWR VPWR _2604_ sky130_fd_sc_hd__o21a_1
XFILLER_0_76_468 VGND VGND VPWR VPWR sky130_fd_sc_hd__decap_8
X_8612_ clknet_leaf_81_CLK _0869_ VGND VGND VPWR VPWR RF.reg_arr\[16\]\[6\] sky130_fd_sc_hd__dfxtp_1
XTAP_TAPCELL_ROW_17_460 VGND VPWR sky130_fd_sc_hd__tapvpwrvgnd_1
XTAP_TAPCELL_ROW_45_791 VGND VPWR sky130_fd_sc_hd__tapvpwrvgnd_1
XFILLER_0_29_362 VPWR VGND VPWR VGND sky130_ef_sc_hd__decap_12
X_5755_ _2271_ _2537_ VGND VGND VPWR VPWR _2538_ sky130_fd_sc_hd__nand2_1
X_8543_ clknet_leaf_56_CLK _0800_ VGND VGND VPWR VPWR RF.reg_arr\[23\]\[1\] sky130_fd_sc_hd__dfxtp_1
XFILLER_0_56_181 VGND VGND VPWR VPWR sky130_fd_sc_hd__decap_4
XFILLER_0_97_3 VGND VGND VPWR VPWR sky130_fd_sc_hd__decap_8
X_5686_ _2411_ _2409_ VGND VGND VPWR VPWR _2472_ sky130_fd_sc_hd__nand2_1
XFILLER_0_60_94 VGND VGND VPWR VPWR sky130_fd_sc_hd__fill_2
X_4706_ _1121_ _1494_ VGND VGND VPWR VPWR _1495_ sky130_fd_sc_hd__or2_1
XFILLER_0_32_505 VGND VGND VPWR VPWR sky130_fd_sc_hd__fill_1
X_8474_ _4220_ VGND VGND VPWR VPWR _0745_ sky130_fd_sc_hd__clkbuf_1
X_4637_ _1424_ _1425_ _1296_ VGND VGND VPWR VPWR _1426_ sky130_fd_sc_hd__mux2_1
X_7425_ _3663_ VGND VGND VPWR VPWR _0253_ sky130_fd_sc_hd__clkbuf_1
XFILLER_0_4_473 VGND VGND VPWR VPWR sky130_fd_sc_hd__decap_3
Xhold620 RF.reg_arr\[29\]\[19\] VGND VGND VPWR VPWR net702 sky130_fd_sc_hd__dlygate4sd3_1
Xhold631 RF.reg_arr\[4\]\[28\] VGND VGND VPWR VPWR net713 sky130_fd_sc_hd__dlygate4sd3_1
XTAP_TAPCELL_ROW_77_1181 VGND VPWR sky130_fd_sc_hd__tapvpwrvgnd_1
XTAP_TAPCELL_ROW_77_1170 VGND VPWR sky130_fd_sc_hd__tapvpwrvgnd_1
X_7356_ _3121_ net768 _3593_ VGND VGND VPWR VPWR _3627_ sky130_fd_sc_hd__mux2_1
Xhold653 RF.reg_arr\[24\]\[1\] VGND VGND VPWR VPWR net735 sky130_fd_sc_hd__dlygate4sd3_1
X_4568_ net1126 VGND VGND VPWR VPWR _1357_ sky130_fd_sc_hd__buf_4
Xhold642 RF.reg_arr\[2\]\[13\] VGND VGND VPWR VPWR net724 sky130_fd_sc_hd__dlygate4sd3_1
X_7287_ _3590_ VGND VGND VPWR VPWR _0188_ sky130_fd_sc_hd__clkbuf_1
X_4499_ _1284_ _1287_ VGND VGND VPWR VPWR _1288_ sky130_fd_sc_hd__nor2_1
Xhold675 RF.reg_arr\[28\]\[27\] VGND VGND VPWR VPWR net757 sky130_fd_sc_hd__dlygate4sd3_1
Xhold686 RF.reg_arr\[31\]\[30\] VGND VGND VPWR VPWR net768 sky130_fd_sc_hd__dlygate4sd3_1
Xhold697 RF.reg_arr\[30\]\[20\] VGND VGND VPWR VPWR net779 sky130_fd_sc_hd__dlygate4sd3_1
XFILLER_0_12_295 VGND VGND VPWR VPWR sky130_fd_sc_hd__decap_4
Xhold664 RF.reg_arr\[15\]\[8\] VGND VGND VPWR VPWR net746 sky130_fd_sc_hd__dlygate4sd3_1
X_6307_ net24 VGND VGND VPWR VPWR _3037_ sky130_fd_sc_hd__buf_2
X_6238_ _2989_ VGND VGND VPWR VPWR _0764_ sky130_fd_sc_hd__clkbuf_1
X_9026_ clknet_leaf_77_CLK _0259_ VGND VGND VPWR VPWR RF.reg_arr\[26\]\[4\] sky130_fd_sc_hd__dfxtp_1
X_6169_ _2001_ _2883_ _2929_ VGND VGND VPWR VPWR _2930_ sky130_fd_sc_hd__o21ba_1
XFILLER_0_99_505 VGND VGND VPWR VPWR sky130_fd_sc_hd__fill_1
XFILLER_0_99_549 VGND VGND VPWR VPWR sky130_fd_sc_hd__decap_4
XFILLER_0_82_416 VGND VGND VPWR VPWR sky130_fd_sc_hd__fill_1
XFILLER_0_67_479 VGND VGND VPWR VPWR sky130_fd_sc_hd__decap_3
XFILLER_0_50_368 VGND VGND VPWR VPWR sky130_fd_sc_hd__decap_4
XFILLER_0_105_297 VGND VGND VPWR VPWR sky130_fd_sc_hd__fill_1
XFILLER_0_105_23 VGND VGND VPWR VPWR sky130_fd_sc_hd__fill_2
XFILLER_0_98_593 VGND VGND VPWR VPWR sky130_fd_sc_hd__fill_1
XFILLER_0_58_424 VGND VGND VPWR VPWR sky130_fd_sc_hd__decap_3
XFILLER_0_116_529 VGND VGND VPWR VPWR sky130_fd_sc_hd__decap_3
XFILLER_0_73_449 VGND VGND VPWR VPWR sky130_fd_sc_hd__fill_2
XTAP_TAPCELL_ROW_42_750 VGND VPWR sky130_fd_sc_hd__tapvpwrvgnd_1
XTAP_TAPCELL_ROW_42_761 VGND VPWR sky130_fd_sc_hd__tapvpwrvgnd_1
XFILLER_0_109_581 VGND VGND VPWR VPWR sky130_fd_sc_hd__decap_4
X_5540_ _1616_ _2328_ net5 VGND VGND VPWR VPWR _2329_ sky130_fd_sc_hd__a21oi_1
X_5471_ RF.reg_arr\[16\]\[6\] RF.reg_arr\[17\]\[6\] RF.reg_arr\[18\]\[6\] RF.reg_arr\[19\]\[6\]
+ _1847_ _1850_ VGND VGND VPWR VPWR _2260_ sky130_fd_sc_hd__mux4_1
XFILLER_0_30_53 VGND VGND VPWR VPWR sky130_fd_sc_hd__decap_3
X_7210_ _3549_ VGND VGND VPWR VPWR _0152_ sky130_fd_sc_hd__clkbuf_1
X_4422_ RF.reg_arr\[28\]\[8\] RF.reg_arr\[29\]\[8\] RF.reg_arr\[30\]\[8\] RF.reg_arr\[31\]\[8\]
+ net93 _1094_ VGND VGND VPWR VPWR _1211_ sky130_fd_sc_hd__mux4_1
XFILLER_0_41_357 VGND VGND VPWR VPWR sky130_fd_sc_hd__decap_4
XTAP_TAPCELL_ROW_113_1613 VGND VPWR sky130_fd_sc_hd__tapvpwrvgnd_1
XTAP_TAPCELL_ROW_113_1602 VGND VPWR sky130_fd_sc_hd__tapvpwrvgnd_1
X_8190_ _3006_ net612 _4066_ VGND VGND VPWR VPWR _4071_ sky130_fd_sc_hd__mux2_1
X_7141_ net154 _3373_ _3507_ VGND VGND VPWR VPWR _3513_ sky130_fd_sc_hd__mux2_1
X_4353_ _1132_ _1137_ _1140_ _1126_ _1141_ VGND VGND VPWR VPWR _1142_ sky130_fd_sc_hd__a221o_1
X_7072_ _3476_ VGND VGND VPWR VPWR _0087_ sky130_fd_sc_hd__clkbuf_1
X_4284_ RF.reg_arr\[20\]\[4\] RF.reg_arr\[21\]\[4\] RF.reg_arr\[22\]\[4\] RF.reg_arr\[23\]\[4\]
+ _1068_ _1069_ VGND VGND VPWR VPWR _1073_ sky130_fd_sc_hd__mux4_1
X_6023_ _2762_ _2765_ _2773_ _2790_ _2791_ VGND VGND VPWR VPWR _2792_ sky130_fd_sc_hd__o311ai_4
XFILLER_0_96_508 VGND VGND VPWR VPWR sky130_fd_sc_hd__decap_4
X_7974_ _2992_ net910 _3921_ VGND VGND VPWR VPWR _3956_ sky130_fd_sc_hd__mux2_1
X_6925_ _3386_ VGND VGND VPWR VPWR _0030_ sky130_fd_sc_hd__clkbuf_1
XFILLER_0_12_3 VPWR VGND VPWR VGND sky130_ef_sc_hd__decap_12
XFILLER_0_64_405 VGND VGND VPWR VPWR sky130_fd_sc_hd__decap_3
X_6856_ net133 _3002_ _3344_ VGND VGND VPWR VPWR _3347_ sky130_fd_sc_hd__mux2_1
X_5807_ _2587_ VGND VGND VPWR VPWR _2588_ sky130_fd_sc_hd__buf_2
X_6787_ net345 _3002_ _3307_ VGND VGND VPWR VPWR _3310_ sky130_fd_sc_hd__mux2_1
X_5738_ _2026_ VGND VGND VPWR VPWR _2521_ sky130_fd_sc_hd__buf_2
XFILLER_0_91_279 VGND VGND VPWR VPWR sky130_fd_sc_hd__fill_1
X_8526_ clknet_leaf_8_CLK _0783_ VGND VGND VPWR VPWR RF.reg_arr\[1\]\[16\] sky130_fd_sc_hd__dfxtp_1
XFILLER_0_44_184 VPWR VGND VPWR VGND sky130_ef_sc_hd__decap_12
XFILLER_0_115_573 VPWR VGND VPWR VGND sky130_ef_sc_hd__decap_12
X_5669_ _2049_ _2454_ VGND VGND VPWR VPWR _2455_ sky130_fd_sc_hd__xnor2_1
X_8457_ net297 net36 _4211_ VGND VGND VPWR VPWR _4212_ sky130_fd_sc_hd__mux2_1
XTAP_TAPCELL_ROW_20_488 VGND VPWR sky130_fd_sc_hd__tapvpwrvgnd_1
X_7408_ _3105_ net811 _3652_ VGND VGND VPWR VPWR _3655_ sky130_fd_sc_hd__mux2_1
X_8388_ net403 _3391_ _4174_ VGND VGND VPWR VPWR _4176_ sky130_fd_sc_hd__mux2_1
Xhold450 RF.reg_arr\[8\]\[26\] VGND VGND VPWR VPWR net532 sky130_fd_sc_hd__dlygate4sd3_1
X_7339_ _3618_ VGND VGND VPWR VPWR _0212_ sky130_fd_sc_hd__clkbuf_1
Xhold461 RF.reg_arr\[10\]\[23\] VGND VGND VPWR VPWR net543 sky130_fd_sc_hd__dlygate4sd3_1
Xhold472 RF.reg_arr\[13\]\[0\] VGND VGND VPWR VPWR net554 sky130_fd_sc_hd__dlygate4sd3_1
Xhold494 RF.reg_arr\[17\]\[9\] VGND VGND VPWR VPWR net576 sky130_fd_sc_hd__dlygate4sd3_1
XPHY_EDGE_ROW_8_Left_125 VGND VGND VPWR VPWR sky130_fd_sc_hd__decap_3
Xhold483 RF.reg_arr\[19\]\[0\] VGND VGND VPWR VPWR net565 sky130_fd_sc_hd__dlygate4sd3_1
X_9009_ clknet_leaf_4_CLK _0242_ VGND VGND VPWR VPWR RF.reg_arr\[27\]\[19\] sky130_fd_sc_hd__dfxtp_1
XFILLER_0_99_335 VGND VGND VPWR VPWR sky130_fd_sc_hd__fill_1
XFILLER_0_67_243 VGND VGND VPWR VPWR sky130_fd_sc_hd__fill_1
XTAP_TAPCELL_ROW_28_588 VGND VPWR sky130_fd_sc_hd__tapvpwrvgnd_1
XFILLER_0_27_107 VGND VGND VPWR VPWR sky130_fd_sc_hd__decap_4
XFILLER_0_106_551 VGND VGND VPWR VPWR sky130_fd_sc_hd__decap_3
XFILLER_0_106_540 VGND VGND VPWR VPWR sky130_fd_sc_hd__decap_6
Xclkload17 clknet_leaf_20_CLK VGND VGND VPWR VPWR clkload17/Y sky130_fd_sc_hd__inv_8
XFILLER_0_51_633 VGND VGND VPWR VPWR sky130_fd_sc_hd__fill_2
Xclkload39 clknet_leaf_30_CLK VGND VGND VPWR VPWR clkload39/Y sky130_fd_sc_hd__clkinv_4
Xclkload28 clknet_leaf_103_CLK VGND VGND VPWR VPWR clkload28/Y sky130_fd_sc_hd__clkinvlp_4
XFILLER_0_23_346 VGND VGND VPWR VPWR sky130_fd_sc_hd__decap_3
XFILLER_0_92_15 VGND VGND VPWR VPWR sky130_fd_sc_hd__decap_6
XFILLER_0_92_37 VGND VGND VPWR VPWR sky130_fd_sc_hd__decap_4
XTAP_TAPCELL_ROW_47_820 VGND VPWR sky130_fd_sc_hd__tapvpwrvgnd_1
X_4971_ RF.reg_arr\[28\]\[27\] RF.reg_arr\[29\]\[27\] RF.reg_arr\[30\]\[27\] RF.reg_arr\[31\]\[27\]
+ _1592_ _1599_ VGND VGND VPWR VPWR _1760_ sky130_fd_sc_hd__mux4_1
X_7690_ _3805_ VGND VGND VPWR VPWR _0376_ sky130_fd_sc_hd__clkbuf_1
XTAP_TAPCELL_ROW_63_1011 VGND VPWR sky130_fd_sc_hd__tapvpwrvgnd_1
X_6710_ net9 net10 VGND VGND VPWR VPWR _3267_ sky130_fd_sc_hd__nor2b_4
X_6641_ _3230_ VGND VGND VPWR VPWR _0926_ sky130_fd_sc_hd__clkbuf_1
XFILLER_0_58_287 VGND VGND VPWR VPWR sky130_fd_sc_hd__fill_2
X_9360_ clknet_leaf_4_CLK _0593_ VGND VGND VPWR VPWR RF.reg_arr\[18\]\[18\] sky130_fd_sc_hd__dfxtp_1
XFILLER_0_41_52 VGND VGND VPWR VPWR sky130_fd_sc_hd__decap_4
X_8311_ _4134_ VGND VGND VPWR VPWR _0668_ sky130_fd_sc_hd__clkbuf_1
X_6572_ net943 _2992_ _3159_ VGND VGND VPWR VPWR _3194_ sky130_fd_sc_hd__mux2_1
X_5523_ _1115_ _2293_ _2311_ VGND VGND VPWR VPWR _2312_ sky130_fd_sc_hd__o21a_1
X_9291_ clknet_leaf_92_CLK _0524_ VGND VGND VPWR VPWR RF.reg_arr\[25\]\[13\] sky130_fd_sc_hd__dfxtp_1
X_8242_ _2988_ net471 _4088_ VGND VGND VPWR VPWR _4098_ sky130_fd_sc_hd__mux2_1
X_5454_ _2241_ _2242_ _1611_ VGND VGND VPWR VPWR _2243_ sky130_fd_sc_hd__mux2_1
X_8173_ _4061_ VGND VGND VPWR VPWR _0603_ sky130_fd_sc_hd__clkbuf_1
X_5385_ _1617_ _2173_ net5 VGND VGND VPWR VPWR _2174_ sky130_fd_sc_hd__a21oi_1
X_4405_ RF.reg_arr\[16\]\[18\] RF.reg_arr\[17\]\[18\] RF.reg_arr\[18\]\[18\] RF.reg_arr\[19\]\[18\]
+ _1187_ _1189_ VGND VGND VPWR VPWR _1194_ sky130_fd_sc_hd__mux4_1
XFILLER_0_112_587 VGND VGND VPWR VPWR sky130_fd_sc_hd__fill_1
XTAP_TAPCELL_ROW_74_1140 VGND VPWR sky130_fd_sc_hd__tapvpwrvgnd_1
X_7124_ net685 _3424_ _3496_ VGND VGND VPWR VPWR _3504_ sky130_fd_sc_hd__mux2_1
X_4336_ _1123_ _1124_ _1121_ VGND VGND VPWR VPWR _1125_ sky130_fd_sc_hd__mux2_1
X_4267_ _1049_ _1054_ _1055_ VGND VGND VPWR VPWR _1056_ sky130_fd_sc_hd__o21a_1
X_7055_ _3467_ VGND VGND VPWR VPWR _0079_ sky130_fd_sc_hd__clkbuf_1
X_6006_ _2370_ _2374_ VGND VGND VPWR VPWR _2776_ sky130_fd_sc_hd__nand2_1
XFILLER_0_96_305 VGND VGND VPWR VPWR sky130_fd_sc_hd__decap_3
XFILLER_0_82_70 VGND VGND VPWR VPWR sky130_fd_sc_hd__fill_1
X_7957_ _3947_ VGND VGND VPWR VPWR _0501_ sky130_fd_sc_hd__clkbuf_1
X_6908_ net32 VGND VGND VPWR VPWR _3375_ sky130_fd_sc_hd__buf_2
X_7888_ _3105_ net540 _3908_ VGND VGND VPWR VPWR _3911_ sky130_fd_sc_hd__mux2_1
XTAP_TAPCELL_ROW_25_547 VGND VPWR sky130_fd_sc_hd__tapvpwrvgnd_1
X_6839_ net350 _2984_ _3329_ VGND VGND VPWR VPWR _3337_ sky130_fd_sc_hd__mux2_1
XFILLER_0_49_298 VGND VGND VPWR VPWR sky130_fd_sc_hd__fill_1
XTAP_TAPCELL_ROW_53_889 VGND VPWR sky130_fd_sc_hd__tapvpwrvgnd_1
XFILLER_0_107_337 VGND VGND VPWR VPWR sky130_fd_sc_hd__fill_2
XFILLER_0_92_577 VGND VGND VPWR VPWR sky130_fd_sc_hd__fill_1
XFILLER_0_64_268 VGND VGND VPWR VPWR sky130_fd_sc_hd__fill_2
XFILLER_0_17_173 VPWR VGND VPWR VGND sky130_ef_sc_hd__decap_12
X_8509_ clknet_leaf_26_CLK _0766_ VGND VGND VPWR VPWR RF.reg_arr\[10\]\[31\] sky130_fd_sc_hd__dfxtp_1
XFILLER_0_33_655 VGND VGND VPWR VPWR sky130_fd_sc_hd__fill_1
X_9489_ clknet_leaf_7_CLK _0722_ VGND VGND VPWR VPWR RF.reg_arr\[11\]\[19\] sky130_fd_sc_hd__dfxtp_1
XFILLER_0_103_532 VGND VGND VPWR VPWR sky130_fd_sc_hd__fill_2
XFILLER_0_5_590 VGND VGND VPWR VPWR sky130_fd_sc_hd__fill_2
XFILLER_0_13_390 VGND VGND VPWR VPWR sky130_fd_sc_hd__fill_2
Xhold280 RF.reg_arr\[11\]\[17\] VGND VGND VPWR VPWR net362 sky130_fd_sc_hd__dlygate4sd3_1
Xhold291 RF.reg_arr\[24\]\[27\] VGND VGND VPWR VPWR net373 sky130_fd_sc_hd__dlygate4sd3_1
XFILLER_0_1_3 VPWR VGND VPWR VGND sky130_ef_sc_hd__decap_12
XTAP_TAPCELL_ROW_88_1309 VGND VPWR sky130_fd_sc_hd__tapvpwrvgnd_1
XFILLER_0_68_530 VGND VGND VPWR VPWR sky130_fd_sc_hd__fill_2
XFILLER_0_62_29 VGND VGND VPWR VPWR sky130_fd_sc_hd__fill_2
XFILLER_0_83_500 VGND VGND VPWR VPWR sky130_fd_sc_hd__decap_4
XFILLER_0_102_46 VGND VGND VPWR VPWR sky130_fd_sc_hd__fill_1
XTAP_TAPCELL_ROW_99_1438 VGND VPWR sky130_fd_sc_hd__tapvpwrvgnd_1
XFILLER_0_36_482 VGND VGND VPWR VPWR sky130_fd_sc_hd__fill_2
XFILLER_0_106_381 VGND VGND VPWR VPWR sky130_fd_sc_hd__fill_2
XFILLER_0_11_349 VGND VGND VPWR VPWR sky130_fd_sc_hd__fill_2
X_5170_ _1845_ _1958_ VGND VGND VPWR VPWR _1959_ sky130_fd_sc_hd__nand2_1
XFILLER_0_46_9 VGND VGND VPWR VPWR sky130_fd_sc_hd__decap_3
Xinput4 A1[3] VGND VGND VPWR VPWR net4 sky130_fd_sc_hd__buf_1
XTAP_TAPCELL_ROW_108_1545 VGND VPWR sky130_fd_sc_hd__tapvpwrvgnd_1
X_8860_ clknet_leaf_20_CLK _0093_ VGND VGND VPWR VPWR RF.reg_arr\[19\]\[30\] sky130_fd_sc_hd__dfxtp_1
X_8791_ clknet_leaf_48_CLK _0024_ VGND VGND VPWR VPWR RF.reg_arr\[5\]\[25\] sky130_fd_sc_hd__dfxtp_1
X_7811_ _3869_ VGND VGND VPWR VPWR _0433_ sky130_fd_sc_hd__clkbuf_1
X_4954_ RF.reg_arr\[24\]\[26\] RF.reg_arr\[25\]\[26\] RF.reg_arr\[26\]\[26\] RF.reg_arr\[27\]\[26\]
+ _1668_ _1669_ VGND VGND VPWR VPWR _1743_ sky130_fd_sc_hd__mux4_1
XFILLER_0_59_552 VGND VGND VPWR VPWR sky130_fd_sc_hd__fill_1
X_7742_ net280 _3426_ _3824_ VGND VGND VPWR VPWR _3833_ sky130_fd_sc_hd__mux2_1
XFILLER_0_74_533 VPWR VGND VPWR VGND sky130_ef_sc_hd__decap_12
XFILLER_0_74_555 VGND VGND VPWR VPWR sky130_fd_sc_hd__decap_4
X_7673_ _3796_ VGND VGND VPWR VPWR _0368_ sky130_fd_sc_hd__clkbuf_1
X_9412_ clknet_leaf_84_CLK _0645_ VGND VGND VPWR VPWR RF.reg_arr\[17\]\[6\] sky130_fd_sc_hd__dfxtp_1
XTAP_TAPCELL_ROW_22_517 VGND VPWR sky130_fd_sc_hd__tapvpwrvgnd_1
XTAP_TAPCELL_ROW_50_848 VGND VPWR sky130_fd_sc_hd__tapvpwrvgnd_1
X_4885_ _1621_ VGND VGND VPWR VPWR _1674_ sky130_fd_sc_hd__buf_4
X_6624_ net460 _3046_ _3218_ VGND VGND VPWR VPWR _3222_ sky130_fd_sc_hd__mux2_1
XFILLER_0_104_307 VGND VGND VPWR VPWR sky130_fd_sc_hd__fill_1
XPHY_EDGE_ROW_89_Left_206 VGND VGND VPWR VPWR sky130_fd_sc_hd__decap_3
X_9343_ clknet_leaf_55_CLK _0576_ VGND VGND VPWR VPWR RF.reg_arr\[18\]\[1\] sky130_fd_sc_hd__dfxtp_1
X_6555_ _3185_ VGND VGND VPWR VPWR _0885_ sky130_fd_sc_hd__clkbuf_1
XFILLER_0_14_132 VGND VGND VPWR VPWR sky130_fd_sc_hd__fill_1
XFILLER_0_27_482 VGND VGND VPWR VPWR sky130_fd_sc_hd__decap_3
XFILLER_0_54_290 VPWR VGND VPWR VGND sky130_ef_sc_hd__decap_12
X_9274_ clknet_leaf_33_CLK _0507_ VGND VGND VPWR VPWR RF.reg_arr\[21\]\[28\] sky130_fd_sc_hd__dfxtp_1
X_5506_ RF.reg_arr\[16\]\[2\] RF.reg_arr\[17\]\[2\] RF.reg_arr\[18\]\[2\] RF.reg_arr\[19\]\[2\]
+ _1588_ _1679_ VGND VGND VPWR VPWR _2295_ sky130_fd_sc_hd__mux4_1
X_6486_ net100 VGND VGND VPWR VPWR _3148_ sky130_fd_sc_hd__clkbuf_1
X_8225_ _4089_ VGND VGND VPWR VPWR _0627_ sky130_fd_sc_hd__clkbuf_1
XFILLER_0_112_362 VGND VGND VPWR VPWR sky130_fd_sc_hd__fill_2
XFILLER_0_2_571 VGND VGND VPWR VPWR sky130_fd_sc_hd__fill_1
X_5437_ RF.reg_arr\[12\]\[5\] RF.reg_arr\[13\]\[5\] RF.reg_arr\[14\]\[5\] RF.reg_arr\[15\]\[5\]
+ _1623_ _1596_ VGND VGND VPWR VPWR _2226_ sky130_fd_sc_hd__mux4_1
X_8156_ net531 _3430_ _4052_ VGND VGND VPWR VPWR _4053_ sky130_fd_sc_hd__mux2_1
X_5368_ _1642_ _2148_ _2156_ VGND VGND VPWR VPWR _2157_ sky130_fd_sc_hd__o21ai_4
X_8087_ _3993_ VGND VGND VPWR VPWR _4016_ sky130_fd_sc_hd__clkbuf_8
X_5299_ RF.reg_arr\[24\]\[8\] RF.reg_arr\[25\]\[8\] RF.reg_arr\[26\]\[8\] RF.reg_arr\[27\]\[8\]
+ _2087_ _1859_ VGND VGND VPWR VPWR _2088_ sky130_fd_sc_hd__mux4_1
X_4319_ RF.reg_arr\[0\]\[0\] RF.reg_arr\[1\]\[0\] RF.reg_arr\[2\]\[0\] RF.reg_arr\[3\]\[0\]
+ net98 _1106_ VGND VGND VPWR VPWR _1108_ sky130_fd_sc_hd__mux4_1
X_7107_ net148 _3407_ _3485_ VGND VGND VPWR VPWR _3495_ sky130_fd_sc_hd__mux2_1
XPHY_EDGE_ROW_98_Left_215 VGND VGND VPWR VPWR sky130_fd_sc_hd__decap_3
X_7038_ _3458_ VGND VGND VPWR VPWR _0071_ sky130_fd_sc_hd__clkbuf_1
XTAP_TAPCELL_ROW_58_948 VGND VPWR sky130_fd_sc_hd__tapvpwrvgnd_1
XFILLER_0_97_614 VGND VGND VPWR VPWR sky130_fd_sc_hd__fill_2
XFILLER_0_96_102 VGND VGND VPWR VPWR sky130_fd_sc_hd__fill_1
X_8989_ clknet_leaf_21_CLK _0222_ VGND VGND VPWR VPWR RF.reg_arr\[31\]\[31\] sky130_fd_sc_hd__dfxtp_1
XTAP_TAPCELL_ROW_2_275 VGND VPWR sky130_fd_sc_hd__tapvpwrvgnd_1
XFILLER_0_92_363 VGND VGND VPWR VPWR sky130_fd_sc_hd__fill_1
XTAP_TAPCELL_ROW_94_1379 VGND VPWR sky130_fd_sc_hd__tapvpwrvgnd_1
Xclkbuf_leaf_105_CLK clknet_3_1__leaf_CLK VGND VGND VPWR VPWR clknet_leaf_105_CLK
+ sky130_fd_sc_hd__clkbuf_8
XFILLER_0_57_18 VGND VGND VPWR VPWR sky130_fd_sc_hd__fill_2
XFILLER_0_113_45 VGND VGND VPWR VPWR sky130_fd_sc_hd__fill_1
XTAP_TAPCELL_ROW_103_1486 VGND VPWR sky130_fd_sc_hd__tapvpwrvgnd_1
XFILLER_0_83_341 VGND VGND VPWR VPWR sky130_fd_sc_hd__fill_1
X_4670_ RF.reg_arr\[8\]\[31\] RF.reg_arr\[9\]\[31\] RF.reg_arr\[10\]\[31\] RF.reg_arr\[11\]\[31\]
+ _1274_ _1276_ VGND VGND VPWR VPWR _1459_ sky130_fd_sc_hd__mux4_1
XFILLER_0_71_503 VGND VGND VPWR VPWR sky130_fd_sc_hd__fill_1
XFILLER_0_16_419 VGND VGND VPWR VPWR sky130_fd_sc_hd__fill_1
XFILLER_0_28_268 VGND VGND VPWR VPWR sky130_fd_sc_hd__fill_1
X_6340_ net10 net9 net46 VGND VGND VPWR VPWR _3057_ sky130_fd_sc_hd__and3_4
XFILLER_0_11_113 VGND VGND VPWR VPWR sky130_fd_sc_hd__decap_6
XFILLER_0_24_485 VGND VGND VPWR VPWR sky130_fd_sc_hd__decap_3
X_6271_ net584 _3012_ _2998_ VGND VGND VPWR VPWR _3013_ sky130_fd_sc_hd__mux2_1
X_8010_ _3975_ VGND VGND VPWR VPWR _0526_ sky130_fd_sc_hd__clkbuf_1
X_5222_ _2009_ _2010_ _1033_ VGND VGND VPWR VPWR _2011_ sky130_fd_sc_hd__mux2_1
X_5153_ _1610_ VGND VGND VPWR VPWR _1942_ sky130_fd_sc_hd__buf_4
XFILLER_0_47_73 VGND VGND VPWR VPWR sky130_fd_sc_hd__fill_1
X_5084_ _1871_ _1872_ _1854_ VGND VGND VPWR VPWR _1873_ sky130_fd_sc_hd__mux2_1
XFILLER_0_79_603 VPWR VGND VPWR VGND sky130_ef_sc_hd__decap_12
X_8912_ clknet_leaf_3_CLK _0145_ VGND VGND VPWR VPWR RF.reg_arr\[7\]\[18\] sky130_fd_sc_hd__dfxtp_1
XTAP_TAPCELL_ROW_55_907 VGND VPWR sky130_fd_sc_hd__tapvpwrvgnd_1
XFILLER_0_79_636 VGND VGND VPWR VPWR sky130_fd_sc_hd__fill_2
XFILLER_0_2_53 VGND VGND VPWR VPWR sky130_fd_sc_hd__decap_4
XFILLER_0_2_75 VGND VGND VPWR VPWR sky130_fd_sc_hd__decap_8
X_8843_ clknet_leaf_93_CLK _0076_ VGND VGND VPWR VPWR RF.reg_arr\[19\]\[13\] sky130_fd_sc_hd__dfxtp_1
XFILLER_0_94_617 VGND VGND VPWR VPWR sky130_fd_sc_hd__fill_1
XFILLER_0_78_157 VGND VGND VPWR VPWR sky130_fd_sc_hd__fill_1
XTAP_TAPCELL_ROW_69_1083 VGND VPWR sky130_fd_sc_hd__tapvpwrvgnd_1
XFILLER_0_2_97 VPWR VGND VPWR VGND sky130_ef_sc_hd__decap_12
X_5986_ _2618_ _2756_ _2022_ VGND VGND VPWR VPWR _2757_ sky130_fd_sc_hd__mux2_1
X_8774_ clknet_leaf_87_CLK _0007_ VGND VGND VPWR VPWR RF.reg_arr\[5\]\[8\] sky130_fd_sc_hd__dfxtp_1
X_4937_ _1724_ _1725_ _1041_ VGND VGND VPWR VPWR _1726_ sky130_fd_sc_hd__mux2_1
XTAP_TAPCELL_ROW_35_675 VGND VPWR sky130_fd_sc_hd__tapvpwrvgnd_1
X_7725_ _3812_ VGND VGND VPWR VPWR _3824_ sky130_fd_sc_hd__buf_4
X_4868_ _1655_ _1656_ _1605_ VGND VGND VPWR VPWR _1657_ sky130_fd_sc_hd__mux2_1
XFILLER_0_74_363 VGND VGND VPWR VPWR sky130_fd_sc_hd__fill_1
XFILLER_0_74_352 VGND VGND VPWR VPWR sky130_fd_sc_hd__decap_3
XFILLER_0_7_641 VGND VGND VPWR VPWR sky130_fd_sc_hd__fill_1
X_7656_ _3787_ VGND VGND VPWR VPWR _0360_ sky130_fd_sc_hd__clkbuf_1
XANTENNA_20 _4138_ VGND VGND VPWR VPWR sky130_fd_sc_hd__diode_2
XFILLER_0_47_588 VGND VGND VPWR VPWR sky130_fd_sc_hd__fill_1
XFILLER_0_15_430 VGND VGND VPWR VPWR sky130_fd_sc_hd__decap_4
X_6607_ net200 _3029_ _3207_ VGND VGND VPWR VPWR _3213_ sky130_fd_sc_hd__mux2_1
Xclkbuf_3_6__f_CLK clknet_0_CLK VGND VGND VPWR VPWR clknet_3_6__leaf_CLK sky130_fd_sc_hd__clkbuf_16
X_4799_ net1 VGND VGND VPWR VPWR _1588_ sky130_fd_sc_hd__buf_4
X_7587_ net356 _3407_ _3741_ VGND VGND VPWR VPWR _3751_ sky130_fd_sc_hd__mux2_1
X_9326_ clknet_leaf_7_CLK _0559_ VGND VGND VPWR VPWR RF.reg_arr\[20\]\[16\] sky130_fd_sc_hd__dfxtp_1
X_6538_ _3176_ VGND VGND VPWR VPWR _0877_ sky130_fd_sc_hd__clkbuf_1
XFILLER_0_88_80 VGND VGND VPWR VPWR sky130_fd_sc_hd__decap_4
X_6469_ _3139_ VGND VGND VPWR VPWR _0845_ sky130_fd_sc_hd__clkbuf_1
X_9257_ clknet_leaf_12_CLK _0490_ VGND VGND VPWR VPWR RF.reg_arr\[21\]\[11\] sky130_fd_sc_hd__dfxtp_1
XFILLER_0_100_321 VGND VGND VPWR VPWR sky130_fd_sc_hd__fill_2
X_9188_ clknet_leaf_83_CLK _0421_ VGND VGND VPWR VPWR RF.reg_arr\[24\]\[6\] sky130_fd_sc_hd__dfxtp_1
X_8208_ _4080_ VGND VGND VPWR VPWR _0619_ sky130_fd_sc_hd__clkbuf_1
XFILLER_0_30_477 VGND VGND VPWR VPWR sky130_fd_sc_hd__fill_2
X_8139_ net265 _3414_ _4041_ VGND VGND VPWR VPWR _4044_ sky130_fd_sc_hd__mux2_1
XTAP_TAPCELL_ROW_7_334 VGND VPWR sky130_fd_sc_hd__tapvpwrvgnd_1
XPHY_EDGE_ROW_102_Right_102 VGND VGND VPWR VPWR sky130_fd_sc_hd__decap_3
XFILLER_0_69_102 VGND VGND VPWR VPWR sky130_fd_sc_hd__fill_2
XFILLER_0_69_113 VGND VGND VPWR VPWR sky130_fd_sc_hd__fill_1
XFILLER_0_85_617 VPWR VGND VPWR VGND sky130_ef_sc_hd__decap_12
XFILLER_0_38_533 VGND VGND VPWR VPWR sky130_fd_sc_hd__fill_2
XFILLER_0_108_421 VGND VGND VPWR VPWR sky130_fd_sc_hd__fill_1
XFILLER_0_53_503 VGND VGND VPWR VPWR sky130_fd_sc_hd__fill_1
XTAP_TAPCELL_ROW_96_1408 VGND VPWR sky130_fd_sc_hd__tapvpwrvgnd_1
XFILLER_0_92_193 VGND VGND VPWR VPWR sky130_fd_sc_hd__decap_3
XTAP_TAPCELL_ROW_105_1515 VGND VPWR sky130_fd_sc_hd__tapvpwrvgnd_1
XFILLER_0_88_455 VGND VGND VPWR VPWR sky130_fd_sc_hd__decap_8
X_5840_ _2522_ _2489_ _2618_ _2051_ VGND VGND VPWR VPWR _2619_ sky130_fd_sc_hd__o22a_1
XFILLER_0_88_499 VGND VGND VPWR VPWR sky130_fd_sc_hd__fill_2
XFILLER_0_29_511 VGND VGND VPWR VPWR sky130_fd_sc_hd__fill_1
XFILLER_0_33_31 VGND VGND VPWR VPWR sky130_fd_sc_hd__fill_2
X_5771_ _2550_ _2552_ VGND VGND VPWR VPWR _2553_ sky130_fd_sc_hd__nand2_1
XFILLER_0_29_533 VGND VGND VPWR VPWR sky130_fd_sc_hd__decap_8
XFILLER_0_84_661 VGND VGND VPWR VPWR sky130_fd_sc_hd__fill_2
X_7510_ _3710_ VGND VGND VPWR VPWR _0291_ sky130_fd_sc_hd__clkbuf_1
XFILLER_0_29_599 VGND VGND VPWR VPWR sky130_fd_sc_hd__fill_1
X_8490_ net797 net23 _4222_ VGND VGND VPWR VPWR _4229_ sky130_fd_sc_hd__mux2_1
XTAP_TAPCELL_ROW_32_634 VGND VPWR sky130_fd_sc_hd__tapvpwrvgnd_1
XFILLER_0_44_514 VGND VGND VPWR VPWR sky130_fd_sc_hd__fill_1
X_4722_ _1126_ _1510_ VGND VGND VPWR VPWR _1511_ sky130_fd_sc_hd__nand2_1
XFILLER_0_83_193 VGND VGND VPWR VPWR sky130_fd_sc_hd__decap_3
XTAP_TAPCELL_ROW_60_976 VGND VPWR sky130_fd_sc_hd__tapvpwrvgnd_1
X_7441_ _3069_ net857 _3667_ VGND VGND VPWR VPWR _3673_ sky130_fd_sc_hd__mux2_1
X_4653_ RF.reg_arr\[8\]\[26\] RF.reg_arr\[9\]\[26\] RF.reg_arr\[10\]\[26\] RF.reg_arr\[11\]\[26\]
+ _1327_ _1328_ VGND VGND VPWR VPWR _1442_ sky130_fd_sc_hd__mux4_1
Xinput40 WD3[4] VGND VGND VPWR VPWR net40 sky130_fd_sc_hd__buf_1
X_4584_ _1371_ _1372_ _1034_ VGND VGND VPWR VPWR _1373_ sky130_fd_sc_hd__mux2_1
XTAP_TAPCELL_ROW_12_391 VGND VPWR sky130_fd_sc_hd__tapvpwrvgnd_1
Xhold802 RF.reg_arr\[13\]\[5\] VGND VGND VPWR VPWR net884 sky130_fd_sc_hd__dlygate4sd3_1
X_7372_ _3069_ net1076 _3630_ VGND VGND VPWR VPWR _3636_ sky130_fd_sc_hd__mux2_1
XTAP_TAPCELL_ROW_116_1655 VGND VPWR sky130_fd_sc_hd__tapvpwrvgnd_1
XTAP_TAPCELL_ROW_116_1644 VGND VPWR sky130_fd_sc_hd__tapvpwrvgnd_1
X_6323_ net164 _2970_ _3040_ VGND VGND VPWR VPWR _3048_ sky130_fd_sc_hd__mux2_1
Xhold835 RF.reg_arr\[12\]\[29\] VGND VGND VPWR VPWR net917 sky130_fd_sc_hd__dlygate4sd3_1
X_9111_ clknet_leaf_38_CLK _0344_ VGND VGND VPWR VPWR RF.reg_arr\[2\]\[25\] sky130_fd_sc_hd__dfxtp_1
Xhold813 RF.reg_arr\[12\]\[16\] VGND VGND VPWR VPWR net895 sky130_fd_sc_hd__dlygate4sd3_1
Xhold824 RF.reg_arr\[12\]\[19\] VGND VGND VPWR VPWR net906 sky130_fd_sc_hd__dlygate4sd3_1
Xhold846 RF.reg_arr\[20\]\[16\] VGND VGND VPWR VPWR net928 sky130_fd_sc_hd__dlygate4sd3_1
X_6254_ _3001_ VGND VGND VPWR VPWR _0768_ sky130_fd_sc_hd__clkbuf_1
X_9042_ clknet_leaf_18_CLK _0275_ VGND VGND VPWR VPWR RF.reg_arr\[26\]\[20\] sky130_fd_sc_hd__dfxtp_1
Xhold868 RF.reg_arr\[23\]\[5\] VGND VGND VPWR VPWR net950 sky130_fd_sc_hd__dlygate4sd3_1
Xhold879 RF.reg_arr\[22\]\[7\] VGND VGND VPWR VPWR net961 sky130_fd_sc_hd__dlygate4sd3_1
Xhold857 RF.reg_arr\[24\]\[9\] VGND VGND VPWR VPWR net939 sky130_fd_sc_hd__dlygate4sd3_1
XFILLER_0_110_685 VGND VGND VPWR VPWR sky130_fd_sc_hd__decap_6
X_5205_ RF.reg_arr\[12\]\[17\] RF.reg_arr\[13\]\[17\] RF.reg_arr\[14\]\[17\] RF.reg_arr\[15\]\[17\]
+ _1947_ _1948_ VGND VGND VPWR VPWR _1994_ sky130_fd_sc_hd__mux4_1
X_6185_ _2430_ _2878_ _2026_ VGND VGND VPWR VPWR _2945_ sky130_fd_sc_hd__a21o_1
XTAP_TAPCELL_ROW_4_304 VGND VPWR sky130_fd_sc_hd__tapvpwrvgnd_1
X_5136_ _1636_ _1920_ _1922_ _1924_ _1586_ VGND VGND VPWR VPWR _1925_ sky130_fd_sc_hd__a221o_1
X_5067_ _1845_ _1855_ VGND VGND VPWR VPWR _1856_ sky130_fd_sc_hd__nand2_1
XFILLER_0_67_617 VGND VGND VPWR VPWR sky130_fd_sc_hd__decap_4
XFILLER_0_39_308 VGND VGND VPWR VPWR sky130_fd_sc_hd__fill_1
X_8826_ clknet_leaf_31_CLK _0059_ VGND VGND VPWR VPWR RF.reg_arr\[4\]\[28\] sky130_fd_sc_hd__dfxtp_1
XTAP_TAPCELL_ROW_80_1209 VGND VPWR sky130_fd_sc_hd__tapvpwrvgnd_1
X_5969_ _1997_ _2740_ VGND VGND VPWR VPWR _2741_ sky130_fd_sc_hd__xnor2_2
X_8757_ clknet_leaf_41_CLK _1014_ VGND VGND VPWR VPWR RF.reg_arr\[6\]\[23\] sky130_fd_sc_hd__dfxtp_1
XFILLER_0_66_149 VGND VGND VPWR VPWR sky130_fd_sc_hd__fill_2
X_7708_ _3815_ VGND VGND VPWR VPWR _0384_ sky130_fd_sc_hd__clkbuf_1
XFILLER_0_35_503 VGND VGND VPWR VPWR sky130_fd_sc_hd__fill_1
XFILLER_0_90_620 VPWR VGND VPWR VGND sky130_ef_sc_hd__decap_12
X_8688_ clknet_leaf_1_CLK _0945_ VGND VGND VPWR VPWR RF.reg_arr\[15\]\[18\] sky130_fd_sc_hd__dfxtp_1
XFILLER_0_35_558 VGND VGND VPWR VPWR sky130_fd_sc_hd__fill_2
X_7639_ _3061_ net1053 _3777_ VGND VGND VPWR VPWR _3779_ sky130_fd_sc_hd__mux2_1
X_9309_ clknet_leaf_21_CLK _0542_ VGND VGND VPWR VPWR RF.reg_arr\[25\]\[31\] sky130_fd_sc_hd__dfxtp_1
XFILLER_0_15_293 VGND VGND VPWR VPWR sky130_fd_sc_hd__fill_1
XTAP_TAPCELL_ROW_91_1338 VGND VPWR sky130_fd_sc_hd__tapvpwrvgnd_1
XTAP_TAPCELL_ROW_91_1349 VGND VPWR sky130_fd_sc_hd__tapvpwrvgnd_1
XFILLER_0_30_296 VGND VGND VPWR VPWR sky130_fd_sc_hd__fill_2
XFILLER_0_85_458 VGND VGND VPWR VPWR sky130_fd_sc_hd__fill_1
XFILLER_0_85_447 VGND VGND VPWR VPWR sky130_fd_sc_hd__fill_1
XFILLER_0_70_29 VGND VGND VPWR VPWR sky130_fd_sc_hd__fill_1
XTAP_TAPCELL_ROW_100_1456 VGND VPWR sky130_fd_sc_hd__tapvpwrvgnd_1
XFILLER_0_81_653 VGND VGND VPWR VPWR sky130_fd_sc_hd__fill_1
XFILLER_0_110_35 VGND VGND VPWR VPWR sky130_fd_sc_hd__fill_1
XFILLER_0_111_427 VGND VGND VPWR VPWR sky130_fd_sc_hd__decap_8
Xhold109 RF.reg_arr\[11\]\[29\] VGND VGND VPWR VPWR net191 sky130_fd_sc_hd__dlygate4sd3_1
XFILLER_0_0_113 VGND VGND VPWR VPWR sky130_fd_sc_hd__decap_3
XFILLER_0_21_252 VGND VGND VPWR VPWR sky130_fd_sc_hd__fill_1
XTAP_TAPCELL_ROW_111_1585 VGND VPWR sky130_fd_sc_hd__tapvpwrvgnd_1
XFILLER_0_28_75 VGND VGND VPWR VPWR sky130_fd_sc_hd__fill_2
X_7990_ _3010_ net924 _3958_ VGND VGND VPWR VPWR _3965_ sky130_fd_sc_hd__mux2_1
XFILLER_0_88_230 VGND VGND VPWR VPWR sky130_fd_sc_hd__fill_1
X_6941_ net942 _3397_ _3389_ VGND VGND VPWR VPWR _3398_ sky130_fd_sc_hd__mux2_1
XTAP_TAPCELL_ROW_66_1042 VGND VPWR sky130_fd_sc_hd__tapvpwrvgnd_1
X_6872_ _3343_ VGND VGND VPWR VPWR _3355_ sky130_fd_sc_hd__clkbuf_8
XFILLER_0_49_617 VGND VGND VPWR VPWR sky130_fd_sc_hd__decap_8
X_5823_ _2521_ _2602_ VGND VGND VPWR VPWR _2603_ sky130_fd_sc_hd__or2_1
XTAP_TAPCELL_ROW_17_450 VGND VPWR sky130_fd_sc_hd__tapvpwrvgnd_1
XTAP_TAPCELL_ROW_17_461 VGND VPWR sky130_fd_sc_hd__tapvpwrvgnd_1
X_8611_ clknet_leaf_73_CLK _0868_ VGND VGND VPWR VPWR RF.reg_arr\[16\]\[5\] sky130_fd_sc_hd__dfxtp_1
XFILLER_0_91_417 VGND VGND VPWR VPWR sky130_fd_sc_hd__fill_2
XFILLER_0_60_40 VGND VGND VPWR VPWR sky130_fd_sc_hd__fill_2
X_8542_ clknet_leaf_74_CLK _0799_ VGND VGND VPWR VPWR RF.reg_arr\[23\]\[0\] sky130_fd_sc_hd__dfxtp_1
XFILLER_0_29_374 VPWR VGND VPWR VGND sky130_ef_sc_hd__decap_12
XTAP_TAPCELL_ROW_45_792 VGND VPWR sky130_fd_sc_hd__tapvpwrvgnd_1
X_5754_ _1401_ _2536_ VGND VGND VPWR VPWR _2537_ sky130_fd_sc_hd__xnor2_1
XFILLER_0_60_51 VGND VGND VPWR VPWR sky130_fd_sc_hd__decap_3
Xclkbuf_leaf_94_CLK clknet_3_1__leaf_CLK VGND VGND VPWR VPWR clknet_leaf_94_CLK sky130_fd_sc_hd__clkbuf_8
XFILLER_0_44_322 VGND VGND VPWR VPWR sky130_fd_sc_hd__fill_1
X_5685_ _2465_ _2470_ _2022_ VGND VGND VPWR VPWR _2471_ sky130_fd_sc_hd__mux2_1
X_4705_ RF.reg_arr\[4\]\[12\] RF.reg_arr\[5\]\[12\] RF.reg_arr\[6\]\[12\] RF.reg_arr\[7\]\[12\]
+ _1342_ _1343_ VGND VGND VPWR VPWR _1494_ sky130_fd_sc_hd__mux4_1
X_8473_ net334 net15 _4211_ VGND VGND VPWR VPWR _4220_ sky130_fd_sc_hd__mux2_1
X_4636_ RF.reg_arr\[8\]\[27\] RF.reg_arr\[9\]\[27\] RF.reg_arr\[10\]\[27\] RF.reg_arr\[11\]\[27\]
+ _1316_ _1304_ VGND VGND VPWR VPWR _1425_ sky130_fd_sc_hd__mux4_1
X_7424_ _3121_ net613 _3629_ VGND VGND VPWR VPWR _3663_ sky130_fd_sc_hd__mux2_1
XPHY_EDGE_ROW_62_Left_179 VGND VGND VPWR VPWR sky130_fd_sc_hd__decap_3
X_7355_ _3626_ VGND VGND VPWR VPWR _0220_ sky130_fd_sc_hd__clkbuf_1
Xhold621 RF.reg_arr\[22\]\[30\] VGND VGND VPWR VPWR net703 sky130_fd_sc_hd__dlygate4sd3_1
Xhold610 RF.reg_arr\[18\]\[19\] VGND VGND VPWR VPWR net692 sky130_fd_sc_hd__dlygate4sd3_1
Xhold632 RF.reg_arr\[30\]\[25\] VGND VGND VPWR VPWR net714 sky130_fd_sc_hd__dlygate4sd3_1
Xhold643 RF.reg_arr\[14\]\[23\] VGND VGND VPWR VPWR net725 sky130_fd_sc_hd__dlygate4sd3_1
X_4567_ _1352_ _1355_ _1039_ VGND VGND VPWR VPWR _1356_ sky130_fd_sc_hd__mux2_1
XTAP_TAPCELL_ROW_77_1171 VGND VPWR sky130_fd_sc_hd__tapvpwrvgnd_1
Xhold654 RF.reg_arr\[22\]\[15\] VGND VGND VPWR VPWR net736 sky130_fd_sc_hd__dlygate4sd3_1
X_6306_ _3036_ VGND VGND VPWR VPWR _0785_ sky130_fd_sc_hd__clkbuf_1
Xhold676 RF.reg_arr\[27\]\[24\] VGND VGND VPWR VPWR net758 sky130_fd_sc_hd__dlygate4sd3_1
X_7286_ _3119_ net459 _3580_ VGND VGND VPWR VPWR _3590_ sky130_fd_sc_hd__mux2_1
X_4498_ _1285_ _1286_ _1281_ VGND VGND VPWR VPWR _1287_ sky130_fd_sc_hd__mux2_1
Xhold665 RF.reg_arr\[26\]\[20\] VGND VGND VPWR VPWR net747 sky130_fd_sc_hd__dlygate4sd3_1
Xhold687 RF.reg_arr\[15\]\[2\] VGND VGND VPWR VPWR net769 sky130_fd_sc_hd__dlygate4sd3_1
X_6237_ net187 _2988_ _2978_ VGND VGND VPWR VPWR _2989_ sky130_fd_sc_hd__mux2_1
Xhold698 RF.reg_arr\[29\]\[9\] VGND VGND VPWR VPWR net780 sky130_fd_sc_hd__dlygate4sd3_1
XFILLER_0_0_691 VGND VGND VPWR VPWR sky130_fd_sc_hd__fill_1
X_9025_ clknet_leaf_69_CLK _0258_ VGND VGND VPWR VPWR RF.reg_arr\[26\]\[3\] sky130_fd_sc_hd__dfxtp_1
X_6168_ _2000_ _1718_ _1774_ VGND VGND VPWR VPWR _2929_ sky130_fd_sc_hd__and3_1
XFILLER_0_85_92 VGND VGND VPWR VPWR sky130_fd_sc_hd__fill_2
X_5119_ RF.reg_arr\[0\]\[20\] RF.reg_arr\[1\]\[20\] RF.reg_arr\[2\]\[20\] RF.reg_arr\[3\]\[20\]
+ _1591_ _1878_ VGND VGND VPWR VPWR _1908_ sky130_fd_sc_hd__mux4_1
X_6099_ _2862_ _2863_ VGND VGND VPWR VPWR _2864_ sky130_fd_sc_hd__nor2_1
XPHY_EDGE_ROW_71_Left_188 VGND VGND VPWR VPWR sky130_fd_sc_hd__decap_3
XFILLER_0_39_105 VGND VGND VPWR VPWR sky130_fd_sc_hd__fill_1
X_8809_ clknet_leaf_13_CLK _0042_ VGND VGND VPWR VPWR RF.reg_arr\[4\]\[11\] sky130_fd_sc_hd__dfxtp_1
XFILLER_0_94_266 VGND VGND VPWR VPWR sky130_fd_sc_hd__fill_2
XFILLER_0_82_406 VGND VGND VPWR VPWR sky130_fd_sc_hd__fill_2
Xclkbuf_leaf_85_CLK clknet_3_4__leaf_CLK VGND VGND VPWR VPWR clknet_leaf_85_CLK sky130_fd_sc_hd__clkbuf_8
XFILLER_0_35_322 VGND VGND VPWR VPWR sky130_fd_sc_hd__decap_8
XPHY_EDGE_ROW_80_Left_197 VGND VGND VPWR VPWR sky130_fd_sc_hd__decap_3
XFILLER_0_62_141 VGND VGND VPWR VPWR sky130_fd_sc_hd__fill_2
XFILLER_0_105_221 VGND VGND VPWR VPWR sky130_fd_sc_hd__decap_3
XFILLER_0_16_580 VGND VGND VPWR VPWR sky130_fd_sc_hd__decap_8
XFILLER_0_105_287 VGND VGND VPWR VPWR sky130_fd_sc_hd__fill_1
XFILLER_0_101_493 VGND VGND VPWR VPWR sky130_fd_sc_hd__decap_8
XFILLER_0_65_29 VGND VGND VPWR VPWR sky130_fd_sc_hd__decap_6
XFILLER_0_58_469 VGND VGND VPWR VPWR sky130_fd_sc_hd__decap_6
XTAP_TAPCELL_ROW_14_420 VGND VPWR sky130_fd_sc_hd__tapvpwrvgnd_1
XFILLER_0_45_108 VGND VGND VPWR VPWR sky130_fd_sc_hd__decap_4
Xclkbuf_leaf_76_CLK clknet_3_5__leaf_CLK VGND VGND VPWR VPWR clknet_leaf_76_CLK sky130_fd_sc_hd__clkbuf_8
XTAP_TAPCELL_ROW_42_751 VGND VPWR sky130_fd_sc_hd__tapvpwrvgnd_1
XFILLER_0_30_10 VGND VGND VPWR VPWR sky130_fd_sc_hd__fill_1
XFILLER_0_53_130 VGND VGND VPWR VPWR sky130_fd_sc_hd__fill_2
XFILLER_0_54_642 VGND VGND VPWR VPWR sky130_fd_sc_hd__fill_2
XFILLER_0_54_653 VGND VGND VPWR VPWR sky130_fd_sc_hd__fill_1
X_5470_ RF.reg_arr\[20\]\[6\] RF.reg_arr\[21\]\[6\] RF.reg_arr\[22\]\[6\] RF.reg_arr\[23\]\[6\]
+ _1675_ _1681_ VGND VGND VPWR VPWR _2259_ sky130_fd_sc_hd__mux4_1
XFILLER_0_26_388 VGND VGND VPWR VPWR sky130_fd_sc_hd__decap_6
XFILLER_0_100_3 VPWR VGND VPWR VGND sky130_ef_sc_hd__decap_12
X_4421_ _1110_ _1209_ VGND VGND VPWR VPWR _1210_ sky130_fd_sc_hd__nand2_1
XTAP_TAPCELL_ROW_113_1603 VGND VPWR sky130_fd_sc_hd__tapvpwrvgnd_1
X_7140_ _3512_ VGND VGND VPWR VPWR _0119_ sky130_fd_sc_hd__clkbuf_1
X_4352_ _1063_ VGND VGND VPWR VPWR _1141_ sky130_fd_sc_hd__buf_4
X_7071_ net248 _3371_ _3471_ VGND VGND VPWR VPWR _3476_ sky130_fd_sc_hd__mux2_1
X_4283_ _1070_ _1071_ _1059_ VGND VGND VPWR VPWR _1072_ sky130_fd_sc_hd__mux2_1
X_6022_ _1964_ _2772_ VGND VGND VPWR VPWR _2791_ sky130_fd_sc_hd__or2_1
X_7973_ _3955_ VGND VGND VPWR VPWR _0509_ sky130_fd_sc_hd__clkbuf_1
X_6924_ net136 _3385_ _3343_ VGND VGND VPWR VPWR _3386_ sky130_fd_sc_hd__mux2_1
XFILLER_0_89_594 VPWR VGND VPWR VGND sky130_ef_sc_hd__decap_12
XFILLER_0_76_277 VGND VGND VPWR VPWR sky130_fd_sc_hd__fill_1
X_6855_ _3346_ VGND VGND VPWR VPWR _0000_ sky130_fd_sc_hd__clkbuf_1
XFILLER_0_9_522 VGND VGND VPWR VPWR sky130_fd_sc_hd__fill_1
X_5806_ _2021_ _2585_ VGND VGND VPWR VPWR _2587_ sky130_fd_sc_hd__nand2_1
X_6786_ _3309_ VGND VGND VPWR VPWR _0992_ sky130_fd_sc_hd__clkbuf_1
Xclkbuf_leaf_67_CLK clknet_3_7__leaf_CLK VGND VGND VPWR VPWR clknet_leaf_67_CLK sky130_fd_sc_hd__clkbuf_8
X_5737_ _2505_ _2507_ _2514_ _2520_ VGND VGND VPWR VPWR net76 sky130_fd_sc_hd__a211o_1
XTAP_TAPCELL_ROW_79_1200 VGND VPWR sky130_fd_sc_hd__tapvpwrvgnd_1
XFILLER_0_72_450 VGND VGND VPWR VPWR sky130_fd_sc_hd__fill_1
XFILLER_0_17_355 VGND VGND VPWR VPWR sky130_fd_sc_hd__fill_2
X_8525_ clknet_leaf_95_CLK _0782_ VGND VGND VPWR VPWR RF.reg_arr\[1\]\[15\] sky130_fd_sc_hd__dfxtp_1
XFILLER_0_115_541 VPWR VGND VPWR VGND sky130_ef_sc_hd__decap_12
X_8456_ _2977_ VGND VGND VPWR VPWR _4211_ sky130_fd_sc_hd__clkbuf_8
XFILLER_0_44_152 VGND VGND VPWR VPWR sky130_fd_sc_hd__fill_2
XFILLER_0_115_585 VPWR VGND VPWR VGND sky130_ef_sc_hd__decap_12
X_7407_ _3654_ VGND VGND VPWR VPWR _0244_ sky130_fd_sc_hd__clkbuf_1
X_5668_ _1829_ _1736_ _1112_ _2447_ VGND VGND VPWR VPWR _2454_ sky130_fd_sc_hd__a31o_1
XTAP_TAPCELL_ROW_20_489 VGND VPWR sky130_fd_sc_hd__tapvpwrvgnd_1
X_5599_ _1700_ _2084_ VGND VGND VPWR VPWR _2387_ sky130_fd_sc_hd__or2_1
X_4619_ RF.reg_arr\[12\]\[7\] RF.reg_arr\[13\]\[7\] RF.reg_arr\[14\]\[7\] RF.reg_arr\[15\]\[7\]
+ _1051_ _1053_ VGND VGND VPWR VPWR _1408_ sky130_fd_sc_hd__mux4_1
X_8387_ _4175_ VGND VGND VPWR VPWR _0703_ sky130_fd_sc_hd__clkbuf_1
XFILLER_0_102_257 VGND VGND VPWR VPWR sky130_fd_sc_hd__fill_1
X_7338_ _3103_ net321 _3616_ VGND VGND VPWR VPWR _3618_ sky130_fd_sc_hd__mux2_1
XFILLER_0_13_572 VGND VGND VPWR VPWR sky130_fd_sc_hd__decap_3
Xhold462 RF.reg_arr\[5\]\[14\] VGND VGND VPWR VPWR net544 sky130_fd_sc_hd__dlygate4sd3_1
Xhold440 RF.reg_arr\[1\]\[12\] VGND VGND VPWR VPWR net522 sky130_fd_sc_hd__dlygate4sd3_1
Xhold451 RF.reg_arr\[6\]\[11\] VGND VGND VPWR VPWR net533 sky130_fd_sc_hd__dlygate4sd3_1
Xhold473 RF.reg_arr\[27\]\[23\] VGND VGND VPWR VPWR net555 sky130_fd_sc_hd__dlygate4sd3_1
X_7269_ _3581_ VGND VGND VPWR VPWR _0179_ sky130_fd_sc_hd__clkbuf_1
Xhold495 RF.reg_arr\[19\]\[16\] VGND VGND VPWR VPWR net577 sky130_fd_sc_hd__dlygate4sd3_1
Xhold484 RF.reg_arr\[19\]\[17\] VGND VGND VPWR VPWR net566 sky130_fd_sc_hd__dlygate4sd3_1
X_9008_ clknet_leaf_0_CLK _0241_ VGND VGND VPWR VPWR RF.reg_arr\[27\]\[18\] sky130_fd_sc_hd__dfxtp_1
XFILLER_0_87_509 VGND VGND VPWR VPWR sky130_fd_sc_hd__fill_1
XTAP_TAPCELL_ROW_28_589 VGND VPWR sky130_fd_sc_hd__tapvpwrvgnd_1
XPHY_EDGE_ROW_109_Left_226 VGND VGND VPWR VPWR sky130_fd_sc_hd__decap_3
XFILLER_0_67_266 VGND VGND VPWR VPWR sky130_fd_sc_hd__decap_4
XFILLER_0_55_417 VGND VGND VPWR VPWR sky130_fd_sc_hd__fill_1
Xclkbuf_leaf_58_CLK clknet_3_7__leaf_CLK VGND VGND VPWR VPWR clknet_leaf_58_CLK sky130_fd_sc_hd__clkbuf_8
XFILLER_0_36_620 VGND VGND VPWR VPWR sky130_fd_sc_hd__fill_1
XFILLER_0_51_612 VGND VGND VPWR VPWR sky130_fd_sc_hd__decap_4
XFILLER_0_106_563 VGND VGND VPWR VPWR sky130_fd_sc_hd__fill_1
Xclkload18 clknet_leaf_21_CLK VGND VGND VPWR VPWR clkload18/Y sky130_fd_sc_hd__inv_8
Xclkload29 clknet_leaf_104_CLK VGND VGND VPWR VPWR clkload29/Y sky130_fd_sc_hd__clkinv_4
XFILLER_0_23_358 VGND VGND VPWR VPWR sky130_fd_sc_hd__decap_3
XTAP_TAPCELL_ROW_47_810 VGND VPWR sky130_fd_sc_hd__tapvpwrvgnd_1
XTAP_TAPCELL_ROW_47_821 VGND VPWR sky130_fd_sc_hd__tapvpwrvgnd_1
XFILLER_0_116_89 VGND VGND VPWR VPWR sky130_fd_sc_hd__decap_6
X_4970_ _1757_ _1758_ _1613_ VGND VGND VPWR VPWR _1759_ sky130_fd_sc_hd__mux2_1
XTAP_TAPCELL_ROW_63_1012 VGND VPWR sky130_fd_sc_hd__tapvpwrvgnd_1
XFILLER_0_19_609 VGND VGND VPWR VPWR sky130_fd_sc_hd__decap_6
Xclkbuf_leaf_49_CLK clknet_3_6__leaf_CLK VGND VGND VPWR VPWR clknet_leaf_49_CLK sky130_fd_sc_hd__clkbuf_8
X_6640_ net535 _2992_ _3195_ VGND VGND VPWR VPWR _3230_ sky130_fd_sc_hd__mux2_1
XFILLER_0_73_225 VGND VGND VPWR VPWR sky130_fd_sc_hd__decap_6
XFILLER_0_73_258 VGND VGND VPWR VPWR sky130_fd_sc_hd__decap_4
X_6571_ _3193_ VGND VGND VPWR VPWR _0893_ sky130_fd_sc_hd__clkbuf_1
XFILLER_0_6_525 VGND VGND VPWR VPWR sky130_fd_sc_hd__decap_6
X_8310_ net195 _3381_ _4124_ VGND VGND VPWR VPWR _4134_ sky130_fd_sc_hd__mux2_1
X_5522_ _1667_ _2310_ VGND VGND VPWR VPWR _2311_ sky130_fd_sc_hd__nand2_1
X_9290_ clknet_leaf_99_CLK _0523_ VGND VGND VPWR VPWR RF.reg_arr\[25\]\[12\] sky130_fd_sc_hd__dfxtp_1
X_8241_ _4097_ VGND VGND VPWR VPWR _0635_ sky130_fd_sc_hd__clkbuf_1
XFILLER_0_112_511 VGND VGND VPWR VPWR sky130_fd_sc_hd__fill_2
X_5453_ RF.reg_arr\[24\]\[7\] RF.reg_arr\[25\]\[7\] RF.reg_arr\[26\]\[7\] RF.reg_arr\[27\]\[7\]
+ _1675_ _1681_ VGND VGND VPWR VPWR _2242_ sky130_fd_sc_hd__mux4_1
X_8172_ net327 _3379_ _4052_ VGND VGND VPWR VPWR _4061_ sky130_fd_sc_hd__mux2_1
X_4404_ RF.reg_arr\[20\]\[18\] RF.reg_arr\[21\]\[18\] RF.reg_arr\[22\]\[18\] RF.reg_arr\[23\]\[18\]
+ _1187_ _1189_ VGND VGND VPWR VPWR _1193_ sky130_fd_sc_hd__mux4_1
X_5384_ _2171_ _2172_ _1610_ VGND VGND VPWR VPWR _2173_ sky130_fd_sc_hd__mux2_1
XTAP_TAPCELL_ROW_74_1141 VGND VPWR sky130_fd_sc_hd__tapvpwrvgnd_1
XFILLER_0_22_391 VGND VGND VPWR VPWR sky130_fd_sc_hd__decap_3
X_4335_ RF.reg_arr\[24\]\[16\] RF.reg_arr\[25\]\[16\] RF.reg_arr\[26\]\[16\] RF.reg_arr\[27\]\[16\]
+ _1117_ _1118_ VGND VGND VPWR VPWR _1124_ sky130_fd_sc_hd__mux4_1
X_7123_ _3503_ VGND VGND VPWR VPWR _0111_ sky130_fd_sc_hd__clkbuf_1
XFILLER_0_10_586 VGND VGND VPWR VPWR sky130_fd_sc_hd__fill_2
X_7054_ net577 _3422_ _3460_ VGND VGND VPWR VPWR _3467_ sky130_fd_sc_hd__mux2_1
X_4266_ net7 VGND VGND VPWR VPWR _1055_ sky130_fd_sc_hd__inv_2
X_6005_ _2773_ _2774_ VGND VGND VPWR VPWR _2775_ sky130_fd_sc_hd__xnor2_1
XFILLER_0_89_391 VGND VGND VPWR VPWR sky130_fd_sc_hd__fill_1
X_7956_ _3044_ net963 _3944_ VGND VGND VPWR VPWR _3947_ sky130_fd_sc_hd__mux2_1
X_6907_ _3374_ VGND VGND VPWR VPWR _0024_ sky130_fd_sc_hd__clkbuf_1
X_7887_ _3910_ VGND VGND VPWR VPWR _0468_ sky130_fd_sc_hd__clkbuf_1
XTAP_TAPCELL_ROW_85_1270 VGND VPWR sky130_fd_sc_hd__tapvpwrvgnd_1
XTAP_TAPCELL_ROW_25_548 VGND VPWR sky130_fd_sc_hd__tapvpwrvgnd_1
X_6838_ _3336_ VGND VGND VPWR VPWR _1017_ sky130_fd_sc_hd__clkbuf_1
XFILLER_0_64_214 VGND VGND VPWR VPWR sky130_fd_sc_hd__fill_1
XFILLER_0_92_545 VGND VGND VPWR VPWR sky130_fd_sc_hd__decap_8
XFILLER_0_18_631 VGND VGND VPWR VPWR sky130_fd_sc_hd__fill_1
X_6769_ _3299_ VGND VGND VPWR VPWR _0985_ sky130_fd_sc_hd__clkbuf_1
X_8508_ clknet_leaf_24_CLK _0765_ VGND VGND VPWR VPWR RF.reg_arr\[10\]\[30\] sky130_fd_sc_hd__dfxtp_1
XFILLER_0_17_185 VGND VGND VPWR VPWR sky130_fd_sc_hd__decap_8
X_9488_ clknet_leaf_3_CLK _0721_ VGND VGND VPWR VPWR RF.reg_arr\[11\]\[18\] sky130_fd_sc_hd__dfxtp_1
X_8439_ _4202_ VGND VGND VPWR VPWR _0728_ sky130_fd_sc_hd__clkbuf_1
XFILLER_0_103_577 VGND VGND VPWR VPWR sky130_fd_sc_hd__fill_2
Xhold270 RF.reg_arr\[20\]\[13\] VGND VGND VPWR VPWR net352 sky130_fd_sc_hd__dlygate4sd3_1
Xhold281 RF.reg_arr\[6\]\[10\] VGND VGND VPWR VPWR net363 sky130_fd_sc_hd__dlygate4sd3_1
Xhold292 RF.reg_arr\[9\]\[10\] VGND VGND VPWR VPWR net374 sky130_fd_sc_hd__dlygate4sd3_1
XFILLER_0_99_122 VGND VGND VPWR VPWR sky130_fd_sc_hd__decap_4
XFILLER_0_95_350 VGND VGND VPWR VPWR sky130_fd_sc_hd__decap_3
XFILLER_0_83_512 VGND VGND VPWR VPWR sky130_fd_sc_hd__fill_1
XFILLER_0_55_225 VGND VGND VPWR VPWR sky130_fd_sc_hd__fill_1
XTAP_TAPCELL_ROW_99_1439 VGND VPWR sky130_fd_sc_hd__tapvpwrvgnd_1
XFILLER_0_106_360 VGND VGND VPWR VPWR sky130_fd_sc_hd__fill_1
XFILLER_0_63_291 VGND VGND VPWR VPWR sky130_fd_sc_hd__decap_4
XFILLER_0_11_45 VGND VGND VPWR VPWR sky130_fd_sc_hd__decap_3
XPHY_EDGE_ROW_116_Right_116 VGND VGND VPWR VPWR sky130_fd_sc_hd__decap_3
XFILLER_0_11_306 VGND VGND VPWR VPWR sky130_fd_sc_hd__decap_4
XFILLER_0_24_689 VGND VGND VPWR VPWR sky130_fd_sc_hd__decap_3
Xinput5 A1[4] VGND VGND VPWR VPWR net5 sky130_fd_sc_hd__clkbuf_4
XTAP_TAPCELL_ROW_108_1546 VGND VPWR sky130_fd_sc_hd__tapvpwrvgnd_1
X_7810_ _3096_ net441 _3860_ VGND VGND VPWR VPWR _3869_ sky130_fd_sc_hd__mux2_1
X_8790_ clknet_leaf_49_CLK _0023_ VGND VGND VPWR VPWR RF.reg_arr\[5\]\[24\] sky130_fd_sc_hd__dfxtp_1
X_4953_ RF.reg_arr\[28\]\[26\] RF.reg_arr\[29\]\[26\] RF.reg_arr\[30\]\[26\] RF.reg_arr\[31\]\[26\]
+ _1668_ _1669_ VGND VGND VPWR VPWR _1742_ sky130_fd_sc_hd__mux4_1
X_7741_ _3832_ VGND VGND VPWR VPWR _0400_ sky130_fd_sc_hd__clkbuf_1
XFILLER_0_74_512 VGND VGND VPWR VPWR sky130_fd_sc_hd__decap_4
XFILLER_0_74_501 VGND VGND VPWR VPWR sky130_fd_sc_hd__fill_2
XFILLER_0_59_597 VGND VGND VPWR VPWR sky130_fd_sc_hd__fill_1
X_7672_ _3094_ net1047 _3788_ VGND VGND VPWR VPWR _3796_ sky130_fd_sc_hd__mux2_1
X_4884_ RF.reg_arr\[28\]\[29\] RF.reg_arr\[29\]\[29\] RF.reg_arr\[30\]\[29\] RF.reg_arr\[31\]\[29\]
+ _1668_ _1669_ VGND VGND VPWR VPWR _1673_ sky130_fd_sc_hd__mux4_1
XFILLER_0_74_545 VGND VGND VPWR VPWR sky130_fd_sc_hd__fill_1
X_6623_ _3221_ VGND VGND VPWR VPWR _0917_ sky130_fd_sc_hd__clkbuf_1
XTAP_TAPCELL_ROW_22_518 VGND VPWR sky130_fd_sc_hd__tapvpwrvgnd_1
X_9411_ clknet_leaf_73_CLK _0644_ VGND VGND VPWR VPWR RF.reg_arr\[17\]\[5\] sky130_fd_sc_hd__dfxtp_1
XTAP_TAPCELL_ROW_50_849 VGND VPWR sky130_fd_sc_hd__tapvpwrvgnd_1
XFILLER_0_116_113 VGND VGND VPWR VPWR sky130_fd_sc_hd__decap_6
XFILLER_0_74_589 VPWR VGND VPWR VGND sky130_ef_sc_hd__decap_12
XFILLER_0_15_612 VGND VGND VPWR VPWR sky130_fd_sc_hd__decap_4
XFILLER_0_116_179 VGND VGND VPWR VPWR sky130_fd_sc_hd__fill_1
X_6554_ net598 _3044_ _3182_ VGND VGND VPWR VPWR _3185_ sky130_fd_sc_hd__mux2_1
X_9342_ clknet_leaf_71_CLK _0575_ VGND VGND VPWR VPWR RF.reg_arr\[18\]\[0\] sky130_fd_sc_hd__dfxtp_1
XFILLER_0_54_280 VGND VGND VPWR VPWR sky130_fd_sc_hd__fill_2
X_9273_ clknet_leaf_33_CLK _0506_ VGND VGND VPWR VPWR RF.reg_arr\[21\]\[27\] sky130_fd_sc_hd__dfxtp_1
X_5505_ RF.reg_arr\[20\]\[2\] RF.reg_arr\[21\]\[2\] RF.reg_arr\[22\]\[2\] RF.reg_arr\[23\]\[2\]
+ _1588_ _1679_ VGND VGND VPWR VPWR _2294_ sky130_fd_sc_hd__mux4_1
X_6485_ _3147_ VGND VGND VPWR VPWR _0853_ sky130_fd_sc_hd__clkbuf_1
XFILLER_0_112_330 VGND VGND VPWR VPWR sky130_fd_sc_hd__decap_8
X_8224_ _3039_ net308 _4088_ VGND VGND VPWR VPWR _4089_ sky130_fd_sc_hd__mux2_1
X_5436_ _2221_ _2224_ _1844_ VGND VGND VPWR VPWR _2225_ sky130_fd_sc_hd__mux2_1
XFILLER_0_30_637 VGND VGND VPWR VPWR sky130_fd_sc_hd__decap_6
XFILLER_0_42_475 VGND VGND VPWR VPWR sky130_fd_sc_hd__fill_1
XFILLER_0_2_583 VGND VGND VPWR VPWR sky130_fd_sc_hd__decap_4
XFILLER_0_30_659 VGND VGND VPWR VPWR sky130_fd_sc_hd__fill_1
X_8155_ _4029_ VGND VGND VPWR VPWR _4052_ sky130_fd_sc_hd__clkbuf_8
X_5367_ _2150_ _2152_ _2155_ _1635_ _1585_ VGND VGND VPWR VPWR _2156_ sky130_fd_sc_hd__a221o_1
X_5298_ _2030_ VGND VGND VPWR VPWR _2087_ sky130_fd_sc_hd__buf_4
X_8086_ _4015_ VGND VGND VPWR VPWR _0562_ sky130_fd_sc_hd__clkbuf_1
X_7106_ _3494_ VGND VGND VPWR VPWR _0103_ sky130_fd_sc_hd__clkbuf_1
X_4318_ RF.reg_arr\[4\]\[0\] RF.reg_arr\[5\]\[0\] RF.reg_arr\[6\]\[0\] RF.reg_arr\[7\]\[0\]
+ _1105_ _1106_ VGND VGND VPWR VPWR _1107_ sky130_fd_sc_hd__mux4_1
X_7037_ net775 _3405_ _3449_ VGND VGND VPWR VPWR _3458_ sky130_fd_sc_hd__mux2_1
X_4249_ _1036_ _1037_ _1034_ VGND VGND VPWR VPWR _1038_ sky130_fd_sc_hd__mux2_1
XTAP_TAPCELL_ROW_58_949 VGND VPWR sky130_fd_sc_hd__tapvpwrvgnd_1
XFILLER_0_96_136 VGND VGND VPWR VPWR sky130_fd_sc_hd__decap_4
X_8988_ clknet_leaf_21_CLK _0221_ VGND VGND VPWR VPWR RF.reg_arr\[31\]\[30\] sky130_fd_sc_hd__dfxtp_1
XTAP_TAPCELL_ROW_2_276 VGND VPWR sky130_fd_sc_hd__tapvpwrvgnd_1
X_7939_ _3027_ net469 _3933_ VGND VGND VPWR VPWR _3938_ sky130_fd_sc_hd__mux2_1
XFILLER_0_37_225 VGND VGND VPWR VPWR sky130_fd_sc_hd__fill_1
XFILLER_0_108_614 VGND VGND VPWR VPWR sky130_fd_sc_hd__decap_3
XFILLER_0_107_113 VGND VGND VPWR VPWR sky130_fd_sc_hd__fill_1
XFILLER_0_9_193 VGND VGND VPWR VPWR sky130_fd_sc_hd__decap_4
XFILLER_0_25_409 VGND VGND VPWR VPWR sky130_fd_sc_hd__fill_2
XFILLER_0_80_537 VGND VGND VPWR VPWR sky130_fd_sc_hd__decap_6
XFILLER_0_116_691 VGND VGND VPWR VPWR sky130_fd_sc_hd__fill_1
XFILLER_0_33_475 VGND VGND VPWR VPWR sky130_fd_sc_hd__fill_1
XFILLER_0_87_125 VGND VGND VPWR VPWR sky130_fd_sc_hd__fill_1
XFILLER_0_87_169 VGND VGND VPWR VPWR sky130_fd_sc_hd__decap_6
XTAP_TAPCELL_ROW_103_1487 VGND VPWR sky130_fd_sc_hd__tapvpwrvgnd_1
XFILLER_0_113_57 VGND VGND VPWR VPWR sky130_fd_sc_hd__fill_2
XFILLER_0_98_15 VGND VGND VPWR VPWR sky130_fd_sc_hd__fill_2
XFILLER_0_43_228 VGND VGND VPWR VPWR sky130_fd_sc_hd__fill_1
XFILLER_0_107_691 VGND VGND VPWR VPWR sky130_fd_sc_hd__fill_1
XFILLER_0_106_190 VGND VGND VPWR VPWR sky130_fd_sc_hd__fill_1
XFILLER_0_3_358 VGND VGND VPWR VPWR sky130_fd_sc_hd__decap_6
XFILLER_0_24_475 VGND VGND VPWR VPWR sky130_fd_sc_hd__fill_1
XFILLER_0_11_136 VGND VGND VPWR VPWR sky130_fd_sc_hd__fill_2
X_6270_ net43 VGND VGND VPWR VPWR _3012_ sky130_fd_sc_hd__buf_2
XTAP_TAPCELL_ROW_71_1100 VGND VPWR sky130_fd_sc_hd__tapvpwrvgnd_1
XFILLER_0_11_169 VGND VGND VPWR VPWR sky130_fd_sc_hd__decap_3
X_5221_ RF.reg_arr\[16\]\[3\] RF.reg_arr\[17\]\[3\] RF.reg_arr\[18\]\[3\] RF.reg_arr\[19\]\[3\]
+ _1229_ _1230_ VGND VGND VPWR VPWR _2010_ sky130_fd_sc_hd__mux4_1
X_5152_ RF.reg_arr\[0\]\[18\] RF.reg_arr\[1\]\[18\] RF.reg_arr\[2\]\[18\] RF.reg_arr\[3\]\[18\]
+ _1624_ _1597_ VGND VGND VPWR VPWR _1941_ sky130_fd_sc_hd__mux4_1
X_5083_ RF.reg_arr\[28\]\[23\] RF.reg_arr\[29\]\[23\] RF.reg_arr\[30\]\[23\] RF.reg_arr\[31\]\[23\]
+ _1676_ _1682_ VGND VGND VPWR VPWR _1872_ sky130_fd_sc_hd__mux4_1
XFILLER_0_79_615 VGND VGND VPWR VPWR sky130_fd_sc_hd__fill_1
X_8911_ clknet_leaf_1_CLK _0144_ VGND VGND VPWR VPWR RF.reg_arr\[7\]\[17\] sky130_fd_sc_hd__dfxtp_1
XTAP_TAPCELL_ROW_55_908 VGND VPWR sky130_fd_sc_hd__tapvpwrvgnd_1
XFILLER_0_79_659 VGND VGND VPWR VPWR sky130_fd_sc_hd__fill_2
X_8842_ clknet_leaf_99_CLK _0075_ VGND VGND VPWR VPWR RF.reg_arr\[19\]\[12\] sky130_fd_sc_hd__dfxtp_1
XTAP_TAPCELL_ROW_69_1084 VGND VPWR sky130_fd_sc_hd__tapvpwrvgnd_1
X_8773_ clknet_leaf_89_CLK _0006_ VGND VGND VPWR VPWR RF.reg_arr\[5\]\[7\] sky130_fd_sc_hd__dfxtp_1
X_5985_ _2687_ _2755_ _2003_ VGND VGND VPWR VPWR _2756_ sky130_fd_sc_hd__mux2_1
XTAP_TAPCELL_ROW_82_1240 VGND VPWR sky130_fd_sc_hd__tapvpwrvgnd_1
X_7724_ _3823_ VGND VGND VPWR VPWR _0392_ sky130_fd_sc_hd__clkbuf_1
X_4936_ RF.reg_arr\[24\]\[1\] RF.reg_arr\[25\]\[1\] RF.reg_arr\[26\]\[1\] RF.reg_arr\[27\]\[1\]
+ _1262_ _1045_ VGND VGND VPWR VPWR _1725_ sky130_fd_sc_hd__mux4_1
XFILLER_0_19_225 VGND VGND VPWR VPWR sky130_fd_sc_hd__fill_1
XTAP_TAPCELL_ROW_35_676 VGND VPWR sky130_fd_sc_hd__tapvpwrvgnd_1
XFILLER_0_47_545 VGND VGND VPWR VPWR sky130_fd_sc_hd__fill_2
XANTENNA_10 _1696_ VGND VGND VPWR VPWR sky130_fd_sc_hd__diode_2
X_4867_ RF.reg_arr\[12\]\[30\] RF.reg_arr\[13\]\[30\] RF.reg_arr\[14\]\[30\] RF.reg_arr\[15\]\[30\]
+ _1593_ _1600_ VGND VGND VPWR VPWR _1656_ sky130_fd_sc_hd__mux4_1
XFILLER_0_62_515 VGND VGND VPWR VPWR sky130_fd_sc_hd__fill_1
X_7655_ _3077_ net913 _3777_ VGND VGND VPWR VPWR _3787_ sky130_fd_sc_hd__mux2_1
XANTENNA_21 net5 VGND VGND VPWR VPWR sky130_fd_sc_hd__diode_2
XFILLER_0_105_617 VGND VGND VPWR VPWR sky130_fd_sc_hd__fill_1
XFILLER_0_74_386 VGND VGND VPWR VPWR sky130_fd_sc_hd__fill_1
XFILLER_0_6_141 VGND VGND VPWR VPWR sky130_fd_sc_hd__fill_1
X_6606_ _3212_ VGND VGND VPWR VPWR _0909_ sky130_fd_sc_hd__clkbuf_1
X_7586_ _3750_ VGND VGND VPWR VPWR _0327_ sky130_fd_sc_hd__clkbuf_1
X_9325_ clknet_leaf_104_CLK _0558_ VGND VGND VPWR VPWR RF.reg_arr\[20\]\[15\] sky130_fd_sc_hd__dfxtp_1
X_6537_ net830 _3027_ _3171_ VGND VGND VPWR VPWR _3176_ sky130_fd_sc_hd__mux2_1
XFILLER_0_6_163 VGND VGND VPWR VPWR sky130_fd_sc_hd__decap_8
X_4798_ _1586_ VGND VGND VPWR VPWR _1587_ sky130_fd_sc_hd__buf_4
XFILLER_0_113_650 VPWR VGND VPWR VGND sky130_ef_sc_hd__decap_12
X_6468_ net121 VGND VGND VPWR VPWR _3139_ sky130_fd_sc_hd__clkbuf_1
X_9256_ clknet_leaf_10_CLK _0489_ VGND VGND VPWR VPWR RF.reg_arr\[21\]\[10\] sky130_fd_sc_hd__dfxtp_1
XFILLER_0_112_182 VGND VGND VPWR VPWR sky130_fd_sc_hd__decap_6
X_8207_ _3023_ net820 _4077_ VGND VGND VPWR VPWR _4080_ sky130_fd_sc_hd__mux2_1
X_6399_ _3097_ VGND VGND VPWR VPWR _0817_ sky130_fd_sc_hd__clkbuf_1
X_9187_ clknet_leaf_74_CLK _0420_ VGND VGND VPWR VPWR RF.reg_arr\[24\]\[5\] sky130_fd_sc_hd__dfxtp_1
X_5419_ RF.reg_arr\[8\]\[4\] RF.reg_arr\[9\]\[4\] RF.reg_arr\[10\]\[4\] RF.reg_arr\[11\]\[4\]
+ _1589_ _1834_ VGND VGND VPWR VPWR _2208_ sky130_fd_sc_hd__mux4_1
X_8138_ _4043_ VGND VGND VPWR VPWR _0586_ sky130_fd_sc_hd__clkbuf_1
XTAP_TAPCELL_ROW_7_335 VGND VPWR sky130_fd_sc_hd__tapvpwrvgnd_1
X_8069_ _3021_ net594 _4005_ VGND VGND VPWR VPWR _4007_ sky130_fd_sc_hd__mux2_1
XFILLER_0_97_434 VGND VGND VPWR VPWR sky130_fd_sc_hd__decap_3
XFILLER_0_97_478 VPWR VGND VPWR VGND sky130_ef_sc_hd__decap_12
XFILLER_0_97_467 VGND VGND VPWR VPWR sky130_fd_sc_hd__fill_1
XFILLER_0_69_158 VGND VGND VPWR VPWR sky130_fd_sc_hd__fill_1
XFILLER_0_85_629 VGND VGND VPWR VPWR sky130_fd_sc_hd__decap_8
XFILLER_0_38_556 VGND VGND VPWR VPWR sky130_fd_sc_hd__fill_1
XFILLER_0_93_684 VGND VGND VPWR VPWR sky130_fd_sc_hd__fill_2
XFILLER_0_93_673 VGND VGND VPWR VPWR sky130_fd_sc_hd__fill_2
XTAP_TAPCELL_ROW_96_1409 VGND VPWR sky130_fd_sc_hd__tapvpwrvgnd_1
XFILLER_0_21_401 VGND VGND VPWR VPWR sky130_fd_sc_hd__fill_1
XFILLER_0_21_445 VGND VGND VPWR VPWR sky130_fd_sc_hd__decap_3
XFILLER_0_88_401 VGND VGND VPWR VPWR sky130_fd_sc_hd__fill_2
XFILLER_0_17_55 VGND VGND VPWR VPWR sky130_fd_sc_hd__fill_1
XTAP_TAPCELL_ROW_105_1516 VGND VPWR sky130_fd_sc_hd__tapvpwrvgnd_1
XFILLER_0_76_607 VPWR VGND VPWR VGND sky130_ef_sc_hd__decap_12
XFILLER_0_48_309 VGND VGND VPWR VPWR sky130_fd_sc_hd__fill_2
XFILLER_0_29_501 VGND VGND VPWR VPWR sky130_fd_sc_hd__decap_3
X_5770_ _2551_ VGND VGND VPWR VPWR _2552_ sky130_fd_sc_hd__inv_2
XFILLER_0_84_684 VGND VGND VPWR VPWR sky130_fd_sc_hd__fill_2
XFILLER_0_84_651 VGND VGND VPWR VPWR sky130_fd_sc_hd__fill_1
XTAP_TAPCELL_ROW_60_966 VGND VPWR sky130_fd_sc_hd__tapvpwrvgnd_1
XTAP_TAPCELL_ROW_32_635 VGND VPWR sky130_fd_sc_hd__tapvpwrvgnd_1
X_4721_ _1508_ _1509_ _1049_ VGND VGND VPWR VPWR _1510_ sky130_fd_sc_hd__mux2_1
X_4652_ _1296_ _1440_ _1173_ VGND VGND VPWR VPWR _1441_ sky130_fd_sc_hd__a21o_1
XTAP_TAPCELL_ROW_60_977 VGND VPWR sky130_fd_sc_hd__tapvpwrvgnd_1
X_7440_ _3672_ VGND VGND VPWR VPWR _0259_ sky130_fd_sc_hd__clkbuf_1
Xinput30 WD3[24] VGND VGND VPWR VPWR net30 sky130_fd_sc_hd__buf_1
XFILLER_0_3_100 VPWR VGND VPWR VGND sky130_ef_sc_hd__decap_12
X_9110_ clknet_leaf_54_CLK _0343_ VGND VGND VPWR VPWR RF.reg_arr\[2\]\[24\] sky130_fd_sc_hd__dfxtp_1
X_4583_ RF.reg_arr\[16\]\[22\] RF.reg_arr\[17\]\[22\] RF.reg_arr\[18\]\[22\] RF.reg_arr\[19\]\[22\]
+ _1082_ _1084_ VGND VGND VPWR VPWR _1372_ sky130_fd_sc_hd__mux4_1
XFILLER_0_12_412 VGND VGND VPWR VPWR sky130_fd_sc_hd__decap_8
XTAP_TAPCELL_ROW_12_392 VGND VPWR sky130_fd_sc_hd__tapvpwrvgnd_1
X_7371_ _3635_ VGND VGND VPWR VPWR _0227_ sky130_fd_sc_hd__clkbuf_1
XFILLER_0_4_645 VGND VGND VPWR VPWR sky130_fd_sc_hd__decap_6
Xhold803 RF.reg_arr\[28\]\[17\] VGND VGND VPWR VPWR net885 sky130_fd_sc_hd__dlygate4sd3_1
Xinput41 WD3[5] VGND VGND VPWR VPWR net41 sky130_fd_sc_hd__buf_1
XTAP_TAPCELL_ROW_116_1656 VGND VPWR sky130_fd_sc_hd__tapvpwrvgnd_1
XTAP_TAPCELL_ROW_116_1645 VGND VPWR sky130_fd_sc_hd__tapvpwrvgnd_1
X_6322_ _3047_ VGND VGND VPWR VPWR _0790_ sky130_fd_sc_hd__clkbuf_1
Xhold836 RF.reg_arr\[10\]\[20\] VGND VGND VPWR VPWR net918 sky130_fd_sc_hd__dlygate4sd3_1
Xhold825 RF.reg_arr\[30\]\[18\] VGND VGND VPWR VPWR net907 sky130_fd_sc_hd__dlygate4sd3_1
Xhold814 RF.reg_arr\[16\]\[19\] VGND VGND VPWR VPWR net896 sky130_fd_sc_hd__dlygate4sd3_1
XFILLER_0_110_620 VGND VGND VPWR VPWR sky130_fd_sc_hd__decap_6
Xhold847 RF.reg_arr\[20\]\[21\] VGND VGND VPWR VPWR net929 sky130_fd_sc_hd__dlygate4sd3_1
Xhold869 RF.reg_arr\[15\]\[21\] VGND VGND VPWR VPWR net951 sky130_fd_sc_hd__dlygate4sd3_1
X_6253_ net163 _3000_ _2998_ VGND VGND VPWR VPWR _3001_ sky130_fd_sc_hd__mux2_1
Xhold858 RF.reg_arr\[13\]\[8\] VGND VGND VPWR VPWR net940 sky130_fd_sc_hd__dlygate4sd3_1
X_9041_ clknet_leaf_4_CLK _0274_ VGND VGND VPWR VPWR RF.reg_arr\[26\]\[19\] sky130_fd_sc_hd__dfxtp_1
X_5204_ RF.reg_arr\[8\]\[17\] RF.reg_arr\[9\]\[17\] RF.reg_arr\[10\]\[17\] RF.reg_arr\[11\]\[17\]
+ _1947_ _1948_ VGND VGND VPWR VPWR _1993_ sky130_fd_sc_hd__mux4_1
X_6184_ _2276_ _2907_ _2943_ _2421_ VGND VGND VPWR VPWR _2944_ sky130_fd_sc_hd__o211a_1
XTAP_TAPCELL_ROW_4_305 VGND VPWR sky130_fd_sc_hd__tapvpwrvgnd_1
X_5135_ _1605_ _1923_ _1842_ VGND VGND VPWR VPWR _1924_ sky130_fd_sc_hd__o21a_1
X_5066_ _1852_ _1853_ _1854_ VGND VGND VPWR VPWR _1855_ sky130_fd_sc_hd__mux2_1
XFILLER_0_79_423 VGND VGND VPWR VPWR sky130_fd_sc_hd__fill_1
XFILLER_0_67_607 VGND VGND VPWR VPWR sky130_fd_sc_hd__decap_8
X_8825_ clknet_leaf_48_CLK _0058_ VGND VGND VPWR VPWR RF.reg_arr\[4\]\[27\] sky130_fd_sc_hd__dfxtp_1
X_5968_ _1161_ _2739_ VGND VGND VPWR VPWR _2740_ sky130_fd_sc_hd__xor2_2
X_8756_ clknet_leaf_45_CLK _1013_ VGND VGND VPWR VPWR RF.reg_arr\[6\]\[22\] sky130_fd_sc_hd__dfxtp_1
XFILLER_0_66_139 VGND VGND VPWR VPWR sky130_fd_sc_hd__fill_1
XFILLER_0_59_180 VGND VGND VPWR VPWR sky130_fd_sc_hd__fill_2
X_4919_ RF.reg_arr\[8\]\[28\] RF.reg_arr\[9\]\[28\] RF.reg_arr\[10\]\[28\] RF.reg_arr\[11\]\[28\]
+ _1678_ _1684_ VGND VGND VPWR VPWR _1708_ sky130_fd_sc_hd__mux4_1
X_7707_ net306 _3391_ _3813_ VGND VGND VPWR VPWR _3815_ sky130_fd_sc_hd__mux2_1
XFILLER_0_90_632 VGND VGND VPWR VPWR sky130_fd_sc_hd__fill_2
XFILLER_0_90_610 VGND VGND VPWR VPWR sky130_fd_sc_hd__decap_4
X_5899_ _2648_ _2653_ _2646_ VGND VGND VPWR VPWR _2675_ sky130_fd_sc_hd__a21oi_1
XFILLER_0_74_161 VGND VGND VPWR VPWR sky130_fd_sc_hd__decap_4
XFILLER_0_62_301 VGND VGND VPWR VPWR sky130_fd_sc_hd__fill_1
X_8687_ clknet_leaf_106_CLK _0944_ VGND VGND VPWR VPWR RF.reg_arr\[15\]\[17\] sky130_fd_sc_hd__dfxtp_1
X_7638_ _3778_ VGND VGND VPWR VPWR _0351_ sky130_fd_sc_hd__clkbuf_1
X_7569_ net813 _3387_ _3741_ VGND VGND VPWR VPWR _3742_ sky130_fd_sc_hd__mux2_1
X_9308_ clknet_leaf_22_CLK _0541_ VGND VGND VPWR VPWR RF.reg_arr\[25\]\[30\] sky130_fd_sc_hd__dfxtp_1
XFILLER_0_30_220 VGND VGND VPWR VPWR sky130_fd_sc_hd__fill_1
X_9239_ clknet_leaf_25_CLK _0472_ VGND VGND VPWR VPWR RF.reg_arr\[22\]\[25\] sky130_fd_sc_hd__dfxtp_1
XFILLER_0_101_664 VGND VGND VPWR VPWR sky130_fd_sc_hd__decap_3
XTAP_TAPCELL_ROW_91_1339 VGND VPWR sky130_fd_sc_hd__tapvpwrvgnd_1
XFILLER_0_30_275 VGND VGND VPWR VPWR sky130_fd_sc_hd__decap_4
XFILLER_0_66_651 VGND VGND VPWR VPWR sky130_fd_sc_hd__fill_2
XFILLER_0_26_504 VGND VGND VPWR VPWR sky130_fd_sc_hd__decap_6
XTAP_TAPCELL_ROW_100_1457 VGND VPWR sky130_fd_sc_hd__tapvpwrvgnd_1
XTAP_TAPCELL_ROW_100_1446 VGND VPWR sky130_fd_sc_hd__tapvpwrvgnd_1
XFILLER_0_81_621 VGND VGND VPWR VPWR sky130_fd_sc_hd__decap_3
XFILLER_0_81_665 VGND VGND VPWR VPWR sky130_fd_sc_hd__decap_3
XFILLER_0_81_643 VGND VGND VPWR VPWR sky130_fd_sc_hd__fill_1
XFILLER_0_53_334 VGND VGND VPWR VPWR sky130_fd_sc_hd__fill_2
XFILLER_0_53_367 VGND VGND VPWR VPWR sky130_fd_sc_hd__decap_8
XFILLER_0_80_197 VPWR VGND VPWR VGND sky130_ef_sc_hd__decap_12
XFILLER_0_0_136 VGND VGND VPWR VPWR sky130_fd_sc_hd__decap_4
XFILLER_0_28_21 VGND VGND VPWR VPWR sky130_fd_sc_hd__decap_4
XTAP_TAPCELL_ROW_111_1586 VGND VPWR sky130_fd_sc_hd__tapvpwrvgnd_1
X_6940_ net40 VGND VGND VPWR VPWR _3397_ sky130_fd_sc_hd__buf_2
XFILLER_0_88_253 VGND VGND VPWR VPWR sky130_fd_sc_hd__decap_8
XTAP_TAPCELL_ROW_66_1043 VGND VPWR sky130_fd_sc_hd__tapvpwrvgnd_1
X_6871_ _3354_ VGND VGND VPWR VPWR _0008_ sky130_fd_sc_hd__clkbuf_1
X_5822_ _2386_ _2489_ _2601_ _2051_ VGND VGND VPWR VPWR _2602_ sky130_fd_sc_hd__o22a_1
X_8610_ clknet_leaf_76_CLK _0867_ VGND VGND VPWR VPWR RF.reg_arr\[16\]\[4\] sky130_fd_sc_hd__dfxtp_1
XFILLER_0_8_203 VGND VGND VPWR VPWR sky130_fd_sc_hd__fill_1
XTAP_TAPCELL_ROW_17_451 VGND VPWR sky130_fd_sc_hd__tapvpwrvgnd_1
X_8541_ clknet_leaf_27_CLK _0798_ VGND VGND VPWR VPWR RF.reg_arr\[1\]\[31\] sky130_fd_sc_hd__dfxtp_1
X_5753_ _2533_ _2534_ _2535_ VGND VGND VPWR VPWR _2536_ sky130_fd_sc_hd__o21a_1
XTAP_TAPCELL_ROW_45_793 VGND VPWR sky130_fd_sc_hd__tapvpwrvgnd_1
X_4704_ _1491_ _1492_ _1042_ VGND VGND VPWR VPWR _1493_ sky130_fd_sc_hd__mux2_1
X_5684_ _2198_ _2467_ _2469_ VGND VGND VPWR VPWR _2470_ sky130_fd_sc_hd__a21oi_1
X_8472_ _4219_ VGND VGND VPWR VPWR _0744_ sky130_fd_sc_hd__clkbuf_1
X_7423_ _3662_ VGND VGND VPWR VPWR _0252_ sky130_fd_sc_hd__clkbuf_1
X_4635_ RF.reg_arr\[12\]\[27\] RF.reg_arr\[13\]\[27\] RF.reg_arr\[14\]\[27\] RF.reg_arr\[15\]\[27\]
+ _1316_ _1304_ VGND VGND VPWR VPWR _1424_ sky130_fd_sc_hd__mux4_1
X_7354_ _3119_ net932 _3616_ VGND VGND VPWR VPWR _3626_ sky130_fd_sc_hd__mux2_1
Xhold611 RF.reg_arr\[28\]\[25\] VGND VGND VPWR VPWR net693 sky130_fd_sc_hd__dlygate4sd3_1
X_4566_ _1353_ _1354_ _1034_ VGND VGND VPWR VPWR _1355_ sky130_fd_sc_hd__mux2_1
Xhold600 RF.reg_arr\[17\]\[31\] VGND VGND VPWR VPWR net682 sky130_fd_sc_hd__dlygate4sd3_1
XFILLER_0_8_53 VPWR VGND VPWR VGND sky130_ef_sc_hd__decap_12
Xhold633 RF.reg_arr\[15\]\[30\] VGND VGND VPWR VPWR net715 sky130_fd_sc_hd__dlygate4sd3_1
XTAP_TAPCELL_ROW_77_1172 VGND VPWR sky130_fd_sc_hd__tapvpwrvgnd_1
Xhold644 RF.reg_arr\[24\]\[14\] VGND VGND VPWR VPWR net726 sky130_fd_sc_hd__dlygate4sd3_1
X_6305_ net253 _3035_ _3019_ VGND VGND VPWR VPWR _3036_ sky130_fd_sc_hd__mux2_1
Xhold622 RF.reg_arr\[5\]\[8\] VGND VGND VPWR VPWR net704 sky130_fd_sc_hd__dlygate4sd3_1
XFILLER_0_40_562 VPWR VGND VPWR VGND sky130_ef_sc_hd__decap_12
X_7285_ _3589_ VGND VGND VPWR VPWR _0187_ sky130_fd_sc_hd__clkbuf_1
X_4497_ RF.reg_arr\[8\]\[28\] RF.reg_arr\[9\]\[28\] RF.reg_arr\[10\]\[28\] RF.reg_arr\[11\]\[28\]
+ _1274_ _1276_ VGND VGND VPWR VPWR _1286_ sky130_fd_sc_hd__mux4_1
Xhold655 RF.reg_arr\[23\]\[25\] VGND VGND VPWR VPWR net737 sky130_fd_sc_hd__dlygate4sd3_1
Xhold666 RF.reg_arr\[14\]\[25\] VGND VGND VPWR VPWR net748 sky130_fd_sc_hd__dlygate4sd3_1
Xhold677 RF.reg_arr\[29\]\[12\] VGND VGND VPWR VPWR net759 sky130_fd_sc_hd__dlygate4sd3_1
X_9024_ clknet_leaf_69_CLK _0257_ VGND VGND VPWR VPWR RF.reg_arr\[26\]\[2\] sky130_fd_sc_hd__dfxtp_1
Xhold688 RF.reg_arr\[14\]\[2\] VGND VGND VPWR VPWR net770 sky130_fd_sc_hd__dlygate4sd3_1
XFILLER_0_110_472 VGND VGND VPWR VPWR sky130_fd_sc_hd__fill_1
X_6236_ net35 VGND VGND VPWR VPWR _2988_ sky130_fd_sc_hd__buf_2
Xhold699 RF.reg_arr\[27\]\[21\] VGND VGND VPWR VPWR net781 sky130_fd_sc_hd__dlygate4sd3_1
X_6167_ _2421_ _2585_ VGND VGND VPWR VPWR _2928_ sky130_fd_sc_hd__nand2_2
XFILLER_0_85_60 VGND VGND VPWR VPWR sky130_fd_sc_hd__decap_4
X_5118_ RF.reg_arr\[4\]\[20\] RF.reg_arr\[5\]\[20\] RF.reg_arr\[6\]\[20\] RF.reg_arr\[7\]\[20\]
+ _1591_ _1878_ VGND VGND VPWR VPWR _1907_ sky130_fd_sc_hd__mux4_1
X_6098_ _2861_ _1789_ VGND VGND VPWR VPWR _2863_ sky130_fd_sc_hd__and2b_1
X_5049_ _1836_ _1837_ _1604_ VGND VGND VPWR VPWR _1838_ sky130_fd_sc_hd__mux2_1
X_8808_ clknet_leaf_63_CLK _0041_ VGND VGND VPWR VPWR RF.reg_arr\[4\]\[10\] sky130_fd_sc_hd__dfxtp_1
XFILLER_0_54_109 VGND VGND VPWR VPWR sky130_fd_sc_hd__fill_1
X_8739_ clknet_leaf_87_CLK _0996_ VGND VGND VPWR VPWR RF.reg_arr\[6\]\[5\] sky130_fd_sc_hd__dfxtp_1
Xclone11 _1026_ VGND VGND VPWR VPWR net93 sky130_fd_sc_hd__clkbuf_16
XFILLER_0_50_326 VGND VGND VPWR VPWR sky130_fd_sc_hd__decap_6
XTAP_TAPCELL_ROW_14_421 VGND VPWR sky130_fd_sc_hd__tapvpwrvgnd_1
XTAP_TAPCELL_ROW_42_752 VGND VPWR sky130_fd_sc_hd__tapvpwrvgnd_1
XFILLER_0_109_561 VGND VGND VPWR VPWR sky130_fd_sc_hd__decap_8
XFILLER_0_81_462 VGND VGND VPWR VPWR sky130_fd_sc_hd__fill_1
XFILLER_0_14_529 VGND VGND VPWR VPWR sky130_fd_sc_hd__decap_3
XFILLER_0_14_507 VGND VGND VPWR VPWR sky130_fd_sc_hd__decap_8
X_4420_ _1207_ _1208_ _1041_ VGND VGND VPWR VPWR _1209_ sky130_fd_sc_hd__mux2_1
XTAP_TAPCELL_ROW_113_1604 VGND VPWR sky130_fd_sc_hd__tapvpwrvgnd_1
XFILLER_0_111_225 VGND VGND VPWR VPWR sky130_fd_sc_hd__decap_4
XFILLER_0_1_445 VGND VGND VPWR VPWR sky130_fd_sc_hd__decap_3
X_4351_ _1138_ _1139_ _1049_ VGND VGND VPWR VPWR _1140_ sky130_fd_sc_hd__mux2_1
X_7070_ _3475_ VGND VGND VPWR VPWR _0086_ sky130_fd_sc_hd__clkbuf_1
X_4282_ RF.reg_arr\[28\]\[4\] RF.reg_arr\[29\]\[4\] RF.reg_arr\[30\]\[4\] RF.reg_arr\[31\]\[4\]
+ _1068_ _1069_ VGND VGND VPWR VPWR _1071_ sky130_fd_sc_hd__mux4_1
XFILLER_0_39_53 VGND VGND VPWR VPWR sky130_fd_sc_hd__decap_3
X_6021_ _1964_ _2772_ net1128 net82 VGND VGND VPWR VPWR _2790_ sky130_fd_sc_hd__a211o_1
XFILLER_0_39_86 VGND VGND VPWR VPWR sky130_fd_sc_hd__decap_3
X_7972_ _2990_ net286 _3921_ VGND VGND VPWR VPWR _3955_ sky130_fd_sc_hd__mux2_1
X_6923_ net38 VGND VGND VPWR VPWR _3385_ sky130_fd_sc_hd__buf_2
XFILLER_0_9_501 VGND VGND VPWR VPWR sky130_fd_sc_hd__decap_3
X_6854_ net138 _3000_ _3344_ VGND VGND VPWR VPWR _3346_ sky130_fd_sc_hd__mux2_1
X_5805_ _2050_ _2585_ VGND VGND VPWR VPWR _2586_ sky130_fd_sc_hd__nand2_2
X_6785_ net302 _3000_ _3307_ VGND VGND VPWR VPWR _3309_ sky130_fd_sc_hd__mux2_1
X_5736_ _2517_ _2518_ _2519_ VGND VGND VPWR VPWR _2520_ sky130_fd_sc_hd__o21a_1
X_8524_ clknet_leaf_96_CLK _0781_ VGND VGND VPWR VPWR RF.reg_arr\[1\]\[14\] sky130_fd_sc_hd__dfxtp_1
X_5667_ _2432_ _2444_ _2446_ _2453_ VGND VGND VPWR VPWR net71 sky130_fd_sc_hd__o2bb2a_1
XTAP_TAPCELL_ROW_79_1201 VGND VPWR sky130_fd_sc_hd__tapvpwrvgnd_1
X_8455_ _4210_ VGND VGND VPWR VPWR _0736_ sky130_fd_sc_hd__clkbuf_1
XFILLER_0_60_602 VGND VGND VPWR VPWR sky130_fd_sc_hd__decap_3
XFILLER_0_115_553 VGND VGND VPWR VPWR sky130_fd_sc_hd__decap_6
X_7406_ _3103_ net781 _3652_ VGND VGND VPWR VPWR _3654_ sky130_fd_sc_hd__mux2_1
X_4618_ RF.reg_arr\[8\]\[7\] RF.reg_arr\[9\]\[7\] RF.reg_arr\[10\]\[7\] RF.reg_arr\[11\]\[7\]
+ _1051_ _1053_ VGND VGND VPWR VPWR _1407_ sky130_fd_sc_hd__mux4_1
XFILLER_0_115_597 VPWR VGND VPWR VGND sky130_ef_sc_hd__decap_12
X_5598_ _2383_ _2385_ VGND VGND VPWR VPWR _2386_ sky130_fd_sc_hd__nand2_1
X_8386_ net402 _3387_ _4174_ VGND VGND VPWR VPWR _4175_ sky130_fd_sc_hd__mux2_1
Xhold463 RF.reg_arr\[26\]\[24\] VGND VGND VPWR VPWR net545 sky130_fd_sc_hd__dlygate4sd3_1
Xhold441 RF.reg_arr\[13\]\[28\] VGND VGND VPWR VPWR net523 sky130_fd_sc_hd__dlygate4sd3_1
Xhold430 RF.reg_arr\[25\]\[31\] VGND VGND VPWR VPWR net512 sky130_fd_sc_hd__dlygate4sd3_1
X_4549_ _1334_ _1335_ _1336_ _1337_ _1121_ _1062_ VGND VGND VPWR VPWR _1338_ sky130_fd_sc_hd__mux4_2
X_7337_ _3617_ VGND VGND VPWR VPWR _0211_ sky130_fd_sc_hd__clkbuf_1
Xhold452 RF.reg_arr\[18\]\[18\] VGND VGND VPWR VPWR net534 sky130_fd_sc_hd__dlygate4sd3_1
Xhold496 RF.reg_arr\[7\]\[23\] VGND VGND VPWR VPWR net578 sky130_fd_sc_hd__dlygate4sd3_1
X_7268_ _3100_ net419 _3580_ VGND VGND VPWR VPWR _3581_ sky130_fd_sc_hd__mux2_1
Xhold474 RF.reg_arr\[7\]\[12\] VGND VGND VPWR VPWR net556 sky130_fd_sc_hd__dlygate4sd3_1
Xhold485 RF.reg_arr\[6\]\[0\] VGND VGND VPWR VPWR net567 sky130_fd_sc_hd__dlygate4sd3_1
XFILLER_0_110_291 VGND VGND VPWR VPWR sky130_fd_sc_hd__decap_6
X_6219_ _2972_ _2973_ _2974_ _2975_ VGND VGND VPWR VPWR _2976_ sky130_fd_sc_hd__or4bb_4
X_9007_ clknet_leaf_106_CLK _0240_ VGND VGND VPWR VPWR RF.reg_arr\[27\]\[17\] sky130_fd_sc_hd__dfxtp_1
X_7199_ net224 _3430_ _3543_ VGND VGND VPWR VPWR _3544_ sky130_fd_sc_hd__mux2_1
XFILLER_0_99_337 VGND VGND VPWR VPWR sky130_fd_sc_hd__decap_4
XFILLER_0_36_643 VGND VGND VPWR VPWR sky130_fd_sc_hd__fill_1
XFILLER_0_63_495 VGND VGND VPWR VPWR sky130_fd_sc_hd__decap_6
XFILLER_0_63_484 VGND VGND VPWR VPWR sky130_fd_sc_hd__decap_8
Xclkload19 clknet_leaf_2_CLK VGND VGND VPWR VPWR clkload19/Y sky130_fd_sc_hd__clkinv_4
XFILLER_0_35_175 VGND VGND VPWR VPWR sky130_fd_sc_hd__fill_1
XFILLER_0_50_123 VGND VGND VPWR VPWR sky130_fd_sc_hd__fill_1
XFILLER_0_31_381 VGND VGND VPWR VPWR sky130_fd_sc_hd__fill_2
XFILLER_0_76_29 VGND VGND VPWR VPWR sky130_fd_sc_hd__fill_1
XTAP_TAPCELL_ROW_47_811 VGND VPWR sky130_fd_sc_hd__tapvpwrvgnd_1
XFILLER_0_116_57 VPWR VGND VPWR VGND sky130_ef_sc_hd__decap_12
XFILLER_0_25_55 VGND VGND VPWR VPWR sky130_fd_sc_hd__fill_1
XFILLER_0_25_77 VGND VGND VPWR VPWR sky130_fd_sc_hd__decap_8
XFILLER_0_86_565 VGND VGND VPWR VPWR sky130_fd_sc_hd__decap_8
XTAP_TAPCELL_ROW_63_1013 VGND VPWR sky130_fd_sc_hd__tapvpwrvgnd_1
XTAP_TAPCELL_ROW_63_1002 VGND VPWR sky130_fd_sc_hd__tapvpwrvgnd_1
XFILLER_0_58_256 VGND VGND VPWR VPWR sky130_fd_sc_hd__fill_1
XFILLER_0_86_598 VGND VGND VPWR VPWR sky130_fd_sc_hd__decap_8
X_6570_ net281 _2990_ _3159_ VGND VGND VPWR VPWR _3193_ sky130_fd_sc_hd__mux2_1
X_5521_ _1833_ _2309_ VGND VGND VPWR VPWR _2310_ sky130_fd_sc_hd__nor2_1
XFILLER_0_54_473 VGND VGND VPWR VPWR sky130_fd_sc_hd__decap_3
X_8240_ _2986_ net523 _4088_ VGND VGND VPWR VPWR _4097_ sky130_fd_sc_hd__mux2_1
X_5452_ RF.reg_arr\[28\]\[7\] RF.reg_arr\[29\]\[7\] RF.reg_arr\[30\]\[7\] RF.reg_arr\[31\]\[7\]
+ _1883_ _1885_ VGND VGND VPWR VPWR _2241_ sky130_fd_sc_hd__mux4_1
X_8171_ _4060_ VGND VGND VPWR VPWR _0602_ sky130_fd_sc_hd__clkbuf_1
X_4403_ _1190_ _1191_ _1133_ VGND VGND VPWR VPWR _1192_ sky130_fd_sc_hd__mux2_1
X_5383_ RF.reg_arr\[0\]\[12\] RF.reg_arr\[1\]\[12\] RF.reg_arr\[2\]\[12\] RF.reg_arr\[3\]\[12\]
+ _1674_ _1680_ VGND VGND VPWR VPWR _2172_ sky130_fd_sc_hd__mux4_1
XFILLER_0_112_589 VGND VGND VPWR VPWR sky130_fd_sc_hd__decap_3
XTAP_TAPCELL_ROW_74_1142 VGND VPWR sky130_fd_sc_hd__tapvpwrvgnd_1
X_7122_ net605 _3422_ _3496_ VGND VGND VPWR VPWR _3503_ sky130_fd_sc_hd__mux2_1
X_4334_ RF.reg_arr\[28\]\[16\] RF.reg_arr\[29\]\[16\] RF.reg_arr\[30\]\[16\] RF.reg_arr\[31\]\[16\]
+ _1117_ _1118_ VGND VGND VPWR VPWR _1123_ sky130_fd_sc_hd__mux4_1
XFILLER_0_10_565 VGND VGND VPWR VPWR sky130_fd_sc_hd__fill_2
X_7053_ _3466_ VGND VGND VPWR VPWR _0078_ sky130_fd_sc_hd__clkbuf_1
XFILLER_0_5_54 VGND VGND VPWR VPWR sky130_fd_sc_hd__fill_2
X_6004_ net82 net1129 _2768_ VGND VGND VPWR VPWR _2774_ sky130_fd_sc_hd__o21a_1
X_4265_ RF.reg_arr\[0\]\[5\] RF.reg_arr\[1\]\[5\] RF.reg_arr\[2\]\[5\] RF.reg_arr\[3\]\[5\]
+ _1051_ _1053_ VGND VGND VPWR VPWR _1054_ sky130_fd_sc_hd__mux4_1
XFILLER_0_5_98 VGND VGND VPWR VPWR sky130_fd_sc_hd__fill_1
X_7955_ _3946_ VGND VGND VPWR VPWR _0500_ sky130_fd_sc_hd__clkbuf_1
XFILLER_0_49_223 VGND VGND VPWR VPWR sky130_fd_sc_hd__fill_1
X_6906_ net186 _3373_ _3366_ VGND VGND VPWR VPWR _3374_ sky130_fd_sc_hd__mux2_1
X_7886_ _3103_ net490 _3908_ VGND VGND VPWR VPWR _3910_ sky130_fd_sc_hd__mux2_1
XTAP_TAPCELL_ROW_85_1271 VGND VPWR sky130_fd_sc_hd__tapvpwrvgnd_1
XTAP_TAPCELL_ROW_25_549 VGND VPWR sky130_fd_sc_hd__tapvpwrvgnd_1
X_6837_ net206 _2982_ _3329_ VGND VGND VPWR VPWR _3336_ sky130_fd_sc_hd__mux2_1
X_6768_ _3113_ net300 _3292_ VGND VGND VPWR VPWR _3299_ sky130_fd_sc_hd__mux2_1
X_8507_ clknet_leaf_27_CLK _0764_ VGND VGND VPWR VPWR RF.reg_arr\[10\]\[29\] sky130_fd_sc_hd__dfxtp_1
X_6699_ _3261_ VGND VGND VPWR VPWR _0953_ sky130_fd_sc_hd__clkbuf_1
X_5719_ _2501_ _2503_ VGND VGND VPWR VPWR _2504_ sky130_fd_sc_hd__xnor2_1
XFILLER_0_72_270 VGND VGND VPWR VPWR sky130_fd_sc_hd__decap_8
XFILLER_0_60_421 VGND VGND VPWR VPWR sky130_fd_sc_hd__fill_1
X_9487_ clknet_leaf_1_CLK _0720_ VGND VGND VPWR VPWR RF.reg_arr\[11\]\[17\] sky130_fd_sc_hd__dfxtp_1
X_8438_ net689 net31 _4196_ VGND VGND VPWR VPWR _4202_ sky130_fd_sc_hd__mux2_1
X_8369_ _4165_ VGND VGND VPWR VPWR _0695_ sky130_fd_sc_hd__clkbuf_1
XFILLER_0_103_567 VGND VGND VPWR VPWR sky130_fd_sc_hd__fill_1
Xhold260 RF.reg_arr\[28\]\[28\] VGND VGND VPWR VPWR net342 sky130_fd_sc_hd__dlygate4sd3_1
Xhold271 RF.reg_arr\[19\]\[9\] VGND VGND VPWR VPWR net353 sky130_fd_sc_hd__dlygate4sd3_1
XFILLER_0_41_690 VGND VGND VPWR VPWR sky130_fd_sc_hd__fill_2
Xhold282 RF.reg_arr\[16\]\[2\] VGND VGND VPWR VPWR net364 sky130_fd_sc_hd__dlygate4sd3_1
Xhold293 RF.reg_arr\[13\]\[2\] VGND VGND VPWR VPWR net375 sky130_fd_sc_hd__dlygate4sd3_1
XFILLER_0_68_554 VGND VGND VPWR VPWR sky130_fd_sc_hd__decap_4
XFILLER_0_83_535 VGND VGND VPWR VPWR sky130_fd_sc_hd__decap_8
XTAP_TAPCELL_ROW_52_880 VGND VPWR sky130_fd_sc_hd__tapvpwrvgnd_1
XFILLER_0_102_15 VPWR VGND VPWR VGND sky130_ef_sc_hd__decap_12
XFILLER_0_36_473 VGND VGND VPWR VPWR sky130_fd_sc_hd__decap_3
XFILLER_0_63_281 VGND VGND VPWR VPWR sky130_fd_sc_hd__fill_1
XFILLER_0_51_410 VGND VGND VPWR VPWR sky130_fd_sc_hd__decap_8
XFILLER_0_11_68 VGND VGND VPWR VPWR sky130_fd_sc_hd__fill_1
Xinput6 A2[2] VGND VGND VPWR VPWR net6 sky130_fd_sc_hd__clkbuf_4
XTAP_TAPCELL_ROW_108_1547 VGND VPWR sky130_fd_sc_hd__tapvpwrvgnd_1
XFILLER_0_78_329 VGND VGND VPWR VPWR sky130_fd_sc_hd__fill_2
X_4952_ RF.reg_arr\[16\]\[26\] RF.reg_arr\[17\]\[26\] RF.reg_arr\[18\]\[26\] RF.reg_arr\[19\]\[26\]
+ _1678_ _1684_ VGND VGND VPWR VPWR _1741_ sky130_fd_sc_hd__mux4_1
X_7740_ net624 _3424_ _3824_ VGND VGND VPWR VPWR _3832_ sky130_fd_sc_hd__mux2_1
X_4883_ _1670_ _1671_ _1614_ VGND VGND VPWR VPWR _1672_ sky130_fd_sc_hd__mux2_1
XFILLER_0_86_362 VGND VGND VPWR VPWR sky130_fd_sc_hd__fill_2
XFILLER_0_46_215 VGND VGND VPWR VPWR sky130_fd_sc_hd__fill_1
X_7671_ _3795_ VGND VGND VPWR VPWR _0367_ sky130_fd_sc_hd__clkbuf_1
X_6622_ net588 _3044_ _3218_ VGND VGND VPWR VPWR _3221_ sky130_fd_sc_hd__mux2_1
X_9410_ clknet_leaf_76_CLK _0643_ VGND VGND VPWR VPWR RF.reg_arr\[17\]\[4\] sky130_fd_sc_hd__dfxtp_1
XTAP_TAPCELL_ROW_22_519 VGND VPWR sky130_fd_sc_hd__tapvpwrvgnd_1
XFILLER_0_116_136 VGND VGND VPWR VPWR sky130_fd_sc_hd__decap_4
XFILLER_0_116_169 VGND VGND VPWR VPWR sky130_fd_sc_hd__fill_1
X_6553_ _3184_ VGND VGND VPWR VPWR _0884_ sky130_fd_sc_hd__clkbuf_1
X_9341_ clknet_leaf_18_CLK _0574_ VGND VGND VPWR VPWR RF.reg_arr\[20\]\[31\] sky130_fd_sc_hd__dfxtp_1
XFILLER_0_42_421 VGND VGND VPWR VPWR sky130_fd_sc_hd__decap_4
X_9272_ clknet_leaf_35_CLK _0505_ VGND VGND VPWR VPWR RF.reg_arr\[21\]\[26\] sky130_fd_sc_hd__dfxtp_1
X_5504_ _1649_ _2292_ VGND VGND VPWR VPWR _2293_ sky130_fd_sc_hd__or2_1
X_6484_ net108 VGND VGND VPWR VPWR _3147_ sky130_fd_sc_hd__clkbuf_1
X_8223_ _4065_ VGND VGND VPWR VPWR _4088_ sky130_fd_sc_hd__clkbuf_8
X_5435_ _2222_ _2223_ _1610_ VGND VGND VPWR VPWR _2224_ sky130_fd_sc_hd__mux2_1
XFILLER_0_65_3 VGND VGND VPWR VPWR sky130_fd_sc_hd__fill_1
X_5366_ _2153_ _2154_ _1603_ VGND VGND VPWR VPWR _2155_ sky130_fd_sc_hd__mux2_1
X_8154_ _4051_ VGND VGND VPWR VPWR _0594_ sky130_fd_sc_hd__clkbuf_1
X_5297_ _2069_ _2085_ VGND VGND VPWR VPWR _2086_ sky130_fd_sc_hd__nand2_1
X_7105_ net398 _3405_ _3485_ VGND VGND VPWR VPWR _3494_ sky130_fd_sc_hd__mux2_1
X_8085_ _3037_ net1071 _4005_ VGND VGND VPWR VPWR _4015_ sky130_fd_sc_hd__mux2_1
X_4317_ _1028_ VGND VGND VPWR VPWR _1106_ sky130_fd_sc_hd__buf_4
X_7036_ _3457_ VGND VGND VPWR VPWR _0070_ sky130_fd_sc_hd__clkbuf_1
X_4248_ RF.reg_arr\[24\]\[5\] RF.reg_arr\[25\]\[5\] RF.reg_arr\[26\]\[5\] RF.reg_arr\[27\]\[5\]
+ _1027_ _1029_ VGND VGND VPWR VPWR _1037_ sky130_fd_sc_hd__mux4_1
XTAP_TAPCELL_ROW_87_1300 VGND VPWR sky130_fd_sc_hd__tapvpwrvgnd_1
X_8987_ clknet_leaf_30_CLK _0220_ VGND VGND VPWR VPWR RF.reg_arr\[31\]\[29\] sky130_fd_sc_hd__dfxtp_1
XFILLER_0_96_126 VGND VGND VPWR VPWR sky130_fd_sc_hd__fill_1
XTAP_TAPCELL_ROW_2_277 VGND VPWR sky130_fd_sc_hd__tapvpwrvgnd_1
X_7938_ _3937_ VGND VGND VPWR VPWR _0492_ sky130_fd_sc_hd__clkbuf_1
X_7869_ _3086_ net1004 _3897_ VGND VGND VPWR VPWR _3901_ sky130_fd_sc_hd__mux2_1
XFILLER_0_92_365 VPWR VGND VPWR VGND sky130_ef_sc_hd__decap_12
XFILLER_0_80_505 VGND VGND VPWR VPWR sky130_fd_sc_hd__fill_1
XPHY_EDGE_ROW_14_Right_14 VGND VGND VPWR VPWR sky130_fd_sc_hd__decap_3
XFILLER_0_18_473 VGND VGND VPWR VPWR sky130_fd_sc_hd__decap_3
XFILLER_0_45_281 VGND VGND VPWR VPWR sky130_fd_sc_hd__decap_3
XFILLER_0_45_292 VGND VGND VPWR VPWR sky130_fd_sc_hd__decap_3
XFILLER_0_14_690 VGND VGND VPWR VPWR sky130_fd_sc_hd__fill_2
XPHY_EDGE_ROW_23_Right_23 VGND VGND VPWR VPWR sky130_fd_sc_hd__decap_3
XFILLER_0_96_671 VGND VGND VPWR VPWR sky130_fd_sc_hd__decap_4
XPHY_EDGE_ROW_32_Right_32 VGND VGND VPWR VPWR sky130_fd_sc_hd__decap_3
XFILLER_0_83_332 VGND VGND VPWR VPWR sky130_fd_sc_hd__decap_4
XFILLER_0_83_310 VGND VGND VPWR VPWR sky130_fd_sc_hd__decap_4
XFILLER_0_28_237 VGND VGND VPWR VPWR sky130_fd_sc_hd__decap_3
XTAP_TAPCELL_ROW_103_1488 VGND VPWR sky130_fd_sc_hd__tapvpwrvgnd_1
XFILLER_0_98_38 VGND VGND VPWR VPWR sky130_fd_sc_hd__decap_6
XFILLER_0_3_326 VGND VGND VPWR VPWR sky130_fd_sc_hd__fill_2
XFILLER_0_3_337 VGND VGND VPWR VPWR sky130_fd_sc_hd__decap_4
X_5220_ RF.reg_arr\[20\]\[3\] RF.reg_arr\[21\]\[3\] RF.reg_arr\[22\]\[3\] RF.reg_arr\[23\]\[3\]
+ _1229_ _1230_ VGND VGND VPWR VPWR _2009_ sky130_fd_sc_hd__mux4_1
XTAP_TAPCELL_ROW_71_1101 VGND VPWR sky130_fd_sc_hd__tapvpwrvgnd_1
XPHY_EDGE_ROW_41_Right_41 VGND VGND VPWR VPWR sky130_fd_sc_hd__decap_3
X_5151_ RF.reg_arr\[4\]\[18\] RF.reg_arr\[5\]\[18\] RF.reg_arr\[6\]\[18\] RF.reg_arr\[7\]\[18\]
+ _1624_ _1597_ VGND VGND VPWR VPWR _1940_ sky130_fd_sc_hd__mux4_1
X_5082_ RF.reg_arr\[24\]\[23\] RF.reg_arr\[25\]\[23\] RF.reg_arr\[26\]\[23\] RF.reg_arr\[27\]\[23\]
+ _1676_ _1682_ VGND VGND VPWR VPWR _1871_ sky130_fd_sc_hd__mux4_1
X_8910_ clknet_leaf_9_CLK _0143_ VGND VGND VPWR VPWR RF.reg_arr\[7\]\[16\] sky130_fd_sc_hd__dfxtp_1
X_8841_ clknet_leaf_13_CLK _0074_ VGND VGND VPWR VPWR RF.reg_arr\[19\]\[11\] sky130_fd_sc_hd__dfxtp_1
XTAP_TAPCELL_ROW_55_909 VGND VPWR sky130_fd_sc_hd__tapvpwrvgnd_1
XFILLER_0_94_608 VGND VGND VPWR VPWR sky130_fd_sc_hd__fill_2
XTAP_TAPCELL_ROW_69_1085 VGND VPWR sky130_fd_sc_hd__tapvpwrvgnd_1
XTAP_TAPCELL_ROW_69_1074 VGND VPWR sky130_fd_sc_hd__tapvpwrvgnd_1
X_8772_ clknet_leaf_85_CLK _0005_ VGND VGND VPWR VPWR RF.reg_arr\[5\]\[6\] sky130_fd_sc_hd__dfxtp_1
XPHY_EDGE_ROW_50_Right_50 VGND VGND VPWR VPWR sky130_fd_sc_hd__decap_3
X_5984_ _2720_ _2754_ _2434_ VGND VGND VPWR VPWR _2755_ sky130_fd_sc_hd__mux2_1
XFILLER_0_87_660 VGND VGND VPWR VPWR sky130_fd_sc_hd__fill_1
XTAP_TAPCELL_ROW_82_1241 VGND VPWR sky130_fd_sc_hd__tapvpwrvgnd_1
XTAP_TAPCELL_ROW_82_1230 VGND VPWR sky130_fd_sc_hd__tapvpwrvgnd_1
XFILLER_0_47_502 VGND VGND VPWR VPWR sky130_fd_sc_hd__fill_2
X_7723_ net381 _3407_ _3813_ VGND VGND VPWR VPWR _3823_ sky130_fd_sc_hd__mux2_1
X_4935_ RF.reg_arr\[28\]\[1\] RF.reg_arr\[29\]\[1\] RF.reg_arr\[30\]\[1\] RF.reg_arr\[31\]\[1\]
+ _1050_ _1052_ VGND VGND VPWR VPWR _1724_ sky130_fd_sc_hd__mux4_1
XTAP_TAPCELL_ROW_35_666 VGND VPWR sky130_fd_sc_hd__tapvpwrvgnd_1
XTAP_TAPCELL_ROW_35_677 VGND VPWR sky130_fd_sc_hd__tapvpwrvgnd_1
XANTENNA_11 _1696_ VGND VGND VPWR VPWR sky130_fd_sc_hd__diode_2
X_4866_ RF.reg_arr\[8\]\[30\] RF.reg_arr\[9\]\[30\] RF.reg_arr\[10\]\[30\] RF.reg_arr\[11\]\[30\]
+ _1593_ _1600_ VGND VGND VPWR VPWR _1655_ sky130_fd_sc_hd__mux4_1
XFILLER_0_74_365 VGND VGND VPWR VPWR sky130_fd_sc_hd__decap_3
X_7654_ _3786_ VGND VGND VPWR VPWR _0359_ sky130_fd_sc_hd__clkbuf_1
XANTENNA_22 net5 VGND VGND VPWR VPWR sky130_fd_sc_hd__diode_2
X_6605_ net742 _3027_ _3207_ VGND VGND VPWR VPWR _3212_ sky130_fd_sc_hd__mux2_1
X_7585_ net587 _3405_ _3741_ VGND VGND VPWR VPWR _3750_ sky130_fd_sc_hd__mux2_1
X_4797_ _1585_ VGND VGND VPWR VPWR _1586_ sky130_fd_sc_hd__clkbuf_8
X_9324_ clknet_leaf_102_CLK _0557_ VGND VGND VPWR VPWR RF.reg_arr\[20\]\[14\] sky130_fd_sc_hd__dfxtp_1
X_6536_ _3175_ VGND VGND VPWR VPWR _0876_ sky130_fd_sc_hd__clkbuf_1
XFILLER_0_104_139 VGND VGND VPWR VPWR sky130_fd_sc_hd__fill_1
XFILLER_0_70_582 VGND VGND VPWR VPWR sky130_fd_sc_hd__decap_6
XFILLER_0_113_673 VPWR VGND VPWR VGND sky130_ef_sc_hd__decap_12
XFILLER_0_113_662 VGND VGND VPWR VPWR sky130_fd_sc_hd__decap_8
XFILLER_0_88_60 VGND VGND VPWR VPWR sky130_fd_sc_hd__fill_1
X_9255_ clknet_leaf_77_CLK _0488_ VGND VGND VPWR VPWR RF.reg_arr\[21\]\[9\] sky130_fd_sc_hd__dfxtp_1
XFILLER_0_30_446 VGND VGND VPWR VPWR sky130_fd_sc_hd__decap_3
X_6467_ _3138_ VGND VGND VPWR VPWR _0844_ sky130_fd_sc_hd__clkbuf_1
XTAP_TAPCELL_ROW_93_1370 VGND VPWR sky130_fd_sc_hd__tapvpwrvgnd_1
X_9186_ clknet_leaf_76_CLK _0419_ VGND VGND VPWR VPWR RF.reg_arr\[24\]\[4\] sky130_fd_sc_hd__dfxtp_1
X_5418_ _2203_ _2206_ _1634_ VGND VGND VPWR VPWR _2207_ sky130_fd_sc_hd__mux2_1
X_6398_ _3096_ net825 _3080_ VGND VGND VPWR VPWR _3097_ sky130_fd_sc_hd__mux2_1
X_8206_ _4079_ VGND VGND VPWR VPWR _0618_ sky130_fd_sc_hd__clkbuf_1
X_8137_ net855 _3412_ _4041_ VGND VGND VPWR VPWR _4043_ sky130_fd_sc_hd__mux2_1
XTAP_TAPCELL_ROW_7_336 VGND VPWR sky130_fd_sc_hd__tapvpwrvgnd_1
X_5349_ _2136_ _2137_ _1611_ VGND VGND VPWR VPWR _2138_ sky130_fd_sc_hd__mux2_1
XFILLER_0_100_389 VGND VGND VPWR VPWR sky130_fd_sc_hd__decap_4
X_8068_ _4006_ VGND VGND VPWR VPWR _0553_ sky130_fd_sc_hd__clkbuf_1
X_7019_ _3447_ _3158_ VGND VGND VPWR VPWR _3448_ sky130_fd_sc_hd__nor2_2
XFILLER_0_97_446 VGND VGND VPWR VPWR sky130_fd_sc_hd__fill_2
XFILLER_0_78_660 VGND VGND VPWR VPWR sky130_fd_sc_hd__decap_8
XFILLER_0_93_641 VPWR VGND VPWR VGND sky130_ef_sc_hd__decap_12
XFILLER_0_53_505 VGND VGND VPWR VPWR sky130_fd_sc_hd__decap_4
XFILLER_0_53_538 VGND VGND VPWR VPWR sky130_fd_sc_hd__fill_1
XFILLER_0_0_307 VGND VGND VPWR VPWR sky130_fd_sc_hd__fill_1
XFILLER_0_21_435 VGND VGND VPWR VPWR sky130_fd_sc_hd__fill_1
XTAP_TAPCELL_ROW_105_1517 VGND VPWR sky130_fd_sc_hd__tapvpwrvgnd_1
XTAP_TAPCELL_ROW_105_1506 VGND VPWR sky130_fd_sc_hd__tapvpwrvgnd_1
XFILLER_0_76_619 VGND VGND VPWR VPWR sky130_fd_sc_hd__decap_3
XFILLER_0_8_418 VGND VGND VPWR VPWR sky130_fd_sc_hd__fill_2
XFILLER_0_29_546 VGND VGND VPWR VPWR sky130_fd_sc_hd__decap_4
XFILLER_0_83_140 VGND VGND VPWR VPWR sky130_fd_sc_hd__fill_2
XTAP_TAPCELL_ROW_32_636 VGND VPWR sky130_fd_sc_hd__tapvpwrvgnd_1
X_4720_ RF.reg_arr\[12\]\[13\] RF.reg_arr\[13\]\[13\] RF.reg_arr\[14\]\[13\] RF.reg_arr\[15\]\[13\]
+ _1357_ _1358_ VGND VGND VPWR VPWR _1509_ sky130_fd_sc_hd__mux4_1
X_4651_ RF.reg_arr\[0\]\[26\] RF.reg_arr\[1\]\[26\] RF.reg_arr\[2\]\[26\] RF.reg_arr\[3\]\[26\]
+ _1327_ _1328_ VGND VGND VPWR VPWR _1440_ sky130_fd_sc_hd__mux4_1
XTAP_TAPCELL_ROW_60_967 VGND VPWR sky130_fd_sc_hd__tapvpwrvgnd_1
Xinput31 WD3[25] VGND VGND VPWR VPWR net31 sky130_fd_sc_hd__buf_1
Xinput20 WD3[15] VGND VGND VPWR VPWR net20 sky130_fd_sc_hd__buf_1
X_4582_ RF.reg_arr\[20\]\[22\] RF.reg_arr\[21\]\[22\] RF.reg_arr\[22\]\[22\] RF.reg_arr\[23\]\[22\]
+ _1082_ _1084_ VGND VGND VPWR VPWR _1371_ sky130_fd_sc_hd__mux4_1
XTAP_TAPCELL_ROW_12_393 VGND VPWR sky130_fd_sc_hd__tapvpwrvgnd_1
X_7370_ _3067_ net874 _3630_ VGND VGND VPWR VPWR _3635_ sky130_fd_sc_hd__mux2_1
Xinput42 WD3[6] VGND VGND VPWR VPWR net42 sky130_fd_sc_hd__buf_1
XTAP_TAPCELL_ROW_116_1657 VGND VPWR sky130_fd_sc_hd__tapvpwrvgnd_1
XTAP_TAPCELL_ROW_116_1646 VGND VPWR sky130_fd_sc_hd__tapvpwrvgnd_1
X_6321_ net399 _3046_ _3040_ VGND VGND VPWR VPWR _3047_ sky130_fd_sc_hd__mux2_1
Xhold837 RF.reg_arr\[31\]\[6\] VGND VGND VPWR VPWR net919 sky130_fd_sc_hd__dlygate4sd3_1
Xhold826 RF.reg_arr\[15\]\[7\] VGND VGND VPWR VPWR net908 sky130_fd_sc_hd__dlygate4sd3_1
Xhold804 RF.reg_arr\[11\]\[8\] VGND VGND VPWR VPWR net886 sky130_fd_sc_hd__dlygate4sd3_1
Xhold815 RF.reg_arr\[15\]\[16\] VGND VGND VPWR VPWR net897 sky130_fd_sc_hd__dlygate4sd3_1
XFILLER_0_110_632 VGND VGND VPWR VPWR sky130_fd_sc_hd__fill_1
X_6252_ net25 VGND VGND VPWR VPWR _3000_ sky130_fd_sc_hd__buf_2
Xhold859 RF.reg_arr\[23\]\[7\] VGND VGND VPWR VPWR net941 sky130_fd_sc_hd__dlygate4sd3_1
X_9040_ clknet_leaf_0_CLK _0273_ VGND VGND VPWR VPWR RF.reg_arr\[26\]\[18\] sky130_fd_sc_hd__dfxtp_1
Xhold848 RF.reg_arr\[12\]\[7\] VGND VGND VPWR VPWR net930 sky130_fd_sc_hd__dlygate4sd3_1
XFILLER_0_110_643 VGND VGND VPWR VPWR sky130_fd_sc_hd__fill_1
X_6183_ _2029_ _2942_ VGND VGND VPWR VPWR _2943_ sky130_fd_sc_hd__or2_1
X_5203_ _1604_ _1991_ _1617_ VGND VGND VPWR VPWR _1992_ sky130_fd_sc_hd__o21a_1
X_5134_ RF.reg_arr\[0\]\[21\] RF.reg_arr\[1\]\[21\] RF.reg_arr\[2\]\[21\] RF.reg_arr\[3\]\[21\]
+ _1625_ _1598_ VGND VGND VPWR VPWR _1923_ sky130_fd_sc_hd__mux4_1
X_5065_ _1603_ VGND VGND VPWR VPWR _1854_ sky130_fd_sc_hd__buf_4
XFILLER_0_28_3 VGND VGND VPWR VPWR sky130_fd_sc_hd__fill_2
X_8824_ clknet_leaf_50_CLK _0057_ VGND VGND VPWR VPWR RF.reg_arr\[4\]\[26\] sky130_fd_sc_hd__dfxtp_1
XFILLER_0_66_107 VGND VGND VPWR VPWR sky130_fd_sc_hd__fill_1
X_5967_ _1143_ _2738_ net96 _2547_ VGND VGND VPWR VPWR _2739_ sky130_fd_sc_hd__o31a_1
X_8755_ clknet_leaf_45_CLK _1012_ VGND VGND VPWR VPWR RF.reg_arr\[6\]\[21\] sky130_fd_sc_hd__dfxtp_1
X_4918_ _1703_ _1706_ _1619_ VGND VGND VPWR VPWR _1707_ sky130_fd_sc_hd__mux2_1
X_7706_ _3814_ VGND VGND VPWR VPWR _0383_ sky130_fd_sc_hd__clkbuf_1
X_8686_ clknet_leaf_5_CLK _0943_ VGND VGND VPWR VPWR RF.reg_arr\[15\]\[16\] sky130_fd_sc_hd__dfxtp_1
X_5898_ _2672_ _2673_ VGND VGND VPWR VPWR _2674_ sky130_fd_sc_hd__nand2b_4
XFILLER_0_62_324 VGND VGND VPWR VPWR sky130_fd_sc_hd__fill_1
X_7637_ _3056_ net1109 _3777_ VGND VGND VPWR VPWR _3778_ sky130_fd_sc_hd__mux2_1
XFILLER_0_105_415 VGND VGND VPWR VPWR sky130_fd_sc_hd__decap_3
X_4849_ RF.reg_arr\[4\]\[31\] RF.reg_arr\[5\]\[31\] RF.reg_arr\[6\]\[31\] RF.reg_arr\[7\]\[31\]
+ _1627_ _1629_ VGND VGND VPWR VPWR _1638_ sky130_fd_sc_hd__mux4_1
X_7568_ _3740_ VGND VGND VPWR VPWR _3741_ sky130_fd_sc_hd__buf_4
XFILLER_0_15_251 VGND VGND VPWR VPWR sky130_fd_sc_hd__fill_2
X_9307_ clknet_leaf_29_CLK _0540_ VGND VGND VPWR VPWR RF.reg_arr\[25\]\[29\] sky130_fd_sc_hd__dfxtp_1
X_7499_ _3703_ VGND VGND VPWR VPWR _3704_ sky130_fd_sc_hd__buf_2
X_6519_ _3166_ VGND VGND VPWR VPWR _0868_ sky130_fd_sc_hd__clkbuf_1
XFILLER_0_43_582 VGND VGND VPWR VPWR sky130_fd_sc_hd__fill_2
X_9238_ clknet_leaf_52_CLK _0471_ VGND VGND VPWR VPWR RF.reg_arr\[22\]\[24\] sky130_fd_sc_hd__dfxtp_1
X_9169_ clknet_leaf_7_CLK _0402_ VGND VGND VPWR VPWR RF.reg_arr\[9\]\[19\] sky130_fd_sc_hd__dfxtp_1
XFILLER_0_100_197 VGND VGND VPWR VPWR sky130_fd_sc_hd__fill_2
XFILLER_0_97_221 VGND VGND VPWR VPWR sky130_fd_sc_hd__decap_3
XFILLER_0_38_365 VGND VGND VPWR VPWR sky130_fd_sc_hd__fill_2
XTAP_TAPCELL_ROW_100_1447 VGND VPWR sky130_fd_sc_hd__tapvpwrvgnd_1
XFILLER_0_93_493 VGND VGND VPWR VPWR sky130_fd_sc_hd__decap_8
XFILLER_0_81_611 VGND VGND VPWR VPWR sky130_fd_sc_hd__decap_4
XFILLER_0_108_253 VGND VGND VPWR VPWR sky130_fd_sc_hd__decap_6
XFILLER_0_110_15 VPWR VGND VPWR VGND sky130_ef_sc_hd__decap_12
XFILLER_0_108_297 VGND VGND VPWR VPWR sky130_fd_sc_hd__fill_2
XFILLER_0_41_508 VGND VGND VPWR VPWR sky130_fd_sc_hd__decap_8
XTAP_TAPCELL_ROW_111_1587 VGND VPWR sky130_fd_sc_hd__tapvpwrvgnd_1
XFILLER_0_88_221 VGND VGND VPWR VPWR sky130_fd_sc_hd__fill_1
XTAP_TAPCELL_ROW_66_1044 VGND VPWR sky130_fd_sc_hd__tapvpwrvgnd_1
X_6870_ net629 _3016_ _3344_ VGND VGND VPWR VPWR _3354_ sky130_fd_sc_hd__mux2_1
XFILLER_0_44_65 VGND VGND VPWR VPWR sky130_fd_sc_hd__decap_3
X_5821_ _2509_ _2600_ _1831_ VGND VGND VPWR VPWR _2601_ sky130_fd_sc_hd__mux2_1
XTAP_TAPCELL_ROW_17_452 VGND VPWR sky130_fd_sc_hd__tapvpwrvgnd_1
X_5752_ net47 _2339_ VGND VGND VPWR VPWR _2535_ sky130_fd_sc_hd__nand2_2
X_8540_ clknet_leaf_23_CLK _0797_ VGND VGND VPWR VPWR RF.reg_arr\[1\]\[30\] sky130_fd_sc_hd__dfxtp_1
XFILLER_0_29_332 VGND VGND VPWR VPWR sky130_fd_sc_hd__fill_1
XTAP_TAPCELL_ROW_45_794 VGND VPWR sky130_fd_sc_hd__tapvpwrvgnd_1
XFILLER_0_72_600 VGND VGND VPWR VPWR sky130_fd_sc_hd__decap_8
X_4703_ RF.reg_arr\[8\]\[12\] RF.reg_arr\[9\]\[12\] RF.reg_arr\[10\]\[12\] RF.reg_arr\[11\]\[12\]
+ _1186_ _1188_ VGND VGND VPWR VPWR _1492_ sky130_fd_sc_hd__mux4_1
X_5683_ _2198_ _2468_ VGND VGND VPWR VPWR _2469_ sky130_fd_sc_hd__nor2_1
XFILLER_0_60_75 VGND VGND VPWR VPWR sky130_fd_sc_hd__fill_2
X_8471_ net198 net45 _4211_ VGND VGND VPWR VPWR _4219_ sky130_fd_sc_hd__mux2_1
X_7422_ _3119_ net992 _3652_ VGND VGND VPWR VPWR _3662_ sky130_fd_sc_hd__mux2_1
X_4634_ _1419_ _1422_ _1158_ VGND VGND VPWR VPWR _1423_ sky130_fd_sc_hd__mux2_1
XFILLER_0_4_421 VGND VGND VPWR VPWR sky130_fd_sc_hd__decap_4
Xhold612 RF.reg_arr\[22\]\[29\] VGND VGND VPWR VPWR net694 sky130_fd_sc_hd__dlygate4sd3_1
X_7353_ _3625_ VGND VGND VPWR VPWR _0219_ sky130_fd_sc_hd__clkbuf_1
XFILLER_0_102_407 VGND VGND VPWR VPWR sky130_fd_sc_hd__decap_4
X_4565_ RF.reg_arr\[24\]\[21\] RF.reg_arr\[25\]\[21\] RF.reg_arr\[26\]\[21\] RF.reg_arr\[27\]\[21\]
+ _1027_ _1029_ VGND VGND VPWR VPWR _1354_ sky130_fd_sc_hd__mux4_1
XFILLER_0_8_65 VGND VGND VPWR VPWR sky130_fd_sc_hd__decap_3
Xhold601 RF.reg_arr\[23\]\[4\] VGND VGND VPWR VPWR net683 sky130_fd_sc_hd__dlygate4sd3_1
Xhold645 RF.reg_arr\[15\]\[25\] VGND VGND VPWR VPWR net727 sky130_fd_sc_hd__dlygate4sd3_1
XTAP_TAPCELL_ROW_77_1173 VGND VPWR sky130_fd_sc_hd__tapvpwrvgnd_1
XFILLER_0_69_73 VGND VGND VPWR VPWR sky130_fd_sc_hd__decap_6
Xhold623 RF.reg_arr\[4\]\[10\] VGND VGND VPWR VPWR net705 sky130_fd_sc_hd__dlygate4sd3_1
XFILLER_0_4_498 VGND VGND VPWR VPWR sky130_fd_sc_hd__decap_6
Xhold634 RF.reg_arr\[7\]\[17\] VGND VGND VPWR VPWR net716 sky130_fd_sc_hd__dlygate4sd3_1
X_6304_ net23 VGND VGND VPWR VPWR _3035_ sky130_fd_sc_hd__buf_2
X_7284_ _3117_ net617 _3580_ VGND VGND VPWR VPWR _3589_ sky130_fd_sc_hd__mux2_1
X_4496_ RF.reg_arr\[12\]\[28\] RF.reg_arr\[13\]\[28\] RF.reg_arr\[14\]\[28\] RF.reg_arr\[15\]\[28\]
+ _1274_ _1276_ VGND VGND VPWR VPWR _1285_ sky130_fd_sc_hd__mux4_1
Xhold667 RF.reg_arr\[25\]\[21\] VGND VGND VPWR VPWR net749 sky130_fd_sc_hd__dlygate4sd3_1
Xhold678 RF.reg_arr\[10\]\[1\] VGND VGND VPWR VPWR net760 sky130_fd_sc_hd__dlygate4sd3_1
X_9023_ clknet_leaf_56_CLK _0256_ VGND VGND VPWR VPWR RF.reg_arr\[26\]\[1\] sky130_fd_sc_hd__dfxtp_1
XPHY_EDGE_ROW_4_Right_4 VGND VGND VPWR VPWR sky130_fd_sc_hd__decap_3
XFILLER_0_40_574 VGND VGND VPWR VPWR sky130_fd_sc_hd__fill_2
Xhold656 RF.reg_arr\[15\]\[9\] VGND VGND VPWR VPWR net738 sky130_fd_sc_hd__dlygate4sd3_1
Xhold689 RF.reg_arr\[31\]\[28\] VGND VGND VPWR VPWR net771 sky130_fd_sc_hd__dlygate4sd3_1
X_6235_ _2987_ VGND VGND VPWR VPWR _0763_ sky130_fd_sc_hd__clkbuf_1
X_6166_ _2925_ _2926_ VGND VGND VPWR VPWR _2927_ sky130_fd_sc_hd__nor2_1
X_6097_ _1789_ _2861_ VGND VGND VPWR VPWR _2862_ sky130_fd_sc_hd__and2b_1
X_5117_ _1619_ _1905_ VGND VGND VPWR VPWR _1906_ sky130_fd_sc_hd__nor2_1
X_5048_ RF.reg_arr\[28\]\[22\] RF.reg_arr\[29\]\[22\] RF.reg_arr\[30\]\[22\] RF.reg_arr\[31\]\[22\]
+ _1590_ _1835_ VGND VGND VPWR VPWR _1837_ sky130_fd_sc_hd__mux4_1
XFILLER_0_94_224 VGND VGND VPWR VPWR sky130_fd_sc_hd__fill_1
X_8807_ clknet_leaf_66_CLK _0040_ VGND VGND VPWR VPWR RF.reg_arr\[4\]\[9\] sky130_fd_sc_hd__dfxtp_1
X_6999_ net29 VGND VGND VPWR VPWR _3437_ sky130_fd_sc_hd__buf_2
X_8738_ clknet_leaf_66_CLK _0995_ VGND VGND VPWR VPWR RF.reg_arr\[6\]\[4\] sky130_fd_sc_hd__dfxtp_1
X_8669_ clknet_leaf_26_CLK _0926_ VGND VGND VPWR VPWR RF.reg_arr\[8\]\[31\] sky130_fd_sc_hd__dfxtp_1
XFILLER_0_90_474 VGND VGND VPWR VPWR sky130_fd_sc_hd__fill_2
XFILLER_0_62_165 VGND VGND VPWR VPWR sky130_fd_sc_hd__fill_2
XFILLER_0_98_541 VGND VGND VPWR VPWR sky130_fd_sc_hd__fill_2
XFILLER_0_98_530 VGND VGND VPWR VPWR sky130_fd_sc_hd__fill_2
XFILLER_0_105_15 VGND VGND VPWR VPWR sky130_fd_sc_hd__decap_8
XTAP_TAPCELL_ROW_14_422 VGND VPWR sky130_fd_sc_hd__tapvpwrvgnd_1
XFILLER_0_85_279 VGND VGND VPWR VPWR sky130_fd_sc_hd__fill_1
XTAP_TAPCELL_ROW_42_753 VGND VPWR sky130_fd_sc_hd__tapvpwrvgnd_1
XFILLER_0_38_195 VGND VGND VPWR VPWR sky130_fd_sc_hd__fill_1
XFILLER_0_81_496 VGND VGND VPWR VPWR sky130_fd_sc_hd__decap_8
XTAP_TAPCELL_ROW_113_1605 VGND VPWR sky130_fd_sc_hd__tapvpwrvgnd_1
X_4350_ RF.reg_arr\[12\]\[16\] RF.reg_arr\[13\]\[16\] RF.reg_arr\[14\]\[16\] RF.reg_arr\[15\]\[16\]
+ _1129_ _1130_ VGND VGND VPWR VPWR _1139_ sky130_fd_sc_hd__mux4_1
X_4281_ RF.reg_arr\[24\]\[4\] RF.reg_arr\[25\]\[4\] RF.reg_arr\[26\]\[4\] RF.reg_arr\[27\]\[4\]
+ _1068_ _1069_ VGND VGND VPWR VPWR _1070_ sky130_fd_sc_hd__mux4_1
X_6020_ _1911_ _2788_ VGND VGND VPWR VPWR _2789_ sky130_fd_sc_hd__xnor2_1
X_7971_ _3954_ VGND VGND VPWR VPWR _0508_ sky130_fd_sc_hd__clkbuf_1
X_6922_ _3384_ VGND VGND VPWR VPWR _0029_ sky130_fd_sc_hd__clkbuf_1
X_6853_ _3345_ VGND VGND VPWR VPWR _1023_ sky130_fd_sc_hd__clkbuf_1
X_5804_ _1066_ _1090_ VGND VGND VPWR VPWR _2585_ sky130_fd_sc_hd__and2_2
XFILLER_0_64_419 VGND VGND VPWR VPWR sky130_fd_sc_hd__fill_1
XFILLER_0_57_471 VGND VGND VPWR VPWR sky130_fd_sc_hd__decap_4
X_6784_ _3308_ VGND VGND VPWR VPWR _0991_ sky130_fd_sc_hd__clkbuf_1
X_5735_ _2517_ _2518_ _2445_ VGND VGND VPWR VPWR _2519_ sky130_fd_sc_hd__a21oi_1
X_8523_ clknet_leaf_89_CLK _0780_ VGND VGND VPWR VPWR RF.reg_arr\[1\]\[13\] sky130_fd_sc_hd__dfxtp_1
XFILLER_0_95_3 VGND VGND VPWR VPWR sky130_fd_sc_hd__decap_8
XTAP_TAPCELL_ROW_79_1202 VGND VPWR sky130_fd_sc_hd__tapvpwrvgnd_1
X_5666_ _2450_ _2452_ VGND VGND VPWR VPWR _2453_ sky130_fd_sc_hd__xor2_1
X_8454_ net760 net25 _2978_ VGND VGND VPWR VPWR _4210_ sky130_fd_sc_hd__mux2_1
XFILLER_0_60_614 VGND VGND VPWR VPWR sky130_fd_sc_hd__decap_3
X_7405_ _3653_ VGND VGND VPWR VPWR _0243_ sky130_fd_sc_hd__clkbuf_1
X_4617_ _1402_ _1403_ _1404_ _1405_ _1042_ _1039_ VGND VGND VPWR VPWR _1406_ sky130_fd_sc_hd__mux4_1
X_5597_ _1737_ _2384_ VGND VGND VPWR VPWR _2385_ sky130_fd_sc_hd__and2_1
Xhold420 RF.reg_arr\[14\]\[21\] VGND VGND VPWR VPWR net502 sky130_fd_sc_hd__dlygate4sd3_1
X_8385_ _4173_ VGND VGND VPWR VPWR _4174_ sky130_fd_sc_hd__clkbuf_8
Xhold442 RF.reg_arr\[11\]\[28\] VGND VGND VPWR VPWR net524 sky130_fd_sc_hd__dlygate4sd3_1
Xhold431 RF.reg_arr\[17\]\[26\] VGND VGND VPWR VPWR net513 sky130_fd_sc_hd__dlygate4sd3_1
Xhold453 RF.reg_arr\[8\]\[31\] VGND VGND VPWR VPWR net535 sky130_fd_sc_hd__dlygate4sd3_1
X_4548_ RF.reg_arr\[24\]\[20\] RF.reg_arr\[25\]\[20\] RF.reg_arr\[26\]\[20\] RF.reg_arr\[27\]\[20\]
+ _1129_ _1130_ VGND VGND VPWR VPWR _1337_ sky130_fd_sc_hd__mux4_1
X_7336_ _3100_ net426 _3616_ VGND VGND VPWR VPWR _3617_ sky130_fd_sc_hd__mux2_1
Xhold464 RF.reg_arr\[30\]\[21\] VGND VGND VPWR VPWR net546 sky130_fd_sc_hd__dlygate4sd3_1
Xhold486 RF.reg_arr\[31\]\[1\] VGND VGND VPWR VPWR net568 sky130_fd_sc_hd__dlygate4sd3_1
X_7267_ _3557_ VGND VGND VPWR VPWR _3580_ sky130_fd_sc_hd__clkbuf_8
Xhold475 RF.reg_arr\[4\]\[18\] VGND VGND VPWR VPWR net557 sky130_fd_sc_hd__dlygate4sd3_1
X_4479_ _1266_ _1267_ _1033_ VGND VGND VPWR VPWR _1268_ sky130_fd_sc_hd__mux2_1
X_6218_ net12 VGND VGND VPWR VPWR _2975_ sky130_fd_sc_hd__clkbuf_4
X_9006_ clknet_leaf_5_CLK _0239_ VGND VGND VPWR VPWR RF.reg_arr\[27\]\[16\] sky130_fd_sc_hd__dfxtp_1
Xhold497 RF.reg_arr\[9\]\[19\] VGND VGND VPWR VPWR net579 sky130_fd_sc_hd__dlygate4sd3_1
X_7198_ _3520_ VGND VGND VPWR VPWR _3543_ sky130_fd_sc_hd__buf_4
X_6149_ _2634_ _2714_ VGND VGND VPWR VPWR _2911_ sky130_fd_sc_hd__or2_1
XPHY_EDGE_ROW_79_Right_79 VGND VGND VPWR VPWR sky130_fd_sc_hd__decap_3
XFILLER_0_95_500 VGND VGND VPWR VPWR sky130_fd_sc_hd__decap_4
XFILLER_0_95_522 VGND VGND VPWR VPWR sky130_fd_sc_hd__decap_3
XFILLER_0_67_202 VGND VGND VPWR VPWR sky130_fd_sc_hd__fill_1
XFILLER_0_82_238 VPWR VGND VPWR VGND sky130_ef_sc_hd__decap_12
XFILLER_0_48_493 VGND VGND VPWR VPWR sky130_fd_sc_hd__decap_6
XFILLER_0_106_521 VGND VGND VPWR VPWR sky130_fd_sc_hd__fill_2
XFILLER_0_90_271 VGND VGND VPWR VPWR sky130_fd_sc_hd__decap_4
XPHY_EDGE_ROW_88_Right_88 VGND VGND VPWR VPWR sky130_fd_sc_hd__decap_3
XFILLER_0_35_187 VGND VGND VPWR VPWR sky130_fd_sc_hd__fill_2
XFILLER_0_31_393 VGND VGND VPWR VPWR sky130_fd_sc_hd__decap_4
XFILLER_0_101_281 VGND VGND VPWR VPWR sky130_fd_sc_hd__fill_1
XPHY_EDGE_ROW_97_Right_97 VGND VGND VPWR VPWR sky130_fd_sc_hd__decap_3
XTAP_TAPCELL_ROW_47_812 VGND VPWR sky130_fd_sc_hd__tapvpwrvgnd_1
XFILLER_0_116_69 VPWR VGND VPWR VGND sky130_ef_sc_hd__decap_12
XFILLER_0_98_393 VGND VGND VPWR VPWR sky130_fd_sc_hd__fill_2
XFILLER_0_86_533 VPWR VGND VPWR VGND sky130_ef_sc_hd__decap_12
XFILLER_0_58_213 VGND VGND VPWR VPWR sky130_fd_sc_hd__fill_2
XTAP_TAPCELL_ROW_63_1003 VGND VPWR sky130_fd_sc_hd__tapvpwrvgnd_1
XFILLER_0_58_235 VGND VGND VPWR VPWR sky130_fd_sc_hd__fill_1
XTAP_TAPCELL_ROW_27_580 VGND VPWR sky130_fd_sc_hd__tapvpwrvgnd_1
XPHY_EDGE_ROW_4_Left_121 VGND VGND VPWR VPWR sky130_fd_sc_hd__decap_3
X_5520_ _1585_ _2300_ _2304_ _2308_ VGND VGND VPWR VPWR _2309_ sky130_fd_sc_hd__o2bb2a_1
XFILLER_0_14_305 VGND VGND VPWR VPWR sky130_fd_sc_hd__decap_3
XFILLER_0_41_113 VGND VGND VPWR VPWR sky130_fd_sc_hd__fill_2
XFILLER_0_42_636 VGND VGND VPWR VPWR sky130_fd_sc_hd__fill_1
X_5451_ _2238_ _2239_ _1611_ VGND VGND VPWR VPWR _2240_ sky130_fd_sc_hd__mux2_1
X_8170_ net474 _3377_ _4052_ VGND VGND VPWR VPWR _4060_ sky130_fd_sc_hd__mux2_1
X_4402_ RF.reg_arr\[28\]\[18\] RF.reg_arr\[29\]\[18\] RF.reg_arr\[30\]\[18\] RF.reg_arr\[31\]\[18\]
+ _1187_ _1189_ VGND VGND VPWR VPWR _1191_ sky130_fd_sc_hd__mux4_1
X_5382_ RF.reg_arr\[4\]\[12\] RF.reg_arr\[5\]\[12\] RF.reg_arr\[6\]\[12\] RF.reg_arr\[7\]\[12\]
+ _1674_ _1680_ VGND VGND VPWR VPWR _2171_ sky130_fd_sc_hd__mux4_1
XTAP_TAPCELL_ROW_74_1143 VGND VPWR sky130_fd_sc_hd__tapvpwrvgnd_1
XFILLER_0_10_533 VGND VGND VPWR VPWR sky130_fd_sc_hd__decap_8
X_7121_ _3502_ VGND VGND VPWR VPWR _0110_ sky130_fd_sc_hd__clkbuf_1
X_4333_ _1119_ _1120_ _1121_ VGND VGND VPWR VPWR _1122_ sky130_fd_sc_hd__mux2_1
X_4264_ _1052_ VGND VGND VPWR VPWR _1053_ sky130_fd_sc_hd__clkbuf_4
X_7052_ net213 _3420_ _3460_ VGND VGND VPWR VPWR _3466_ sky130_fd_sc_hd__mux2_1
X_6003_ _1964_ _2772_ VGND VGND VPWR VPWR _2773_ sky130_fd_sc_hd__xnor2_2
X_7954_ _3042_ net891 _3944_ VGND VGND VPWR VPWR _3946_ sky130_fd_sc_hd__mux2_1
X_6905_ net31 VGND VGND VPWR VPWR _3373_ sky130_fd_sc_hd__buf_2
XFILLER_0_89_393 VGND VGND VPWR VPWR sky130_fd_sc_hd__decap_6
XFILLER_0_77_511 VGND VGND VPWR VPWR sky130_fd_sc_hd__decap_8
XFILLER_0_10_3 VPWR VGND VPWR VGND sky130_ef_sc_hd__decap_12
XTAP_TAPCELL_ROW_85_1272 VGND VPWR sky130_fd_sc_hd__tapvpwrvgnd_1
XFILLER_0_77_544 VGND VGND VPWR VPWR sky130_fd_sc_hd__fill_1
X_7885_ _3909_ VGND VGND VPWR VPWR _0467_ sky130_fd_sc_hd__clkbuf_1
XFILLER_0_49_246 VGND VGND VPWR VPWR sky130_fd_sc_hd__decap_6
X_6836_ _3335_ VGND VGND VPWR VPWR _1016_ sky130_fd_sc_hd__clkbuf_1
XPHY_EDGE_ROW_59_Left_176 VGND VGND VPWR VPWR sky130_fd_sc_hd__decap_3
XFILLER_0_49_279 VGND VGND VPWR VPWR sky130_fd_sc_hd__fill_1
XFILLER_0_92_558 VGND VGND VPWR VPWR sky130_fd_sc_hd__decap_6
X_6767_ _3298_ VGND VGND VPWR VPWR _0984_ sky130_fd_sc_hd__clkbuf_1
XFILLER_0_17_121 VGND VGND VPWR VPWR sky130_fd_sc_hd__decap_6
X_8506_ clknet_leaf_28_CLK _0763_ VGND VGND VPWR VPWR RF.reg_arr\[10\]\[28\] sky130_fd_sc_hd__dfxtp_1
X_5718_ _2457_ _2459_ _2502_ VGND VGND VPWR VPWR _2503_ sky130_fd_sc_hd__a21o_1
XFILLER_0_18_688 VGND VGND VPWR VPWR sky130_fd_sc_hd__decap_4
X_6698_ _3113_ net794 _3254_ VGND VGND VPWR VPWR _3261_ sky130_fd_sc_hd__mux2_1
X_9486_ clknet_leaf_7_CLK _0719_ VGND VGND VPWR VPWR RF.reg_arr\[11\]\[16\] sky130_fd_sc_hd__dfxtp_1
X_8437_ _4201_ VGND VGND VPWR VPWR _0727_ sky130_fd_sc_hd__clkbuf_1
X_5649_ _2433_ _2435_ _2361_ VGND VGND VPWR VPWR _2436_ sky130_fd_sc_hd__mux2_1
XFILLER_0_103_502 VGND VGND VPWR VPWR sky130_fd_sc_hd__fill_2
X_8368_ _2970_ net744 _4160_ VGND VGND VPWR VPWR _4165_ sky130_fd_sc_hd__mux2_1
Xhold261 RF.reg_arr\[9\]\[28\] VGND VGND VPWR VPWR net343 sky130_fd_sc_hd__dlygate4sd3_1
XPHY_EDGE_ROW_68_Left_185 VGND VGND VPWR VPWR sky130_fd_sc_hd__decap_3
X_7319_ _3084_ net989 _3605_ VGND VGND VPWR VPWR _3608_ sky130_fd_sc_hd__mux2_1
Xhold250 RF.reg_arr\[7\]\[14\] VGND VGND VPWR VPWR net332 sky130_fd_sc_hd__dlygate4sd3_1
XFILLER_0_111_590 VGND VGND VPWR VPWR sky130_fd_sc_hd__fill_1
Xhold283 RF.reg_arr\[16\]\[24\] VGND VGND VPWR VPWR net365 sky130_fd_sc_hd__dlygate4sd3_1
Xhold272 RF.reg_arr\[19\]\[26\] VGND VGND VPWR VPWR net354 sky130_fd_sc_hd__dlygate4sd3_1
Xhold294 RF.reg_arr\[4\]\[25\] VGND VGND VPWR VPWR net376 sky130_fd_sc_hd__dlygate4sd3_1
X_8299_ _4128_ VGND VGND VPWR VPWR _0662_ sky130_fd_sc_hd__clkbuf_1
XFILLER_0_99_135 VGND VGND VPWR VPWR sky130_fd_sc_hd__decap_6
XFILLER_0_95_341 VGND VGND VPWR VPWR sky130_fd_sc_hd__fill_1
XPHY_EDGE_ROW_77_Left_194 VGND VGND VPWR VPWR sky130_fd_sc_hd__decap_3
XFILLER_0_68_544 VGND VGND VPWR VPWR sky130_fd_sc_hd__fill_1
XFILLER_0_95_374 VGND VGND VPWR VPWR sky130_fd_sc_hd__fill_1
XTAP_TAPCELL_ROW_52_870 VGND VPWR sky130_fd_sc_hd__tapvpwrvgnd_1
XTAP_TAPCELL_ROW_52_881 VGND VPWR sky130_fd_sc_hd__tapvpwrvgnd_1
XFILLER_0_102_27 VGND VGND VPWR VPWR sky130_fd_sc_hd__fill_1
XFILLER_0_23_113 VGND VGND VPWR VPWR sky130_fd_sc_hd__fill_2
Xinput7 A2[3] VGND VGND VPWR VPWR net7 sky130_fd_sc_hd__clkbuf_2
XTAP_TAPCELL_ROW_108_1548 VGND VPWR sky130_fd_sc_hd__tapvpwrvgnd_1
XFILLER_0_99_691 VGND VGND VPWR VPWR sky130_fd_sc_hd__fill_1
XFILLER_0_59_500 VGND VGND VPWR VPWR sky130_fd_sc_hd__decap_4
X_4951_ RF.reg_arr\[20\]\[26\] RF.reg_arr\[21\]\[26\] RF.reg_arr\[22\]\[26\] RF.reg_arr\[23\]\[26\]
+ _1668_ _1669_ VGND VGND VPWR VPWR _1740_ sky130_fd_sc_hd__mux4_1
X_4882_ RF.reg_arr\[16\]\[29\] RF.reg_arr\[17\]\[29\] RF.reg_arr\[18\]\[29\] RF.reg_arr\[19\]\[29\]
+ _1668_ _1669_ VGND VGND VPWR VPWR _1671_ sky130_fd_sc_hd__mux4_1
XFILLER_0_86_374 VGND VGND VPWR VPWR sky130_fd_sc_hd__decap_6
X_7670_ _3092_ net898 _3788_ VGND VGND VPWR VPWR _3795_ sky130_fd_sc_hd__mux2_1
X_6621_ _3220_ VGND VGND VPWR VPWR _0916_ sky130_fd_sc_hd__clkbuf_1
X_9340_ clknet_leaf_18_CLK _0573_ VGND VGND VPWR VPWR RF.reg_arr\[20\]\[30\] sky130_fd_sc_hd__dfxtp_1
X_6552_ net260 _3042_ _3182_ VGND VGND VPWR VPWR _3184_ sky130_fd_sc_hd__mux2_1
XFILLER_0_61_219 VGND VGND VPWR VPWR sky130_fd_sc_hd__decap_4
XFILLER_0_15_625 VGND VGND VPWR VPWR sky130_fd_sc_hd__fill_1
X_9271_ clknet_leaf_40_CLK _0504_ VGND VGND VPWR VPWR RF.reg_arr\[21\]\[25\] sky130_fd_sc_hd__dfxtp_1
X_6483_ _3146_ VGND VGND VPWR VPWR _0852_ sky130_fd_sc_hd__clkbuf_1
X_5503_ _1585_ _2283_ _2287_ _2291_ VGND VGND VPWR VPWR _2292_ sky130_fd_sc_hd__o2bb2a_1
X_5434_ RF.reg_arr\[24\]\[5\] RF.reg_arr\[25\]\[5\] RF.reg_arr\[26\]\[5\] RF.reg_arr\[27\]\[5\]
+ _1589_ _1834_ VGND VGND VPWR VPWR _2223_ sky130_fd_sc_hd__mux4_1
XFILLER_0_42_477 VPWR VGND VPWR VGND sky130_ef_sc_hd__decap_12
X_8222_ _4087_ VGND VGND VPWR VPWR _0626_ sky130_fd_sc_hd__clkbuf_1
X_8153_ net692 _3428_ _4041_ VGND VGND VPWR VPWR _4051_ sky130_fd_sc_hd__mux2_1
XFILLER_0_10_363 VGND VGND VPWR VPWR sky130_fd_sc_hd__fill_1
X_5365_ RF.reg_arr\[12\]\[15\] RF.reg_arr\[13\]\[15\] RF.reg_arr\[14\]\[15\] RF.reg_arr\[15\]\[15\]
+ _1675_ _1681_ VGND VGND VPWR VPWR _2154_ sky130_fd_sc_hd__mux4_1
X_7104_ _3493_ VGND VGND VPWR VPWR _0102_ sky130_fd_sc_hd__clkbuf_1
X_5296_ _1114_ _2084_ VGND VGND VPWR VPWR _2085_ sky130_fd_sc_hd__or2_1
X_8084_ _4014_ VGND VGND VPWR VPWR _0561_ sky130_fd_sc_hd__clkbuf_1
X_4316_ _1026_ VGND VGND VPWR VPWR _1105_ sky130_fd_sc_hd__buf_12
X_7035_ net232 _3403_ _3449_ VGND VGND VPWR VPWR _3457_ sky130_fd_sc_hd__mux2_1
X_4247_ RF.reg_arr\[28\]\[5\] RF.reg_arr\[29\]\[5\] RF.reg_arr\[30\]\[5\] RF.reg_arr\[31\]\[5\]
+ _1027_ _1029_ VGND VGND VPWR VPWR _1036_ sky130_fd_sc_hd__mux4_1
XTAP_TAPCELL_ROW_87_1301 VGND VPWR sky130_fd_sc_hd__tapvpwrvgnd_1
X_8986_ clknet_leaf_29_CLK _0219_ VGND VGND VPWR VPWR RF.reg_arr\[31\]\[28\] sky130_fd_sc_hd__dfxtp_1
XTAP_TAPCELL_ROW_2_278 VGND VPWR sky130_fd_sc_hd__tapvpwrvgnd_1
X_7937_ _3025_ net602 _3933_ VGND VGND VPWR VPWR _3937_ sky130_fd_sc_hd__mux2_1
XFILLER_0_65_514 VGND VGND VPWR VPWR sky130_fd_sc_hd__decap_4
XFILLER_0_65_503 VGND VGND VPWR VPWR sky130_fd_sc_hd__fill_1
X_7868_ _3900_ VGND VGND VPWR VPWR _0459_ sky130_fd_sc_hd__clkbuf_1
X_6819_ _3326_ VGND VGND VPWR VPWR _1008_ sky130_fd_sc_hd__clkbuf_1
XFILLER_0_9_162 VGND VGND VPWR VPWR sky130_fd_sc_hd__decap_6
X_7799_ _3863_ VGND VGND VPWR VPWR _0427_ sky130_fd_sc_hd__clkbuf_1
XTAP_TAPCELL_ROW_98_1430 VGND VPWR sky130_fd_sc_hd__tapvpwrvgnd_1
X_9469_ clknet_leaf_24_CLK _0702_ VGND VGND VPWR VPWR RF.reg_arr\[12\]\[31\] sky130_fd_sc_hd__dfxtp_1
XFILLER_0_33_433 VGND VGND VPWR VPWR sky130_fd_sc_hd__fill_1
XFILLER_0_103_387 VGND VGND VPWR VPWR sky130_fd_sc_hd__fill_1
XFILLER_0_88_639 VGND VGND VPWR VPWR sky130_fd_sc_hd__decap_4
XFILLER_0_87_105 VGND VGND VPWR VPWR sky130_fd_sc_hd__decap_6
XPHY_EDGE_ROW_85_Left_202 VGND VGND VPWR VPWR sky130_fd_sc_hd__decap_3
XTAP_TAPCELL_ROW_57_940 VGND VPWR sky130_fd_sc_hd__tapvpwrvgnd_1
XFILLER_0_87_138 VGND VGND VPWR VPWR sky130_fd_sc_hd__decap_4
XFILLER_0_95_160 VGND VGND VPWR VPWR sky130_fd_sc_hd__decap_8
XFILLER_0_56_514 VGND VGND VPWR VPWR sky130_fd_sc_hd__fill_1
XFILLER_0_113_15 VPWR VGND VPWR VGND sky130_ef_sc_hd__decap_12
XFILLER_0_28_249 VGND VGND VPWR VPWR sky130_fd_sc_hd__decap_3
XTAP_TAPCELL_ROW_103_1489 VGND VPWR sky130_fd_sc_hd__tapvpwrvgnd_1
XFILLER_0_107_671 VGND VGND VPWR VPWR sky130_fd_sc_hd__fill_1
XPHY_EDGE_ROW_94_Left_211 VGND VGND VPWR VPWR sky130_fd_sc_hd__decap_3
XFILLER_0_24_477 VGND VGND VPWR VPWR sky130_fd_sc_hd__decap_8
XFILLER_0_12_639 VGND VGND VPWR VPWR sky130_fd_sc_hd__decap_4
XTAP_TAPCELL_ROW_71_1102 VGND VPWR sky130_fd_sc_hd__tapvpwrvgnd_1
X_5150_ _1865_ _1938_ _1635_ VGND VGND VPWR VPWR _1939_ sky130_fd_sc_hd__o21a_1
X_5081_ _1648_ _1869_ VGND VGND VPWR VPWR _1870_ sky130_fd_sc_hd__nand2_1
XFILLER_0_79_617 VGND VGND VPWR VPWR sky130_fd_sc_hd__fill_1
X_8840_ clknet_leaf_11_CLK _0073_ VGND VGND VPWR VPWR RF.reg_arr\[19\]\[10\] sky130_fd_sc_hd__dfxtp_1
X_5983_ _1946_ _1998_ VGND VGND VPWR VPWR _2754_ sky130_fd_sc_hd__nand2_1
XFILLER_0_87_650 VGND VGND VPWR VPWR sky130_fd_sc_hd__fill_1
XTAP_TAPCELL_ROW_69_1075 VGND VPWR sky130_fd_sc_hd__tapvpwrvgnd_1
X_8771_ clknet_leaf_80_CLK _0004_ VGND VGND VPWR VPWR RF.reg_arr\[5\]\[5\] sky130_fd_sc_hd__dfxtp_1
XTAP_TAPCELL_ROW_82_1231 VGND VPWR sky130_fd_sc_hd__tapvpwrvgnd_1
X_4934_ _1077_ _1722_ VGND VGND VPWR VPWR _1723_ sky130_fd_sc_hd__nand2_1
X_7722_ _3822_ VGND VGND VPWR VPWR _0391_ sky130_fd_sc_hd__clkbuf_1
XTAP_TAPCELL_ROW_35_667 VGND VPWR sky130_fd_sc_hd__tapvpwrvgnd_1
XANTENNA_12 _1696_ VGND VGND VPWR VPWR sky130_fd_sc_hd__diode_2
XFILLER_0_74_344 VGND VGND VPWR VPWR sky130_fd_sc_hd__fill_2
X_4865_ _1650_ _1651_ _1652_ _1653_ _1614_ _1637_ VGND VGND VPWR VPWR _1654_ sky130_fd_sc_hd__mux4_1
XANTENNA_23 net36 VGND VGND VPWR VPWR sky130_fd_sc_hd__diode_2
XFILLER_0_7_633 VGND VGND VPWR VPWR sky130_fd_sc_hd__decap_8
X_7653_ _3075_ net815 _3777_ VGND VGND VPWR VPWR _3786_ sky130_fd_sc_hd__mux2_1
X_4796_ net5 VGND VGND VPWR VPWR _1585_ sky130_fd_sc_hd__buf_4
XFILLER_0_27_260 VGND VGND VPWR VPWR sky130_fd_sc_hd__decap_4
X_7584_ _3749_ VGND VGND VPWR VPWR _0326_ sky130_fd_sc_hd__clkbuf_1
X_6604_ _3211_ VGND VGND VPWR VPWR _0908_ sky130_fd_sc_hd__clkbuf_1
XFILLER_0_15_444 VGND VGND VPWR VPWR sky130_fd_sc_hd__decap_4
X_9323_ clknet_leaf_93_CLK _0556_ VGND VGND VPWR VPWR RF.reg_arr\[20\]\[13\] sky130_fd_sc_hd__dfxtp_1
X_6535_ net145 _3025_ _3171_ VGND VGND VPWR VPWR _3175_ sky130_fd_sc_hd__mux2_1
XFILLER_0_104_129 VGND VGND VPWR VPWR sky130_fd_sc_hd__fill_1
X_9254_ clknet_leaf_81_CLK _0487_ VGND VGND VPWR VPWR RF.reg_arr\[21\]\[8\] sky130_fd_sc_hd__dfxtp_1
XFILLER_0_30_414 VGND VGND VPWR VPWR sky130_fd_sc_hd__decap_6
X_6466_ net109 VGND VGND VPWR VPWR _3138_ sky130_fd_sc_hd__clkbuf_1
X_8205_ _3021_ net640 _4077_ VGND VGND VPWR VPWR _4079_ sky130_fd_sc_hd__mux2_1
XFILLER_0_113_685 VGND VGND VPWR VPWR sky130_fd_sc_hd__decap_6
X_5417_ _2204_ _2205_ _1863_ VGND VGND VPWR VPWR _2206_ sky130_fd_sc_hd__mux2_1
X_6397_ net23 VGND VGND VPWR VPWR _3096_ sky130_fd_sc_hd__clkbuf_2
X_9185_ clknet_leaf_69_CLK _0418_ VGND VGND VPWR VPWR RF.reg_arr\[24\]\[3\] sky130_fd_sc_hd__dfxtp_1
XTAP_TAPCELL_ROW_93_1371 VGND VPWR sky130_fd_sc_hd__tapvpwrvgnd_1
XTAP_TAPCELL_ROW_7_337 VGND VPWR sky130_fd_sc_hd__tapvpwrvgnd_1
X_5348_ RF.reg_arr\[0\]\[14\] RF.reg_arr\[1\]\[14\] RF.reg_arr\[2\]\[14\] RF.reg_arr\[3\]\[14\]
+ _1847_ _1850_ VGND VGND VPWR VPWR _2137_ sky130_fd_sc_hd__mux4_1
X_8136_ _4042_ VGND VGND VPWR VPWR _0585_ sky130_fd_sc_hd__clkbuf_1
XFILLER_0_10_193 VGND VGND VPWR VPWR sky130_fd_sc_hd__decap_3
X_8067_ _3018_ net792 _4005_ VGND VGND VPWR VPWR _4006_ sky130_fd_sc_hd__mux2_1
X_5279_ _1584_ _2067_ VGND VGND VPWR VPWR _2068_ sky130_fd_sc_hd__nor2_1
X_7018_ net10 net9 VGND VGND VPWR VPWR _3447_ sky130_fd_sc_hd__nand2_2
XFILLER_0_85_609 VGND VGND VPWR VPWR sky130_fd_sc_hd__decap_6
X_8969_ clknet_leaf_14_CLK _0202_ VGND VGND VPWR VPWR RF.reg_arr\[31\]\[11\] sky130_fd_sc_hd__dfxtp_1
XFILLER_0_93_653 VGND VGND VPWR VPWR sky130_fd_sc_hd__decap_3
XFILLER_0_92_185 VGND VGND VPWR VPWR sky130_fd_sc_hd__decap_8
XFILLER_0_65_388 VGND VGND VPWR VPWR sky130_fd_sc_hd__decap_4
XFILLER_0_80_369 VGND VGND VPWR VPWR sky130_fd_sc_hd__decap_8
XFILLER_0_61_561 VGND VGND VPWR VPWR sky130_fd_sc_hd__decap_3
XFILLER_0_33_274 VGND VGND VPWR VPWR sky130_fd_sc_hd__fill_2
XFILLER_0_108_26 VGND VGND VPWR VPWR sky130_fd_sc_hd__fill_2
XTAP_TAPCELL_ROW_105_1507 VGND VPWR sky130_fd_sc_hd__tapvpwrvgnd_1
XTAP_TAPCELL_ROW_32_637 VGND VPWR sky130_fd_sc_hd__tapvpwrvgnd_1
X_4650_ _1308_ _1438_ VGND VGND VPWR VPWR _1439_ sky130_fd_sc_hd__and2_1
XTAP_TAPCELL_ROW_60_968 VGND VPWR sky130_fd_sc_hd__tapvpwrvgnd_1
XFILLER_0_44_528 VGND VGND VPWR VPWR sky130_fd_sc_hd__decap_4
XFILLER_0_56_399 VGND VGND VPWR VPWR sky130_fd_sc_hd__fill_1
XFILLER_0_116_3 VPWR VGND VPWR VGND sky130_ef_sc_hd__decap_12
Xinput10 A3[1] VGND VGND VPWR VPWR net10 sky130_fd_sc_hd__buf_2
Xinput21 WD3[16] VGND VGND VPWR VPWR net21 sky130_fd_sc_hd__buf_1
Xinput32 WD3[26] VGND VGND VPWR VPWR net32 sky130_fd_sc_hd__buf_1
X_6320_ net29 VGND VGND VPWR VPWR _3046_ sky130_fd_sc_hd__buf_2
X_4581_ _1368_ _1369_ _1059_ VGND VGND VPWR VPWR _1370_ sky130_fd_sc_hd__mux2_1
XTAP_TAPCELL_ROW_12_394 VGND VPWR sky130_fd_sc_hd__tapvpwrvgnd_1
Xinput43 WD3[7] VGND VGND VPWR VPWR net43 sky130_fd_sc_hd__buf_1
XFILLER_0_52_561 VGND VGND VPWR VPWR sky130_fd_sc_hd__fill_2
XTAP_TAPCELL_ROW_116_1658 VGND VPWR sky130_fd_sc_hd__tapvpwrvgnd_1
XTAP_TAPCELL_ROW_116_1647 VGND VPWR sky130_fd_sc_hd__tapvpwrvgnd_1
Xhold805 RF.reg_arr\[30\]\[22\] VGND VGND VPWR VPWR net887 sky130_fd_sc_hd__dlygate4sd3_1
Xhold827 RF.reg_arr\[25\]\[5\] VGND VGND VPWR VPWR net909 sky130_fd_sc_hd__dlygate4sd3_1
Xhold816 RF.reg_arr\[30\]\[16\] VGND VGND VPWR VPWR net898 sky130_fd_sc_hd__dlygate4sd3_1
Xhold838 RF.reg_arr\[21\]\[12\] VGND VGND VPWR VPWR net920 sky130_fd_sc_hd__dlygate4sd3_1
Xhold849 RF.reg_arr\[7\]\[16\] VGND VGND VPWR VPWR net931 sky130_fd_sc_hd__dlygate4sd3_1
X_6251_ _2999_ VGND VGND VPWR VPWR _0767_ sky130_fd_sc_hd__clkbuf_1
X_6182_ _2351_ _2354_ VGND VGND VPWR VPWR _2942_ sky130_fd_sc_hd__nor2_1
Xclkbuf_leaf_30_CLK clknet_3_2__leaf_CLK VGND VGND VPWR VPWR clknet_leaf_30_CLK sky130_fd_sc_hd__clkbuf_8
X_5202_ RF.reg_arr\[0\]\[17\] RF.reg_arr\[1\]\[17\] RF.reg_arr\[2\]\[17\] RF.reg_arr\[3\]\[17\]
+ _1624_ _1597_ VGND VGND VPWR VPWR _1991_ sky130_fd_sc_hd__mux4_1
X_5133_ _1612_ _1921_ VGND VGND VPWR VPWR _1922_ sky130_fd_sc_hd__or2_1
X_5064_ RF.reg_arr\[12\]\[22\] RF.reg_arr\[13\]\[22\] RF.reg_arr\[14\]\[22\] RF.reg_arr\[15\]\[22\]
+ _1848_ _1851_ VGND VGND VPWR VPWR _1853_ sky130_fd_sc_hd__mux4_1
XFILLER_0_74_85 VGND VGND VPWR VPWR sky130_fd_sc_hd__decap_6
X_8823_ clknet_leaf_49_CLK _0056_ VGND VGND VPWR VPWR RF.reg_arr\[4\]\[25\] sky130_fd_sc_hd__dfxtp_1
XFILLER_0_87_480 VGND VGND VPWR VPWR sky130_fd_sc_hd__fill_1
X_5966_ _1517_ _1533_ _1549_ VGND VGND VPWR VPWR _2738_ sky130_fd_sc_hd__or3b_4
X_8754_ clknet_leaf_41_CLK _1011_ VGND VGND VPWR VPWR RF.reg_arr\[6\]\[20\] sky130_fd_sc_hd__dfxtp_1
XFILLER_0_66_119 VGND VGND VPWR VPWR sky130_fd_sc_hd__fill_2
Xclkbuf_leaf_97_CLK clknet_3_4__leaf_CLK VGND VGND VPWR VPWR clknet_leaf_97_CLK sky130_fd_sc_hd__clkbuf_8
XFILLER_0_47_311 VGND VGND VPWR VPWR sky130_fd_sc_hd__decap_3
X_4917_ _1704_ _1705_ _1613_ VGND VGND VPWR VPWR _1706_ sky130_fd_sc_hd__mux2_1
X_5897_ _2668_ _2671_ _2192_ VGND VGND VPWR VPWR _2673_ sky130_fd_sc_hd__a21o_1
X_8685_ clknet_leaf_103_CLK _0942_ VGND VGND VPWR VPWR RF.reg_arr\[15\]\[15\] sky130_fd_sc_hd__dfxtp_1
X_7705_ net845 _3387_ _3813_ VGND VGND VPWR VPWR _3814_ sky130_fd_sc_hd__mux2_1
X_4848_ _1636_ VGND VGND VPWR VPWR _1637_ sky130_fd_sc_hd__buf_4
XFILLER_0_7_441 VGND VGND VPWR VPWR sky130_fd_sc_hd__decap_4
X_7636_ _3776_ VGND VGND VPWR VPWR _3777_ sky130_fd_sc_hd__clkbuf_8
XFILLER_0_90_645 VGND VGND VPWR VPWR sky130_fd_sc_hd__decap_6
X_4779_ RF.reg_arr\[20\]\[24\] RF.reg_arr\[21\]\[24\] RF.reg_arr\[22\]\[24\] RF.reg_arr\[23\]\[24\]
+ _1327_ _1328_ VGND VGND VPWR VPWR _1568_ sky130_fd_sc_hd__mux4_1
XFILLER_0_105_449 VGND VGND VPWR VPWR sky130_fd_sc_hd__decap_4
X_9306_ clknet_leaf_29_CLK _0539_ VGND VGND VPWR VPWR RF.reg_arr\[25\]\[28\] sky130_fd_sc_hd__dfxtp_1
X_7567_ _2974_ _3267_ _2995_ VGND VGND VPWR VPWR _3740_ sky130_fd_sc_hd__and3_4
XFILLER_0_15_241 VGND VGND VPWR VPWR sky130_fd_sc_hd__fill_1
X_7498_ _2995_ _3556_ net46 _3702_ VGND VGND VPWR VPWR _3703_ sky130_fd_sc_hd__and4b_1
X_6518_ net623 _3008_ _3160_ VGND VGND VPWR VPWR _3166_ sky130_fd_sc_hd__mux2_1
XFILLER_0_101_633 VGND VGND VPWR VPWR sky130_fd_sc_hd__fill_1
X_9237_ clknet_leaf_40_CLK _0470_ VGND VGND VPWR VPWR RF.reg_arr\[22\]\[23\] sky130_fd_sc_hd__dfxtp_1
XFILLER_0_3_691 VGND VGND VPWR VPWR sky130_fd_sc_hd__fill_1
X_6449_ _3129_ VGND VGND VPWR VPWR _0835_ sky130_fd_sc_hd__clkbuf_1
Xclkbuf_leaf_21_CLK clknet_3_0__leaf_CLK VGND VGND VPWR VPWR clknet_leaf_21_CLK sky130_fd_sc_hd__clkbuf_8
X_9168_ clknet_leaf_2_CLK _0401_ VGND VGND VPWR VPWR RF.reg_arr\[9\]\[18\] sky130_fd_sc_hd__dfxtp_1
X_8119_ _4033_ VGND VGND VPWR VPWR _0577_ sky130_fd_sc_hd__clkbuf_1
XFILLER_0_100_187 VGND VGND VPWR VPWR sky130_fd_sc_hd__fill_1
X_9099_ clknet_leaf_90_CLK _0332_ VGND VGND VPWR VPWR RF.reg_arr\[2\]\[13\] sky130_fd_sc_hd__dfxtp_1
XFILLER_0_97_277 VGND VGND VPWR VPWR sky130_fd_sc_hd__decap_3
XFILLER_0_85_417 VGND VGND VPWR VPWR sky130_fd_sc_hd__fill_1
XFILLER_0_85_439 VGND VGND VPWR VPWR sky130_fd_sc_hd__fill_1
Xclkbuf_leaf_88_CLK clknet_3_4__leaf_CLK VGND VGND VPWR VPWR clknet_leaf_88_CLK sky130_fd_sc_hd__clkbuf_8
XTAP_TAPCELL_ROW_100_1448 VGND VPWR sky130_fd_sc_hd__tapvpwrvgnd_1
XFILLER_0_26_528 VGND VGND VPWR VPWR sky130_fd_sc_hd__decap_4
XFILLER_0_110_27 VGND VGND VPWR VPWR sky130_fd_sc_hd__fill_1
XFILLER_0_1_617 VPWR VGND VPWR VGND sky130_ef_sc_hd__decap_12
XFILLER_0_21_222 VGND VGND VPWR VPWR sky130_fd_sc_hd__fill_2
XFILLER_0_34_583 VGND VGND VPWR VPWR sky130_fd_sc_hd__decap_4
XFILLER_0_21_244 VGND VGND VPWR VPWR sky130_fd_sc_hd__decap_8
Xclkbuf_leaf_12_CLK clknet_3_1__leaf_CLK VGND VGND VPWR VPWR clknet_leaf_12_CLK sky130_fd_sc_hd__clkbuf_8
XTAP_TAPCELL_ROW_111_1588 VGND VPWR sky130_fd_sc_hd__tapvpwrvgnd_1
XFILLER_0_44_11 VGND VGND VPWR VPWR sky130_fd_sc_hd__fill_1
XTAP_TAPCELL_ROW_66_1045 VGND VPWR sky130_fd_sc_hd__tapvpwrvgnd_1
X_5820_ _2559_ _2599_ _2434_ VGND VGND VPWR VPWR _2600_ sky130_fd_sc_hd__mux2_1
XTAP_TAPCELL_ROW_17_453 VGND VPWR sky130_fd_sc_hd__tapvpwrvgnd_1
Xclkbuf_leaf_79_CLK clknet_3_5__leaf_CLK VGND VGND VPWR VPWR clknet_leaf_79_CLK sky130_fd_sc_hd__clkbuf_8
X_5751_ _1065_ _1090_ VGND VGND VPWR VPWR _2534_ sky130_fd_sc_hd__nand2_2
XFILLER_0_60_10 VGND VGND VPWR VPWR sky130_fd_sc_hd__fill_1
XPHY_EDGE_ROW_22_Left_139 VGND VGND VPWR VPWR sky130_fd_sc_hd__decap_3
XTAP_TAPCELL_ROW_45_795 VGND VPWR sky130_fd_sc_hd__tapvpwrvgnd_1
XFILLER_0_56_141 VGND VGND VPWR VPWR sky130_fd_sc_hd__fill_2
XFILLER_0_84_461 VPWR VGND VPWR VGND sky130_ef_sc_hd__decap_12
X_4702_ RF.reg_arr\[12\]\[12\] RF.reg_arr\[13\]\[12\] RF.reg_arr\[14\]\[12\] RF.reg_arr\[15\]\[12\]
+ _1186_ _1188_ VGND VGND VPWR VPWR _1491_ sky130_fd_sc_hd__mux4_1
X_8470_ _4218_ VGND VGND VPWR VPWR _0743_ sky130_fd_sc_hd__clkbuf_1
X_7421_ _3661_ VGND VGND VPWR VPWR _0251_ sky130_fd_sc_hd__clkbuf_1
X_5682_ _2372_ _2365_ _2029_ VGND VGND VPWR VPWR _2468_ sky130_fd_sc_hd__mux2_1
XFILLER_0_72_645 VGND VGND VPWR VPWR sky130_fd_sc_hd__decap_4
XFILLER_0_72_634 VGND VGND VPWR VPWR sky130_fd_sc_hd__fill_1
XFILLER_0_71_111 VGND VGND VPWR VPWR sky130_fd_sc_hd__fill_1
XFILLER_0_44_347 VGND VGND VPWR VPWR sky130_fd_sc_hd__decap_8
X_4633_ _1420_ _1421_ _1168_ VGND VGND VPWR VPWR _1422_ sky130_fd_sc_hd__mux2_1
XFILLER_0_25_561 VGND VGND VPWR VPWR sky130_fd_sc_hd__decap_4
XFILLER_0_114_246 VGND VGND VPWR VPWR sky130_fd_sc_hd__fill_2
X_7352_ _3117_ net771 _3616_ VGND VGND VPWR VPWR _3625_ sky130_fd_sc_hd__mux2_1
X_4564_ RF.reg_arr\[28\]\[21\] RF.reg_arr\[29\]\[21\] RF.reg_arr\[30\]\[21\] RF.reg_arr\[31\]\[21\]
+ _1082_ _1084_ VGND VGND VPWR VPWR _1353_ sky130_fd_sc_hd__mux4_1
Xhold602 RF.reg_arr\[4\]\[12\] VGND VGND VPWR VPWR net684 sky130_fd_sc_hd__dlygate4sd3_1
X_7283_ _3588_ VGND VGND VPWR VPWR _0186_ sky130_fd_sc_hd__clkbuf_1
Xhold613 RF.reg_arr\[8\]\[30\] VGND VGND VPWR VPWR net695 sky130_fd_sc_hd__dlygate4sd3_1
XTAP_TAPCELL_ROW_77_1174 VGND VPWR sky130_fd_sc_hd__tapvpwrvgnd_1
Xhold635 RF.reg_arr\[22\]\[31\] VGND VGND VPWR VPWR net717 sky130_fd_sc_hd__dlygate4sd3_1
Xhold624 RF.reg_arr\[17\]\[11\] VGND VGND VPWR VPWR net706 sky130_fd_sc_hd__dlygate4sd3_1
X_6303_ _3034_ VGND VGND VPWR VPWR _0784_ sky130_fd_sc_hd__clkbuf_1
XFILLER_0_40_531 VGND VGND VPWR VPWR sky130_fd_sc_hd__fill_1
X_6234_ net503 _2986_ _2978_ VGND VGND VPWR VPWR _2987_ sky130_fd_sc_hd__mux2_1
Xhold668 RF.reg_arr\[25\]\[27\] VGND VGND VPWR VPWR net750 sky130_fd_sc_hd__dlygate4sd3_1
X_4495_ _1158_ VGND VGND VPWR VPWR _1284_ sky130_fd_sc_hd__buf_4
Xhold646 RF.reg_arr\[28\]\[9\] VGND VGND VPWR VPWR net728 sky130_fd_sc_hd__dlygate4sd3_1
X_9022_ clknet_leaf_75_CLK _0255_ VGND VGND VPWR VPWR RF.reg_arr\[26\]\[0\] sky130_fd_sc_hd__dfxtp_1
Xhold657 RF.reg_arr\[15\]\[4\] VGND VGND VPWR VPWR net739 sky130_fd_sc_hd__dlygate4sd3_1
Xhold679 RF.reg_arr\[16\]\[18\] VGND VGND VPWR VPWR net761 sky130_fd_sc_hd__dlygate4sd3_1
XPHY_EDGE_ROW_31_Left_148 VGND VGND VPWR VPWR sky130_fd_sc_hd__decap_3
XFILLER_0_40_597 VGND VGND VPWR VPWR sky130_fd_sc_hd__fill_2
XTAP_TAPCELL_ROW_90_1330 VGND VPWR sky130_fd_sc_hd__tapvpwrvgnd_1
XFILLER_0_110_485 VGND VGND VPWR VPWR sky130_fd_sc_hd__fill_1
X_6165_ _2921_ _2924_ _2918_ VGND VGND VPWR VPWR _2926_ sky130_fd_sc_hd__a21oi_2
XFILLER_0_40_3 VGND VGND VPWR VPWR sky130_fd_sc_hd__decap_3
X_6096_ _1580_ _2860_ VGND VGND VPWR VPWR _2861_ sky130_fd_sc_hd__xnor2_1
X_5116_ _1903_ _1904_ _1854_ VGND VGND VPWR VPWR _1905_ sky130_fd_sc_hd__mux2_1
X_5047_ RF.reg_arr\[24\]\[22\] RF.reg_arr\[25\]\[22\] RF.reg_arr\[26\]\[22\] RF.reg_arr\[27\]\[22\]
+ _1590_ _1835_ VGND VGND VPWR VPWR _1836_ sky130_fd_sc_hd__mux4_1
XFILLER_0_67_406 VGND VGND VPWR VPWR sky130_fd_sc_hd__fill_2
X_6998_ _3436_ VGND VGND VPWR VPWR _0053_ sky130_fd_sc_hd__clkbuf_1
X_8806_ clknet_leaf_86_CLK _0039_ VGND VGND VPWR VPWR RF.reg_arr\[4\]\[8\] sky130_fd_sc_hd__dfxtp_1
XPHY_EDGE_ROW_40_Left_157 VGND VGND VPWR VPWR sky130_fd_sc_hd__decap_3
X_5949_ _2719_ _2721_ _1831_ VGND VGND VPWR VPWR _2722_ sky130_fd_sc_hd__mux2_1
X_8737_ clknet_leaf_64_CLK _0994_ VGND VGND VPWR VPWR RF.reg_arr\[6\]\[3\] sky130_fd_sc_hd__dfxtp_1
X_8668_ clknet_leaf_24_CLK _0925_ VGND VGND VPWR VPWR RF.reg_arr\[8\]\[30\] sky130_fd_sc_hd__dfxtp_1
X_7619_ net214 _3371_ _3763_ VGND VGND VPWR VPWR _3768_ sky130_fd_sc_hd__mux2_1
X_8599_ clknet_leaf_49_CLK _0856_ VGND VGND VPWR VPWR RF.reg_arr\[0\]\[25\] sky130_fd_sc_hd__dfxtp_1
XFILLER_0_63_689 VGND VGND VPWR VPWR sky130_fd_sc_hd__decap_3
XFILLER_0_7_260 VGND VGND VPWR VPWR sky130_fd_sc_hd__decap_6
XFILLER_0_31_520 VGND VGND VPWR VPWR sky130_fd_sc_hd__fill_2
XFILLER_0_105_279 VGND VGND VPWR VPWR sky130_fd_sc_hd__fill_1
XFILLER_0_31_564 VGND VGND VPWR VPWR sky130_fd_sc_hd__decap_4
XFILLER_0_31_575 VGND VGND VPWR VPWR sky130_fd_sc_hd__fill_2
XFILLER_0_58_406 VGND VGND VPWR VPWR sky130_fd_sc_hd__fill_2
XFILLER_0_85_225 VGND VGND VPWR VPWR sky130_fd_sc_hd__decap_4
XFILLER_0_58_439 VGND VGND VPWR VPWR sky130_fd_sc_hd__decap_3
Xclkbuf_leaf_1_CLK clknet_3_0__leaf_CLK VGND VGND VPWR VPWR clknet_leaf_1_CLK sky130_fd_sc_hd__clkbuf_8
XTAP_TAPCELL_ROW_14_423 VGND VPWR sky130_fd_sc_hd__tapvpwrvgnd_1
XFILLER_0_38_141 VGND VGND VPWR VPWR sky130_fd_sc_hd__decap_8
XFILLER_0_38_152 VGND VGND VPWR VPWR sky130_fd_sc_hd__decap_4
XTAP_TAPCELL_ROW_42_754 VGND VPWR sky130_fd_sc_hd__tapvpwrvgnd_1
XFILLER_0_109_574 VGND VGND VPWR VPWR sky130_fd_sc_hd__fill_1
XFILLER_0_109_552 VGND VGND VPWR VPWR sky130_fd_sc_hd__fill_1
XFILLER_0_53_100 VGND VGND VPWR VPWR sky130_fd_sc_hd__fill_1
XFILLER_0_53_166 VGND VGND VPWR VPWR sky130_fd_sc_hd__fill_2
XTAP_TAPCELL_ROW_113_1606 VGND VPWR sky130_fd_sc_hd__tapvpwrvgnd_1
XFILLER_0_22_531 VGND VGND VPWR VPWR sky130_fd_sc_hd__fill_1
XFILLER_0_39_66 VGND VGND VPWR VPWR sky130_fd_sc_hd__fill_2
X_4280_ _1028_ VGND VGND VPWR VPWR _1069_ sky130_fd_sc_hd__buf_4
X_7970_ _2988_ net560 _3944_ VGND VGND VPWR VPWR _3954_ sky130_fd_sc_hd__mux2_1
XFILLER_0_89_531 VGND VGND VPWR VPWR sky130_fd_sc_hd__fill_1
XFILLER_0_55_54 VGND VGND VPWR VPWR sky130_fd_sc_hd__fill_2
X_6921_ net296 _3383_ _3343_ VGND VGND VPWR VPWR _3384_ sky130_fd_sc_hd__mux2_1
XFILLER_0_89_586 VGND VGND VPWR VPWR sky130_fd_sc_hd__fill_2
XFILLER_0_71_20 VGND VGND VPWR VPWR sky130_fd_sc_hd__fill_1
X_6852_ net528 _2994_ _3344_ VGND VGND VPWR VPWR _3345_ sky130_fd_sc_hd__mux2_1
X_5803_ _1832_ _2583_ _2445_ VGND VGND VPWR VPWR _2584_ sky130_fd_sc_hd__o21a_1
XFILLER_0_71_86 VGND VGND VPWR VPWR sky130_fd_sc_hd__fill_1
XFILLER_0_57_461 VGND VGND VPWR VPWR sky130_fd_sc_hd__fill_1
X_8522_ clknet_leaf_97_CLK _0779_ VGND VGND VPWR VPWR RF.reg_arr\[1\]\[12\] sky130_fd_sc_hd__dfxtp_1
X_6783_ net567 _2994_ _3307_ VGND VGND VPWR VPWR _3308_ sky130_fd_sc_hd__mux2_1
XFILLER_0_84_280 VGND VGND VPWR VPWR sky130_fd_sc_hd__decap_6
X_5734_ _2500_ _2503_ _2499_ VGND VGND VPWR VPWR _2518_ sky130_fd_sc_hd__a21o_1
XFILLER_0_17_314 VGND VGND VPWR VPWR sky130_fd_sc_hd__fill_1
XFILLER_0_45_623 VGND VGND VPWR VPWR sky130_fd_sc_hd__fill_1
XTAP_TAPCELL_ROW_79_1203 VGND VPWR sky130_fd_sc_hd__tapvpwrvgnd_1
X_5665_ _2337_ _2346_ _2451_ VGND VGND VPWR VPWR _2452_ sky130_fd_sc_hd__o21a_1
XFILLER_0_45_667 VGND VGND VPWR VPWR sky130_fd_sc_hd__fill_2
X_8453_ _4209_ VGND VGND VPWR VPWR _0735_ sky130_fd_sc_hd__clkbuf_1
XFILLER_0_88_3 VGND VGND VPWR VPWR sky130_fd_sc_hd__decap_3
X_7404_ _3100_ net696 _3652_ VGND VGND VPWR VPWR _3653_ sky130_fd_sc_hd__mux2_1
X_8384_ _2976_ _3447_ VGND VGND VPWR VPWR _4173_ sky130_fd_sc_hd__nor2_2
XFILLER_0_60_626 VGND VGND VPWR VPWR sky130_fd_sc_hd__fill_2
X_4616_ RF.reg_arr\[24\]\[7\] RF.reg_arr\[25\]\[7\] RF.reg_arr\[26\]\[7\] RF.reg_arr\[27\]\[7\]
+ _1186_ _1188_ VGND VGND VPWR VPWR _1405_ sky130_fd_sc_hd__mux4_1
XPHY_EDGE_ROW_111_Right_111 VGND VGND VPWR VPWR sky130_fd_sc_hd__decap_3
X_5596_ _1114_ _2331_ VGND VGND VPWR VPWR _2384_ sky130_fd_sc_hd__nand2_1
Xhold410 RF.reg_arr\[26\]\[22\] VGND VGND VPWR VPWR net492 sky130_fd_sc_hd__dlygate4sd3_1
X_7335_ _3593_ VGND VGND VPWR VPWR _3616_ sky130_fd_sc_hd__clkbuf_8
Xhold421 RF.reg_arr\[10\]\[28\] VGND VGND VPWR VPWR net503 sky130_fd_sc_hd__dlygate4sd3_1
Xhold443 RF.reg_arr\[25\]\[28\] VGND VGND VPWR VPWR net525 sky130_fd_sc_hd__dlygate4sd3_1
Xhold454 RF.reg_arr\[23\]\[27\] VGND VGND VPWR VPWR net536 sky130_fd_sc_hd__dlygate4sd3_1
Xhold432 RF.reg_arr\[30\]\[23\] VGND VGND VPWR VPWR net514 sky130_fd_sc_hd__dlygate4sd3_1
X_4547_ RF.reg_arr\[28\]\[20\] RF.reg_arr\[29\]\[20\] RF.reg_arr\[30\]\[20\] RF.reg_arr\[31\]\[20\]
+ _1129_ _1130_ VGND VGND VPWR VPWR _1336_ sky130_fd_sc_hd__mux4_1
XFILLER_0_40_361 VGND VGND VPWR VPWR sky130_fd_sc_hd__decap_3
Xhold487 RF.reg_arr\[1\]\[21\] VGND VGND VPWR VPWR net569 sky130_fd_sc_hd__dlygate4sd3_1
Xhold465 RF.reg_arr\[2\]\[23\] VGND VGND VPWR VPWR net547 sky130_fd_sc_hd__dlygate4sd3_1
X_7266_ _3579_ VGND VGND VPWR VPWR _0178_ sky130_fd_sc_hd__clkbuf_1
Xhold476 RF.reg_arr\[29\]\[3\] VGND VGND VPWR VPWR net558 sky130_fd_sc_hd__dlygate4sd3_1
X_4478_ RF.reg_arr\[0\]\[11\] RF.reg_arr\[1\]\[11\] RF.reg_arr\[2\]\[11\] RF.reg_arr\[3\]\[11\]
+ _1262_ _1045_ VGND VGND VPWR VPWR _1267_ sky130_fd_sc_hd__mux4_1
XFILLER_0_96_94 VGND VGND VPWR VPWR sky130_fd_sc_hd__decap_8
XFILLER_0_96_83 VGND VGND VPWR VPWR sky130_fd_sc_hd__fill_1
X_6217_ net46 VGND VGND VPWR VPWR _2974_ sky130_fd_sc_hd__buf_2
X_9005_ clknet_leaf_105_CLK _0238_ VGND VGND VPWR VPWR RF.reg_arr\[27\]\[15\] sky130_fd_sc_hd__dfxtp_1
Xhold498 RF.reg_arr\[7\]\[7\] VGND VGND VPWR VPWR net580 sky130_fd_sc_hd__dlygate4sd3_1
X_7197_ _3542_ VGND VGND VPWR VPWR _0146_ sky130_fd_sc_hd__clkbuf_1
X_6148_ _2465_ _2588_ VGND VGND VPWR VPWR _2910_ sky130_fd_sc_hd__or2_1
X_6079_ _1791_ _1893_ VGND VGND VPWR VPWR _2844_ sky130_fd_sc_hd__nand2_1
XFILLER_0_95_578 VGND VGND VPWR VPWR sky130_fd_sc_hd__decap_3
XFILLER_0_48_483 VGND VGND VPWR VPWR sky130_fd_sc_hd__fill_1
XFILLER_0_63_453 VGND VGND VPWR VPWR sky130_fd_sc_hd__fill_1
XFILLER_0_51_604 VGND VGND VPWR VPWR sky130_fd_sc_hd__fill_2
XFILLER_0_116_15 VPWR VGND VPWR VGND sky130_ef_sc_hd__decap_12
XTAP_TAPCELL_ROW_47_813 VGND VPWR sky130_fd_sc_hd__tapvpwrvgnd_1
XFILLER_0_25_57 VGND VGND VPWR VPWR sky130_fd_sc_hd__fill_2
XFILLER_0_86_545 VGND VGND VPWR VPWR sky130_fd_sc_hd__decap_3
XTAP_TAPCELL_ROW_63_1004 VGND VPWR sky130_fd_sc_hd__tapvpwrvgnd_1
XTAP_TAPCELL_ROW_27_570 VGND VPWR sky130_fd_sc_hd__tapvpwrvgnd_1
XFILLER_0_86_589 VGND VGND VPWR VPWR sky130_fd_sc_hd__decap_6
XTAP_TAPCELL_ROW_27_581 VGND VPWR sky130_fd_sc_hd__tapvpwrvgnd_1
XFILLER_0_26_155 VGND VGND VPWR VPWR sky130_fd_sc_hd__fill_2
X_5450_ RF.reg_arr\[16\]\[7\] RF.reg_arr\[17\]\[7\] RF.reg_arr\[18\]\[7\] RF.reg_arr\[19\]\[7\]
+ _1883_ _1885_ VGND VGND VPWR VPWR _2239_ sky130_fd_sc_hd__mux4_1
XFILLER_0_14_339 VPWR VGND VPWR VGND sky130_ef_sc_hd__decap_12
XFILLER_0_42_626 VGND VGND VPWR VPWR sky130_fd_sc_hd__fill_1
X_4401_ RF.reg_arr\[24\]\[18\] RF.reg_arr\[25\]\[18\] RF.reg_arr\[26\]\[18\] RF.reg_arr\[27\]\[18\]
+ _1187_ _1189_ VGND VGND VPWR VPWR _1190_ sky130_fd_sc_hd__mux4_1
XFILLER_0_41_136 VGND VGND VPWR VPWR sky130_fd_sc_hd__decap_4
X_5381_ _1844_ _2169_ VGND VGND VPWR VPWR _2170_ sky130_fd_sc_hd__nand2_1
XTAP_TAPCELL_ROW_74_1144 VGND VPWR sky130_fd_sc_hd__tapvpwrvgnd_1
X_4332_ _1075_ VGND VGND VPWR VPWR _1121_ sky130_fd_sc_hd__clkbuf_8
X_7120_ net386 _3420_ _3496_ VGND VGND VPWR VPWR _3502_ sky130_fd_sc_hd__mux2_1
X_7051_ _3465_ VGND VGND VPWR VPWR _0077_ sky130_fd_sc_hd__clkbuf_1
X_4263_ _1028_ VGND VGND VPWR VPWR _1052_ sky130_fd_sc_hd__buf_4
XPHY_EDGE_ROW_105_Left_222 VGND VGND VPWR VPWR sky130_fd_sc_hd__decap_3
X_6002_ _1185_ _2547_ _2770_ _2771_ VGND VGND VPWR VPWR _2772_ sky130_fd_sc_hd__a2bb2o_4
XFILLER_0_10_589 VGND VGND VPWR VPWR sky130_fd_sc_hd__decap_6
XFILLER_0_96_309 VGND VGND VPWR VPWR sky130_fd_sc_hd__fill_1
X_7953_ _3945_ VGND VGND VPWR VPWR _0499_ sky130_fd_sc_hd__clkbuf_1
X_6904_ _3372_ VGND VGND VPWR VPWR _0023_ sky130_fd_sc_hd__clkbuf_1
XFILLER_0_89_361 VGND VGND VPWR VPWR sky130_fd_sc_hd__decap_6
XFILLER_0_82_52 VGND VGND VPWR VPWR sky130_fd_sc_hd__fill_1
XTAP_TAPCELL_ROW_85_1273 VGND VPWR sky130_fd_sc_hd__tapvpwrvgnd_1
XFILLER_0_82_85 VGND VGND VPWR VPWR sky130_fd_sc_hd__fill_2
X_7884_ _3100_ net625 _3908_ VGND VGND VPWR VPWR _3909_ sky130_fd_sc_hd__mux2_1
X_6835_ net445 _2980_ _3329_ VGND VGND VPWR VPWR _3335_ sky130_fd_sc_hd__mux2_1
XFILLER_0_9_311 VGND VGND VPWR VPWR sky130_fd_sc_hd__fill_1
XFILLER_0_37_409 VGND VGND VPWR VPWR sky130_fd_sc_hd__fill_1
XPHY_EDGE_ROW_114_Left_231 VGND VGND VPWR VPWR sky130_fd_sc_hd__decap_3
X_6766_ _3111_ net748 _3292_ VGND VGND VPWR VPWR _3298_ sky130_fd_sc_hd__mux2_1
XFILLER_0_18_645 VGND VGND VPWR VPWR sky130_fd_sc_hd__decap_3
X_8505_ clknet_leaf_37_CLK _0762_ VGND VGND VPWR VPWR RF.reg_arr\[10\]\[27\] sky130_fd_sc_hd__dfxtp_1
X_5717_ _2292_ _2455_ VGND VGND VPWR VPWR _2502_ sky130_fd_sc_hd__nor2_1
XFILLER_0_72_250 VGND VGND VPWR VPWR sky130_fd_sc_hd__fill_2
X_6697_ _3260_ VGND VGND VPWR VPWR _0952_ sky130_fd_sc_hd__clkbuf_1
X_9485_ clknet_leaf_103_CLK _0718_ VGND VGND VPWR VPWR RF.reg_arr\[11\]\[15\] sky130_fd_sc_hd__dfxtp_1
X_8436_ net347 net30 _4196_ VGND VGND VPWR VPWR _4201_ sky130_fd_sc_hd__mux2_1
X_5648_ _1719_ _1775_ _2434_ VGND VGND VPWR VPWR _2435_ sky130_fd_sc_hd__mux2_1
XFILLER_0_60_456 VGND VGND VPWR VPWR sky130_fd_sc_hd__decap_4
X_5579_ _1790_ _1892_ _1113_ VGND VGND VPWR VPWR _2367_ sky130_fd_sc_hd__mux2_1
X_8367_ _4164_ VGND VGND VPWR VPWR _0694_ sky130_fd_sc_hd__clkbuf_1
XFILLER_0_13_350 VGND VGND VPWR VPWR sky130_fd_sc_hd__fill_1
XFILLER_0_20_309 VGND VGND VPWR VPWR sky130_fd_sc_hd__decap_4
XFILLER_0_41_670 VGND VGND VPWR VPWR sky130_fd_sc_hd__fill_2
X_8298_ net294 _3437_ _4124_ VGND VGND VPWR VPWR _4128_ sky130_fd_sc_hd__mux2_1
Xhold262 RF.reg_arr\[18\]\[22\] VGND VGND VPWR VPWR net344 sky130_fd_sc_hd__dlygate4sd3_1
Xhold251 RF.reg_arr\[12\]\[6\] VGND VGND VPWR VPWR net333 sky130_fd_sc_hd__dlygate4sd3_1
Xhold240 RF.reg_arr\[5\]\[10\] VGND VGND VPWR VPWR net322 sky130_fd_sc_hd__dlygate4sd3_1
X_7318_ _3607_ VGND VGND VPWR VPWR _0202_ sky130_fd_sc_hd__clkbuf_1
Xhold273 RF.reg_arr\[18\]\[26\] VGND VGND VPWR VPWR net355 sky130_fd_sc_hd__dlygate4sd3_1
Xhold295 RF.reg_arr\[16\]\[12\] VGND VGND VPWR VPWR net377 sky130_fd_sc_hd__dlygate4sd3_1
Xhold284 RF.reg_arr\[4\]\[19\] VGND VGND VPWR VPWR net366 sky130_fd_sc_hd__dlygate4sd3_1
X_7249_ _3082_ net439 _3569_ VGND VGND VPWR VPWR _3571_ sky130_fd_sc_hd__mux2_1
XFILLER_0_95_364 VGND VGND VPWR VPWR sky130_fd_sc_hd__fill_1
XFILLER_0_55_217 VGND VGND VPWR VPWR sky130_fd_sc_hd__decap_4
XFILLER_0_95_386 VGND VGND VPWR VPWR sky130_fd_sc_hd__decap_6
XFILLER_0_83_559 VGND VGND VPWR VPWR sky130_fd_sc_hd__fill_1
XTAP_TAPCELL_ROW_24_540 VGND VPWR sky130_fd_sc_hd__tapvpwrvgnd_1
XTAP_TAPCELL_ROW_52_871 VGND VPWR sky130_fd_sc_hd__tapvpwrvgnd_1
XFILLER_0_11_15 VPWR VGND VPWR VGND sky130_ef_sc_hd__decap_12
XFILLER_0_36_486 VGND VGND VPWR VPWR sky130_fd_sc_hd__decap_3
XFILLER_0_51_401 VGND VGND VPWR VPWR sky130_fd_sc_hd__decap_3
XFILLER_0_102_580 VGND VGND VPWR VPWR sky130_fd_sc_hd__decap_3
Xinput8 A2[4] VGND VGND VPWR VPWR net8 sky130_fd_sc_hd__clkbuf_4
XTAP_TAPCELL_ROW_108_1549 VGND VPWR sky130_fd_sc_hd__tapvpwrvgnd_1
X_4950_ _1666_ _1719_ _1738_ VGND VGND VPWR VPWR _1739_ sky130_fd_sc_hd__mux2_1
XFILLER_0_98_191 VGND VGND VPWR VPWR sky130_fd_sc_hd__decap_4
XFILLER_0_86_331 VGND VGND VPWR VPWR sky130_fd_sc_hd__fill_1
X_4881_ RF.reg_arr\[20\]\[29\] RF.reg_arr\[21\]\[29\] RF.reg_arr\[22\]\[29\] RF.reg_arr\[23\]\[29\]
+ _1668_ _1669_ VGND VGND VPWR VPWR _1670_ sky130_fd_sc_hd__mux4_1
XFILLER_0_59_589 VGND VGND VPWR VPWR sky130_fd_sc_hd__decap_8
XFILLER_0_86_386 VGND VGND VPWR VPWR sky130_fd_sc_hd__fill_2
X_6620_ net671 _3042_ _3218_ VGND VGND VPWR VPWR _3220_ sky130_fd_sc_hd__mux2_1
X_6551_ _3183_ VGND VGND VPWR VPWR _0883_ sky130_fd_sc_hd__clkbuf_1
XFILLER_0_109_190 VGND VGND VPWR VPWR sky130_fd_sc_hd__fill_2
X_5502_ _1844_ _2290_ _1641_ VGND VGND VPWR VPWR _2291_ sky130_fd_sc_hd__o21ai_1
XFILLER_0_54_272 VGND VGND VPWR VPWR sky130_fd_sc_hd__decap_8
X_9270_ clknet_leaf_53_CLK _0503_ VGND VGND VPWR VPWR RF.reg_arr\[21\]\[24\] sky130_fd_sc_hd__dfxtp_1
X_6482_ net101 VGND VGND VPWR VPWR _3146_ sky130_fd_sc_hd__clkbuf_1
X_5433_ RF.reg_arr\[28\]\[5\] RF.reg_arr\[29\]\[5\] RF.reg_arr\[30\]\[5\] RF.reg_arr\[31\]\[5\]
+ _1589_ _1834_ VGND VGND VPWR VPWR _2222_ sky130_fd_sc_hd__mux4_1
XFILLER_0_42_489 VGND VGND VPWR VPWR sky130_fd_sc_hd__decap_4
X_8221_ _3037_ net479 _4077_ VGND VGND VPWR VPWR _4087_ sky130_fd_sc_hd__mux2_1
X_5364_ RF.reg_arr\[8\]\[15\] RF.reg_arr\[9\]\[15\] RF.reg_arr\[10\]\[15\] RF.reg_arr\[11\]\[15\]
+ _1675_ _1681_ VGND VGND VPWR VPWR _2153_ sky130_fd_sc_hd__mux4_1
X_8152_ _4050_ VGND VGND VPWR VPWR _0593_ sky130_fd_sc_hd__clkbuf_1
X_7103_ net370 _3403_ _3485_ VGND VGND VPWR VPWR _3493_ sky130_fd_sc_hd__mux2_1
X_4315_ _1059_ _1103_ _1061_ VGND VGND VPWR VPWR _1104_ sky130_fd_sc_hd__o21a_1
X_5295_ _1584_ _2083_ VGND VGND VPWR VPWR _2084_ sky130_fd_sc_hd__nor2_1
X_8083_ _3035_ net877 _4005_ VGND VGND VPWR VPWR _4014_ sky130_fd_sc_hd__mux2_1
X_7034_ _3456_ VGND VGND VPWR VPWR _0069_ sky130_fd_sc_hd__clkbuf_1
X_4246_ _1030_ _1031_ _1034_ VGND VGND VPWR VPWR _1035_ sky130_fd_sc_hd__mux2_1
X_8985_ clknet_leaf_33_CLK _0218_ VGND VGND VPWR VPWR RF.reg_arr\[31\]\[27\] sky130_fd_sc_hd__dfxtp_1
XTAP_TAPCELL_ROW_2_279 VGND VPWR sky130_fd_sc_hd__tapvpwrvgnd_1
X_7936_ _3936_ VGND VGND VPWR VPWR _0491_ sky130_fd_sc_hd__clkbuf_1
X_7867_ _3084_ net672 _3897_ VGND VGND VPWR VPWR _3900_ sky130_fd_sc_hd__mux2_1
XFILLER_0_77_386 VGND VGND VPWR VPWR sky130_fd_sc_hd__decap_6
XFILLER_0_9_152 VGND VGND VPWR VPWR sky130_fd_sc_hd__fill_1
X_6818_ net827 _3033_ _3318_ VGND VGND VPWR VPWR _3326_ sky130_fd_sc_hd__mux2_1
XFILLER_0_65_559 VGND VGND VPWR VPWR sky130_fd_sc_hd__fill_1
X_7798_ _3084_ net1117 _3860_ VGND VGND VPWR VPWR _3863_ sky130_fd_sc_hd__mux2_1
XFILLER_0_18_442 VGND VGND VPWR VPWR sky130_fd_sc_hd__decap_6
XTAP_TAPCELL_ROW_98_1431 VGND VPWR sky130_fd_sc_hd__tapvpwrvgnd_1
XFILLER_0_92_389 VGND VGND VPWR VPWR sky130_fd_sc_hd__fill_2
X_6749_ _3094_ net1108 _3281_ VGND VGND VPWR VPWR _3289_ sky130_fd_sc_hd__mux2_1
X_9468_ clknet_leaf_24_CLK _0701_ VGND VGND VPWR VPWR RF.reg_arr\[12\]\[30\] sky130_fd_sc_hd__dfxtp_1
XFILLER_0_60_242 VGND VGND VPWR VPWR sky130_fd_sc_hd__fill_1
XFILLER_0_5_391 VGND VGND VPWR VPWR sky130_fd_sc_hd__fill_1
X_8419_ net1052 _3422_ _4185_ VGND VGND VPWR VPWR _4192_ sky130_fd_sc_hd__mux2_1
X_9399_ clknet_leaf_41_CLK _0632_ VGND VGND VPWR VPWR RF.reg_arr\[13\]\[25\] sky130_fd_sc_hd__dfxtp_1
Xclkbuf_3_1__f_CLK clknet_0_CLK VGND VGND VPWR VPWR clknet_3_1__leaf_CLK sky130_fd_sc_hd__clkbuf_16
XFILLER_0_88_618 VPWR VGND VPWR VGND sky130_ef_sc_hd__decap_12
XTAP_TAPCELL_ROW_57_930 VGND VPWR sky130_fd_sc_hd__tapvpwrvgnd_1
XTAP_TAPCELL_ROW_57_941 VGND VPWR sky130_fd_sc_hd__tapvpwrvgnd_1
XFILLER_0_56_504 VGND VGND VPWR VPWR sky130_fd_sc_hd__fill_1
XFILLER_0_113_27 VPWR VGND VPWR VGND sky130_ef_sc_hd__decap_12
XFILLER_0_11_106 VGND VGND VPWR VPWR sky130_fd_sc_hd__decap_6
XTAP_TAPCELL_ROW_71_1103 VGND VPWR sky130_fd_sc_hd__tapvpwrvgnd_1
XFILLER_0_20_640 VGND VGND VPWR VPWR sky130_fd_sc_hd__decap_4
XFILLER_0_47_22 VGND VGND VPWR VPWR sky130_fd_sc_hd__fill_1
X_5080_ _1833_ _1868_ VGND VGND VPWR VPWR _1869_ sky130_fd_sc_hd__or2_1
XFILLER_0_47_77 VGND VGND VPWR VPWR sky130_fd_sc_hd__decap_3
XFILLER_0_63_21 VGND VGND VPWR VPWR sky130_fd_sc_hd__fill_1
XFILLER_0_2_57 VGND VGND VPWR VPWR sky130_fd_sc_hd__fill_1
X_5982_ _2442_ _2746_ _2443_ VGND VGND VPWR VPWR _2753_ sky130_fd_sc_hd__o21ai_1
XFILLER_0_78_128 VGND VGND VPWR VPWR sky130_fd_sc_hd__fill_1
XTAP_TAPCELL_ROW_69_1076 VGND VPWR sky130_fd_sc_hd__tapvpwrvgnd_1
X_8770_ clknet_leaf_66_CLK _0003_ VGND VGND VPWR VPWR RF.reg_arr\[5\]\[4\] sky130_fd_sc_hd__dfxtp_1
XFILLER_0_87_673 VGND VGND VPWR VPWR sky130_fd_sc_hd__fill_1
XTAP_TAPCELL_ROW_82_1232 VGND VPWR sky130_fd_sc_hd__tapvpwrvgnd_1
X_4933_ _1720_ _1721_ _1033_ VGND VGND VPWR VPWR _1722_ sky130_fd_sc_hd__mux2_1
X_7721_ net551 _3405_ _3813_ VGND VGND VPWR VPWR _3822_ sky130_fd_sc_hd__mux2_1
XTAP_TAPCELL_ROW_35_668 VGND VPWR sky130_fd_sc_hd__tapvpwrvgnd_1
XFILLER_0_47_526 VPWR VGND VPWR VGND sky130_ef_sc_hd__decap_12
XANTENNA_13 _1808_ VGND VGND VPWR VPWR sky130_fd_sc_hd__diode_2
X_4864_ RF.reg_arr\[24\]\[30\] RF.reg_arr\[25\]\[30\] RF.reg_arr\[26\]\[30\] RF.reg_arr\[27\]\[30\]
+ _1627_ _1629_ VGND VGND VPWR VPWR _1653_ sky130_fd_sc_hd__mux4_1
XFILLER_0_7_601 VGND VGND VPWR VPWR sky130_fd_sc_hd__decap_3
X_7652_ _3785_ VGND VGND VPWR VPWR _0358_ sky130_fd_sc_hd__clkbuf_1
XFILLER_0_47_559 VGND VGND VPWR VPWR sky130_fd_sc_hd__fill_1
X_4795_ _1583_ VGND VGND VPWR VPWR _1584_ sky130_fd_sc_hd__buf_2
XFILLER_0_105_609 VGND VGND VPWR VPWR sky130_fd_sc_hd__decap_6
XFILLER_0_15_401 VGND VGND VPWR VPWR sky130_fd_sc_hd__fill_2
X_7583_ net189 _3403_ _3741_ VGND VGND VPWR VPWR _3749_ sky130_fd_sc_hd__mux2_1
X_6603_ net603 _3025_ _3207_ VGND VGND VPWR VPWR _3211_ sky130_fd_sc_hd__mux2_1
XANTENNA_24 A2[3] VGND VGND VPWR VPWR sky130_fd_sc_hd__diode_2
X_9322_ clknet_leaf_99_CLK _0555_ VGND VGND VPWR VPWR RF.reg_arr\[20\]\[12\] sky130_fd_sc_hd__dfxtp_1
X_6534_ _3174_ VGND VGND VPWR VPWR _0875_ sky130_fd_sc_hd__clkbuf_1
XFILLER_0_7_689 VGND VGND VPWR VPWR sky130_fd_sc_hd__decap_3
XFILLER_0_15_434 VGND VGND VPWR VPWR sky130_fd_sc_hd__fill_1
XFILLER_0_88_40 VPWR VGND VPWR VGND sky130_ef_sc_hd__decap_12
X_9253_ clknet_leaf_83_CLK _0486_ VGND VGND VPWR VPWR RF.reg_arr\[21\]\[7\] sky130_fd_sc_hd__dfxtp_1
XFILLER_0_15_467 VGND VGND VPWR VPWR sky130_fd_sc_hd__fill_2
X_6465_ _3137_ VGND VGND VPWR VPWR _0843_ sky130_fd_sc_hd__clkbuf_1
XFILLER_0_112_141 VGND VGND VPWR VPWR sky130_fd_sc_hd__decap_3
XFILLER_0_70_3 VGND VGND VPWR VPWR sky130_fd_sc_hd__decap_4
X_5416_ RF.reg_arr\[24\]\[4\] RF.reg_arr\[25\]\[4\] RF.reg_arr\[26\]\[4\] RF.reg_arr\[27\]\[4\]
+ _2030_ _1858_ VGND VGND VPWR VPWR _2205_ sky130_fd_sc_hd__mux4_1
X_8204_ _4078_ VGND VGND VPWR VPWR _0617_ sky130_fd_sc_hd__clkbuf_1
X_6396_ _3095_ VGND VGND VPWR VPWR _0816_ sky130_fd_sc_hd__clkbuf_1
X_9184_ clknet_leaf_69_CLK _0417_ VGND VGND VPWR VPWR RF.reg_arr\[24\]\[2\] sky130_fd_sc_hd__dfxtp_1
XTAP_TAPCELL_ROW_93_1372 VGND VPWR sky130_fd_sc_hd__tapvpwrvgnd_1
XTAP_TAPCELL_ROW_7_338 VGND VPWR sky130_fd_sc_hd__tapvpwrvgnd_1
X_5347_ RF.reg_arr\[4\]\[14\] RF.reg_arr\[5\]\[14\] RF.reg_arr\[6\]\[14\] RF.reg_arr\[7\]\[14\]
+ _1847_ _1850_ VGND VGND VPWR VPWR _2136_ sky130_fd_sc_hd__mux4_1
X_8135_ net172 _3409_ _4041_ VGND VGND VPWR VPWR _4042_ sky130_fd_sc_hd__mux2_1
X_5278_ _1643_ _2058_ _2062_ _2066_ VGND VGND VPWR VPWR _2067_ sky130_fd_sc_hd__a2bb2o_2
X_8066_ _3993_ VGND VGND VPWR VPWR _4005_ sky130_fd_sc_hd__clkbuf_8
X_7017_ _3446_ VGND VGND VPWR VPWR _0062_ sky130_fd_sc_hd__clkbuf_1
X_8968_ clknet_leaf_11_CLK _0201_ VGND VGND VPWR VPWR RF.reg_arr\[31\]\[10\] sky130_fd_sc_hd__dfxtp_1
XTAP_TAPCELL_ROW_54_900 VGND VPWR sky130_fd_sc_hd__tapvpwrvgnd_1
X_7919_ _3927_ VGND VGND VPWR VPWR _0483_ sky130_fd_sc_hd__clkbuf_1
XFILLER_0_93_621 VGND VGND VPWR VPWR sky130_fd_sc_hd__fill_1
XFILLER_0_65_312 VGND VGND VPWR VPWR sky130_fd_sc_hd__decap_6
X_8899_ clknet_leaf_87_CLK _0132_ VGND VGND VPWR VPWR RF.reg_arr\[7\]\[5\] sky130_fd_sc_hd__dfxtp_1
XFILLER_0_116_480 VGND VGND VPWR VPWR sky130_fd_sc_hd__fill_1
XFILLER_0_61_540 VGND VGND VPWR VPWR sky130_fd_sc_hd__decap_4
XFILLER_0_104_686 VGND VGND VPWR VPWR sky130_fd_sc_hd__decap_6
XTAP_TAPCELL_ROW_105_1508 VGND VPWR sky130_fd_sc_hd__tapvpwrvgnd_1
XFILLER_0_69_640 VGND VGND VPWR VPWR sky130_fd_sc_hd__decap_4
XFILLER_0_69_662 VGND VGND VPWR VPWR sky130_fd_sc_hd__fill_1
XFILLER_0_33_57 VGND VGND VPWR VPWR sky130_fd_sc_hd__fill_2
XFILLER_0_29_559 VGND VGND VPWR VPWR sky130_fd_sc_hd__fill_1
XTAP_TAPCELL_ROW_32_638 VGND VPWR sky130_fd_sc_hd__tapvpwrvgnd_1
XFILLER_0_56_356 VGND VGND VPWR VPWR sky130_fd_sc_hd__decap_3
XFILLER_0_71_315 VGND VGND VPWR VPWR sky130_fd_sc_hd__decap_4
XTAP_TAPCELL_ROW_60_969 VGND VPWR sky130_fd_sc_hd__tapvpwrvgnd_1
XFILLER_0_44_518 VGND VGND VPWR VPWR sky130_fd_sc_hd__fill_1
X_4580_ RF.reg_arr\[28\]\[22\] RF.reg_arr\[29\]\[22\] RF.reg_arr\[30\]\[22\] RF.reg_arr\[31\]\[22\]
+ _1082_ _1084_ VGND VGND VPWR VPWR _1369_ sky130_fd_sc_hd__mux4_1
Xinput22 WD3[17] VGND VGND VPWR VPWR net22 sky130_fd_sc_hd__buf_1
Xinput11 A3[2] VGND VGND VPWR VPWR net11 sky130_fd_sc_hd__clkbuf_1
Xinput33 WD3[27] VGND VGND VPWR VPWR net33 sky130_fd_sc_hd__buf_1
XFILLER_0_109_3 VPWR VGND VPWR VGND sky130_ef_sc_hd__decap_12
XFILLER_0_107_480 VGND VGND VPWR VPWR sky130_fd_sc_hd__fill_1
XTAP_TAPCELL_ROW_12_395 VGND VPWR sky130_fd_sc_hd__tapvpwrvgnd_1
Xinput44 WD3[8] VGND VGND VPWR VPWR net44 sky130_fd_sc_hd__buf_1
XTAP_TAPCELL_ROW_116_1648 VGND VPWR sky130_fd_sc_hd__tapvpwrvgnd_1
Xhold806 RF.reg_arr\[14\]\[31\] VGND VGND VPWR VPWR net888 sky130_fd_sc_hd__dlygate4sd3_1
Xhold828 RF.reg_arr\[21\]\[31\] VGND VGND VPWR VPWR net910 sky130_fd_sc_hd__dlygate4sd3_1
XFILLER_0_3_169 VGND VGND VPWR VPWR sky130_fd_sc_hd__decap_3
Xhold817 RF.reg_arr\[21\]\[15\] VGND VGND VPWR VPWR net899 sky130_fd_sc_hd__dlygate4sd3_1
XTAP_TAPCELL_ROW_116_1659 VGND VPWR sky130_fd_sc_hd__tapvpwrvgnd_1
X_6250_ net210 _2994_ _2998_ VGND VGND VPWR VPWR _2999_ sky130_fd_sc_hd__mux2_1
Xhold839 RF.reg_arr\[10\]\[19\] VGND VGND VPWR VPWR net921 sky130_fd_sc_hd__dlygate4sd3_1
XFILLER_0_110_667 VGND VGND VPWR VPWR sky130_fd_sc_hd__fill_2
X_6181_ _2916_ _2926_ _2939_ VGND VGND VPWR VPWR _2941_ sky130_fd_sc_hd__or3_1
XFILLER_0_58_65 VGND VGND VPWR VPWR sky130_fd_sc_hd__fill_1
X_5201_ _1942_ _1989_ VGND VGND VPWR VPWR _1990_ sky130_fd_sc_hd__or2_1
X_5132_ RF.reg_arr\[4\]\[21\] RF.reg_arr\[5\]\[21\] RF.reg_arr\[6\]\[21\] RF.reg_arr\[7\]\[21\]
+ _1625_ _1878_ VGND VGND VPWR VPWR _1921_ sky130_fd_sc_hd__mux4_1
X_5063_ RF.reg_arr\[8\]\[22\] RF.reg_arr\[9\]\[22\] RF.reg_arr\[10\]\[22\] RF.reg_arr\[11\]\[22\]
+ _1848_ _1851_ VGND VGND VPWR VPWR _1852_ sky130_fd_sc_hd__mux4_1
X_8822_ clknet_leaf_49_CLK _0055_ VGND VGND VPWR VPWR RF.reg_arr\[4\]\[24\] sky130_fd_sc_hd__dfxtp_1
X_5965_ _2717_ _2723_ _2724_ _2737_ _2568_ VGND VGND VPWR VPWR net56 sky130_fd_sc_hd__o32a_1
XFILLER_0_90_52 VGND VGND VPWR VPWR sky130_fd_sc_hd__decap_6
X_8753_ clknet_leaf_19_CLK _1010_ VGND VGND VPWR VPWR RF.reg_arr\[6\]\[19\] sky130_fd_sc_hd__dfxtp_1
X_4916_ RF.reg_arr\[16\]\[28\] RF.reg_arr\[17\]\[28\] RF.reg_arr\[18\]\[28\] RF.reg_arr\[19\]\[28\]
+ _1592_ _1599_ VGND VGND VPWR VPWR _1705_ sky130_fd_sc_hd__mux4_1
X_5896_ _2192_ _2668_ _2671_ VGND VGND VPWR VPWR _2672_ sky130_fd_sc_hd__and3_1
X_7704_ _3812_ VGND VGND VPWR VPWR _3813_ sky130_fd_sc_hd__clkbuf_8
X_8684_ clknet_leaf_94_CLK _0941_ VGND VGND VPWR VPWR RF.reg_arr\[15\]\[14\] sky130_fd_sc_hd__dfxtp_1
XFILLER_0_90_602 VGND VGND VPWR VPWR sky130_fd_sc_hd__fill_1
X_4847_ _1635_ VGND VGND VPWR VPWR _1636_ sky130_fd_sc_hd__buf_4
X_7635_ _2974_ _3267_ _3556_ VGND VGND VPWR VPWR _3776_ sky130_fd_sc_hd__nand3_4
XFILLER_0_62_337 VGND VGND VPWR VPWR sky130_fd_sc_hd__fill_2
X_4778_ _1565_ _1566_ _1308_ VGND VGND VPWR VPWR _1567_ sky130_fd_sc_hd__mux2_1
X_9305_ clknet_leaf_32_CLK _0538_ VGND VGND VPWR VPWR RF.reg_arr\[25\]\[27\] sky130_fd_sc_hd__dfxtp_1
X_7566_ _3739_ VGND VGND VPWR VPWR _0318_ sky130_fd_sc_hd__clkbuf_1
X_6517_ _3165_ VGND VGND VPWR VPWR _0867_ sky130_fd_sc_hd__clkbuf_1
X_7497_ net10 net9 VGND VGND VPWR VPWR _3702_ sky130_fd_sc_hd__nor2_2
X_9236_ clknet_leaf_62_CLK _0469_ VGND VGND VPWR VPWR RF.reg_arr\[22\]\[22\] sky130_fd_sc_hd__dfxtp_1
XFILLER_0_30_245 VGND VGND VPWR VPWR sky130_fd_sc_hd__fill_2
X_6448_ net124 VGND VGND VPWR VPWR _3129_ sky130_fd_sc_hd__clkbuf_1
X_9167_ clknet_leaf_1_CLK _0400_ VGND VGND VPWR VPWR RF.reg_arr\[9\]\[17\] sky130_fd_sc_hd__dfxtp_1
X_6379_ net17 VGND VGND VPWR VPWR _3084_ sky130_fd_sc_hd__clkbuf_2
XFILLER_0_101_689 VGND VGND VPWR VPWR sky130_fd_sc_hd__decap_3
X_8118_ net498 _3393_ _4030_ VGND VGND VPWR VPWR _4033_ sky130_fd_sc_hd__mux2_1
X_9098_ clknet_leaf_96_CLK _0331_ VGND VGND VPWR VPWR RF.reg_arr\[2\]\[12\] sky130_fd_sc_hd__dfxtp_1
X_8049_ _3996_ VGND VGND VPWR VPWR _0544_ sky130_fd_sc_hd__clkbuf_1
XTAP_TAPCELL_ROW_100_1449 VGND VPWR sky130_fd_sc_hd__tapvpwrvgnd_1
XFILLER_0_81_657 VGND VGND VPWR VPWR sky130_fd_sc_hd__decap_8
XFILLER_0_81_679 VGND VGND VPWR VPWR sky130_fd_sc_hd__fill_1
XFILLER_0_34_551 VGND VGND VPWR VPWR sky130_fd_sc_hd__fill_2
XFILLER_0_110_39 VGND VGND VPWR VPWR sky130_fd_sc_hd__decap_4
XFILLER_0_21_212 VGND VGND VPWR VPWR sky130_fd_sc_hd__fill_1
XFILLER_0_34_573 VGND VGND VPWR VPWR sky130_fd_sc_hd__fill_1
XFILLER_0_104_461 VGND VGND VPWR VPWR sky130_fd_sc_hd__decap_3
XFILLER_0_1_629 VPWR VGND VPWR VGND sky130_ef_sc_hd__decap_12
XFILLER_0_21_289 VGND VGND VPWR VPWR sky130_fd_sc_hd__fill_2
XTAP_TAPCELL_ROW_111_1578 VGND VPWR sky130_fd_sc_hd__tapvpwrvgnd_1
XTAP_TAPCELL_ROW_111_1589 VGND VPWR sky130_fd_sc_hd__tapvpwrvgnd_1
XTAP_TAPCELL_ROW_66_1046 VGND VPWR sky130_fd_sc_hd__tapvpwrvgnd_1
XTAP_TAPCELL_ROW_17_454 VGND VPWR sky130_fd_sc_hd__tapvpwrvgnd_1
XFILLER_0_44_89 VGND VGND VPWR VPWR sky130_fd_sc_hd__fill_2
X_5750_ _2049_ _2197_ _1699_ _2028_ VGND VGND VPWR VPWR _2533_ sky130_fd_sc_hd__or4_4
XFILLER_0_29_323 VGND VGND VPWR VPWR sky130_fd_sc_hd__fill_1
XTAP_TAPCELL_ROW_45_796 VGND VPWR sky130_fd_sc_hd__tapvpwrvgnd_1
X_5681_ _2358_ _2466_ _2366_ VGND VGND VPWR VPWR _2467_ sky130_fd_sc_hd__mux2_1
XFILLER_0_84_473 VGND VGND VPWR VPWR sky130_fd_sc_hd__decap_3
XFILLER_0_57_665 VGND VGND VPWR VPWR sky130_fd_sc_hd__decap_4
X_4701_ _1486_ _1489_ _1062_ VGND VGND VPWR VPWR _1490_ sky130_fd_sc_hd__mux2_1
XFILLER_0_29_389 VGND VGND VPWR VPWR sky130_fd_sc_hd__decap_3
X_7420_ _3117_ net999 _3652_ VGND VGND VPWR VPWR _3661_ sky130_fd_sc_hd__mux2_1
X_4632_ RF.reg_arr\[16\]\[27\] RF.reg_arr\[17\]\[27\] RF.reg_arr\[18\]\[27\] RF.reg_arr\[19\]\[27\]
+ _1175_ _1176_ VGND VGND VPWR VPWR _1421_ sky130_fd_sc_hd__mux4_1
X_7351_ _3624_ VGND VGND VPWR VPWR _0218_ sky130_fd_sc_hd__clkbuf_1
X_4563_ _1350_ _1351_ _1034_ VGND VGND VPWR VPWR _1352_ sky130_fd_sc_hd__mux2_1
XFILLER_0_80_690 VGND VGND VPWR VPWR sky130_fd_sc_hd__fill_2
Xhold603 RF.reg_arr\[3\]\[17\] VGND VGND VPWR VPWR net685 sky130_fd_sc_hd__dlygate4sd3_1
X_4494_ _1277_ _1278_ _1279_ _1280_ _1281_ _1282_ VGND VGND VPWR VPWR _1283_ sky130_fd_sc_hd__mux4_1
X_7282_ _3115_ net575 _3580_ VGND VGND VPWR VPWR _3588_ sky130_fd_sc_hd__mux2_1
Xhold614 RF.reg_arr\[27\]\[20\] VGND VGND VPWR VPWR net696 sky130_fd_sc_hd__dlygate4sd3_1
X_6302_ net442 _3033_ _3019_ VGND VGND VPWR VPWR _3034_ sky130_fd_sc_hd__mux2_1
Xhold625 RF.reg_arr\[5\]\[12\] VGND VGND VPWR VPWR net707 sky130_fd_sc_hd__dlygate4sd3_1
Xhold636 RF.reg_arr\[31\]\[3\] VGND VGND VPWR VPWR net718 sky130_fd_sc_hd__dlygate4sd3_1
X_6233_ net34 VGND VGND VPWR VPWR _2986_ sky130_fd_sc_hd__buf_2
Xhold647 RF.reg_arr\[14\]\[27\] VGND VGND VPWR VPWR net729 sky130_fd_sc_hd__dlygate4sd3_1
XFILLER_0_100_83 VGND VGND VPWR VPWR sky130_fd_sc_hd__fill_1
Xhold658 RF.reg_arr\[1\]\[30\] VGND VGND VPWR VPWR net740 sky130_fd_sc_hd__dlygate4sd3_1
XTAP_TAPCELL_ROW_77_1175 VGND VPWR sky130_fd_sc_hd__tapvpwrvgnd_1
X_9021_ clknet_leaf_21_CLK _0254_ VGND VGND VPWR VPWR RF.reg_arr\[27\]\[31\] sky130_fd_sc_hd__dfxtp_1
Xhold669 RF.reg_arr\[2\]\[10\] VGND VGND VPWR VPWR net751 sky130_fd_sc_hd__dlygate4sd3_1
XTAP_TAPCELL_ROW_90_1331 VGND VPWR sky130_fd_sc_hd__tapvpwrvgnd_1
XFILLER_0_0_673 VPWR VGND VPWR VGND sky130_ef_sc_hd__decap_12
X_6164_ _2918_ _2921_ _2924_ VGND VGND VPWR VPWR _2925_ sky130_fd_sc_hd__and3_1
XFILLER_0_85_41 VGND VGND VPWR VPWR sky130_fd_sc_hd__decap_6
X_6095_ _2759_ _2859_ VGND VGND VPWR VPWR _2860_ sky130_fd_sc_hd__nor2_1
X_5115_ RF.reg_arr\[12\]\[20\] RF.reg_arr\[13\]\[20\] RF.reg_arr\[14\]\[20\] RF.reg_arr\[15\]\[20\]
+ _1625_ _1598_ VGND VGND VPWR VPWR _1904_ sky130_fd_sc_hd__mux4_1
XFILLER_0_109_81 VGND VGND VPWR VPWR sky130_fd_sc_hd__decap_6
X_5046_ _1834_ VGND VGND VPWR VPWR _1835_ sky130_fd_sc_hd__clkbuf_4
XFILLER_0_79_234 VGND VGND VPWR VPWR sky130_fd_sc_hd__fill_1
XFILLER_0_79_223 VGND VGND VPWR VPWR sky130_fd_sc_hd__fill_1
XFILLER_0_79_212 VGND VGND VPWR VPWR sky130_fd_sc_hd__fill_2
X_6997_ net336 _3435_ _3431_ VGND VGND VPWR VPWR _3436_ sky130_fd_sc_hd__mux2_1
X_8805_ clknet_leaf_89_CLK _0038_ VGND VGND VPWR VPWR RF.reg_arr\[4\]\[7\] sky130_fd_sc_hd__dfxtp_1
XFILLER_0_39_109 VGND VGND VPWR VPWR sky130_fd_sc_hd__decap_3
X_5948_ _2686_ _2720_ _1738_ VGND VGND VPWR VPWR _2721_ sky130_fd_sc_hd__mux2_1
X_8736_ clknet_leaf_61_CLK _0993_ VGND VGND VPWR VPWR RF.reg_arr\[6\]\[2\] sky130_fd_sc_hd__dfxtp_1
XFILLER_0_48_643 VGND VGND VPWR VPWR sky130_fd_sc_hd__fill_1
XFILLER_0_48_654 VGND VGND VPWR VPWR sky130_fd_sc_hd__decap_4
XFILLER_0_75_473 VGND VGND VPWR VPWR sky130_fd_sc_hd__decap_4
XFILLER_0_63_613 VGND VGND VPWR VPWR sky130_fd_sc_hd__decap_3
X_8667_ clknet_leaf_27_CLK _0924_ VGND VGND VPWR VPWR RF.reg_arr\[8\]\[29\] sky130_fd_sc_hd__dfxtp_1
XFILLER_0_90_421 VGND VGND VPWR VPWR sky130_fd_sc_hd__fill_2
X_5879_ _2593_ _2655_ _1738_ VGND VGND VPWR VPWR _2656_ sky130_fd_sc_hd__mux2_1
X_8598_ clknet_leaf_54_CLK _0855_ VGND VGND VPWR VPWR RF.reg_arr\[0\]\[24\] sky130_fd_sc_hd__dfxtp_1
X_7618_ _3767_ VGND VGND VPWR VPWR _0342_ sky130_fd_sc_hd__clkbuf_1
XFILLER_0_63_668 VGND VGND VPWR VPWR sky130_fd_sc_hd__decap_4
X_7549_ net593 _3437_ _3727_ VGND VGND VPWR VPWR _3731_ sky130_fd_sc_hd__mux2_1
X_9219_ clknet_leaf_79_CLK _0452_ VGND VGND VPWR VPWR RF.reg_arr\[22\]\[5\] sky130_fd_sc_hd__dfxtp_1
XFILLER_0_31_598 VGND VGND VPWR VPWR sky130_fd_sc_hd__fill_1
XFILLER_0_101_486 VGND VGND VPWR VPWR sky130_fd_sc_hd__fill_1
XFILLER_0_105_39 VGND VGND VPWR VPWR sky130_fd_sc_hd__decap_6
XFILLER_0_105_28 VGND VGND VPWR VPWR sky130_fd_sc_hd__fill_2
XFILLER_0_98_587 VGND VGND VPWR VPWR sky130_fd_sc_hd__fill_1
XFILLER_0_14_15 VPWR VGND VPWR VGND sky130_ef_sc_hd__decap_12
XFILLER_0_66_473 VGND VGND VPWR VPWR sky130_fd_sc_hd__decap_3
XTAP_TAPCELL_ROW_14_424 VGND VPWR sky130_fd_sc_hd__tapvpwrvgnd_1
XTAP_TAPCELL_ROW_42_755 VGND VPWR sky130_fd_sc_hd__tapvpwrvgnd_1
XFILLER_0_30_14 VGND VGND VPWR VPWR sky130_fd_sc_hd__fill_2
XFILLER_0_30_25 VGND VGND VPWR VPWR sky130_fd_sc_hd__decap_3
XTAP_TAPCELL_ROW_113_1607 VGND VPWR sky130_fd_sc_hd__tapvpwrvgnd_1
XFILLER_0_55_66 VGND VGND VPWR VPWR sky130_fd_sc_hd__fill_2
XFILLER_0_89_554 VGND VGND VPWR VPWR sky130_fd_sc_hd__decap_6
XFILLER_0_89_543 VGND VGND VPWR VPWR sky130_fd_sc_hd__fill_1
X_6920_ net37 VGND VGND VPWR VPWR _3383_ sky130_fd_sc_hd__buf_2
XFILLER_0_71_10 VGND VGND VPWR VPWR sky130_fd_sc_hd__fill_1
X_6851_ _3343_ VGND VGND VPWR VPWR _3344_ sky130_fd_sc_hd__buf_4
X_5802_ _1092_ _2050_ VGND VGND VPWR VPWR _2583_ sky130_fd_sc_hd__or2_1
X_6782_ _3306_ VGND VGND VPWR VPWR _3307_ sky130_fd_sc_hd__buf_4
XFILLER_0_29_164 VGND VGND VPWR VPWR sky130_fd_sc_hd__fill_1
X_8521_ clknet_leaf_91_CLK _0778_ VGND VGND VPWR VPWR RF.reg_arr\[1\]\[11\] sky130_fd_sc_hd__dfxtp_1
X_5733_ _2234_ _2516_ VGND VGND VPWR VPWR _2517_ sky130_fd_sc_hd__xor2_1
XFILLER_0_17_337 VGND VGND VPWR VPWR sky130_fd_sc_hd__decap_4
XFILLER_0_115_501 VGND VGND VPWR VPWR sky130_fd_sc_hd__decap_3
XTAP_TAPCELL_ROW_79_1204 VGND VPWR sky130_fd_sc_hd__tapvpwrvgnd_1
X_5664_ _2330_ _2345_ VGND VGND VPWR VPWR _2451_ sky130_fd_sc_hd__or2_1
XFILLER_0_72_454 VGND VGND VPWR VPWR sky130_fd_sc_hd__decap_3
X_8452_ net178 net14 _2978_ VGND VGND VPWR VPWR _4209_ sky130_fd_sc_hd__mux2_1
X_8383_ _4172_ VGND VGND VPWR VPWR _0702_ sky130_fd_sc_hd__clkbuf_1
X_5595_ _1114_ _2045_ VGND VGND VPWR VPWR _2383_ sky130_fd_sc_hd__or2_1
X_7403_ _3629_ VGND VGND VPWR VPWR _3652_ sky130_fd_sc_hd__clkbuf_8
X_4615_ RF.reg_arr\[28\]\[7\] RF.reg_arr\[29\]\[7\] RF.reg_arr\[30\]\[7\] RF.reg_arr\[31\]\[7\]
+ _1186_ _1188_ VGND VGND VPWR VPWR _1404_ sky130_fd_sc_hd__mux4_1
XFILLER_0_32_307 VGND VGND VPWR VPWR sky130_fd_sc_hd__fill_1
Xhold411 RF.reg_arr\[25\]\[24\] VGND VGND VPWR VPWR net493 sky130_fd_sc_hd__dlygate4sd3_1
Xhold400 RF.reg_arr\[19\]\[1\] VGND VGND VPWR VPWR net482 sky130_fd_sc_hd__dlygate4sd3_1
X_4546_ RF.reg_arr\[16\]\[20\] RF.reg_arr\[17\]\[20\] RF.reg_arr\[18\]\[20\] RF.reg_arr\[19\]\[20\]
+ _1117_ _1118_ VGND VGND VPWR VPWR _1335_ sky130_fd_sc_hd__mux4_1
XFILLER_0_4_253 VGND VGND VPWR VPWR sky130_fd_sc_hd__decap_4
X_7334_ _3615_ VGND VGND VPWR VPWR _0210_ sky130_fd_sc_hd__clkbuf_1
Xhold444 RF.reg_arr\[21\]\[28\] VGND VGND VPWR VPWR net526 sky130_fd_sc_hd__dlygate4sd3_1
XFILLER_0_102_239 VGND VGND VPWR VPWR sky130_fd_sc_hd__decap_3
Xhold433 RF.reg_arr\[19\]\[20\] VGND VGND VPWR VPWR net515 sky130_fd_sc_hd__dlygate4sd3_1
Xhold422 RF.reg_arr\[26\]\[3\] VGND VGND VPWR VPWR net504 sky130_fd_sc_hd__dlygate4sd3_1
Xhold477 RF.reg_arr\[26\]\[26\] VGND VGND VPWR VPWR net559 sky130_fd_sc_hd__dlygate4sd3_1
Xhold466 RF.reg_arr\[23\]\[2\] VGND VGND VPWR VPWR net548 sky130_fd_sc_hd__dlygate4sd3_1
X_4477_ RF.reg_arr\[4\]\[11\] RF.reg_arr\[5\]\[11\] RF.reg_arr\[6\]\[11\] RF.reg_arr\[7\]\[11\]
+ _1262_ _1045_ VGND VGND VPWR VPWR _1266_ sky130_fd_sc_hd__mux4_1
X_7265_ _3098_ net702 _3569_ VGND VGND VPWR VPWR _3579_ sky130_fd_sc_hd__mux2_1
Xhold455 RF.reg_arr\[25\]\[11\] VGND VGND VPWR VPWR net537 sky130_fd_sc_hd__dlygate4sd3_1
Xhold499 RF.reg_arr\[6\]\[19\] VGND VGND VPWR VPWR net581 sky130_fd_sc_hd__dlygate4sd3_1
X_7196_ net903 _3428_ _3532_ VGND VGND VPWR VPWR _3542_ sky130_fd_sc_hd__mux2_1
X_6216_ net11 VGND VGND VPWR VPWR _2973_ sky130_fd_sc_hd__clkbuf_4
X_9004_ clknet_leaf_100_CLK _0237_ VGND VGND VPWR VPWR RF.reg_arr\[27\]\[14\] sky130_fd_sc_hd__dfxtp_1
Xhold488 RF.reg_arr\[18\]\[16\] VGND VGND VPWR VPWR net570 sky130_fd_sc_hd__dlygate4sd3_1
X_6147_ _2430_ _2840_ _2908_ _2421_ VGND VGND VPWR VPWR _2909_ sky130_fd_sc_hd__a22o_1
X_6078_ _2836_ _2837_ _2843_ VGND VGND VPWR VPWR net64 sky130_fd_sc_hd__o21a_1
XFILLER_0_99_329 VGND VGND VPWR VPWR sky130_fd_sc_hd__decap_6
X_5029_ RF.reg_arr\[24\]\[2\] RF.reg_arr\[25\]\[2\] RF.reg_arr\[26\]\[2\] RF.reg_arr\[27\]\[2\]
+ _1262_ _1045_ VGND VGND VPWR VPWR _1818_ sky130_fd_sc_hd__mux4_1
XFILLER_0_95_557 VGND VGND VPWR VPWR sky130_fd_sc_hd__decap_3
XFILLER_0_75_281 VPWR VGND VPWR VGND sky130_ef_sc_hd__decap_12
X_8719_ clknet_leaf_106_CLK _0976_ VGND VGND VPWR VPWR RF.reg_arr\[14\]\[17\] sky130_fd_sc_hd__dfxtp_1
XFILLER_0_63_443 VGND VGND VPWR VPWR sky130_fd_sc_hd__decap_4
XFILLER_0_106_589 VGND VGND VPWR VPWR sky130_fd_sc_hd__decap_3
XFILLER_0_44_690 VGND VGND VPWR VPWR sky130_fd_sc_hd__fill_2
XTAP_TAPCELL_ROW_47_814 VGND VPWR sky130_fd_sc_hd__tapvpwrvgnd_1
XFILLER_0_116_27 VGND VGND VPWR VPWR sky130_fd_sc_hd__fill_1
XTAP_TAPCELL_ROW_63_1005 VGND VPWR sky130_fd_sc_hd__tapvpwrvgnd_1
XTAP_TAPCELL_ROW_27_571 VGND VPWR sky130_fd_sc_hd__tapvpwrvgnd_1
XFILLER_0_27_602 VGND VGND VPWR VPWR sky130_fd_sc_hd__decap_4
XFILLER_0_41_57 VGND VGND VPWR VPWR sky130_fd_sc_hd__fill_1
XFILLER_0_54_421 VGND VGND VPWR VPWR sky130_fd_sc_hd__decap_3
X_4400_ _1188_ VGND VGND VPWR VPWR _1189_ sky130_fd_sc_hd__clkbuf_4
XFILLER_0_35_690 VGND VGND VPWR VPWR sky130_fd_sc_hd__fill_2
X_5380_ _2167_ _2168_ _1603_ VGND VGND VPWR VPWR _2169_ sky130_fd_sc_hd__mux2_1
XFILLER_0_22_362 VGND VGND VPWR VPWR sky130_fd_sc_hd__fill_2
XTAP_TAPCELL_ROW_74_1145 VGND VPWR sky130_fd_sc_hd__tapvpwrvgnd_1
XTAP_TAPCELL_ROW_74_1134 VGND VPWR sky130_fd_sc_hd__tapvpwrvgnd_1
X_4331_ RF.reg_arr\[16\]\[16\] RF.reg_arr\[17\]\[16\] RF.reg_arr\[18\]\[16\] RF.reg_arr\[19\]\[16\]
+ _1117_ _1118_ VGND VGND VPWR VPWR _1120_ sky130_fd_sc_hd__mux4_1
XFILLER_0_22_373 VGND VGND VPWR VPWR sky130_fd_sc_hd__fill_2
X_7050_ net331 _3418_ _3460_ VGND VGND VPWR VPWR _3465_ sky130_fd_sc_hd__mux2_1
XFILLER_0_1_278 VGND VGND VPWR VPWR sky130_fd_sc_hd__fill_2
X_4262_ _1050_ VGND VGND VPWR VPWR _1051_ sky130_fd_sc_hd__buf_6
X_6001_ _1162_ _1205_ _1550_ net1123 _1185_ VGND VGND VPWR VPWR _2771_ sky130_fd_sc_hd__a41o_1
X_7952_ _3039_ net1069 _3944_ VGND VGND VPWR VPWR _3945_ sky130_fd_sc_hd__mux2_1
X_6903_ net183 _3371_ _3366_ VGND VGND VPWR VPWR _3372_ sky130_fd_sc_hd__mux2_1
XFILLER_0_89_351 VGND VGND VPWR VPWR sky130_fd_sc_hd__fill_1
XTAP_TAPCELL_ROW_85_1274 VGND VPWR sky130_fd_sc_hd__tapvpwrvgnd_1
X_7883_ _3885_ VGND VGND VPWR VPWR _3908_ sky130_fd_sc_hd__clkbuf_8
X_6834_ _3334_ VGND VGND VPWR VPWR _1015_ sky130_fd_sc_hd__clkbuf_1
X_6765_ _3297_ VGND VGND VPWR VPWR _0983_ sky130_fd_sc_hd__clkbuf_1
XFILLER_0_57_281 VGND VGND VPWR VPWR sky130_fd_sc_hd__fill_2
X_8504_ clknet_leaf_36_CLK _0761_ VGND VGND VPWR VPWR RF.reg_arr\[10\]\[26\] sky130_fd_sc_hd__dfxtp_1
X_5716_ _2499_ _2500_ VGND VGND VPWR VPWR _2501_ sky130_fd_sc_hd__or2b_1
XFILLER_0_18_679 VGND VGND VPWR VPWR sky130_fd_sc_hd__fill_1
X_9484_ clknet_leaf_102_CLK _0717_ VGND VGND VPWR VPWR RF.reg_arr\[11\]\[14\] sky130_fd_sc_hd__dfxtp_1
X_6696_ _3111_ net727 _3254_ VGND VGND VPWR VPWR _3260_ sky130_fd_sc_hd__mux2_1
X_8435_ _4200_ VGND VGND VPWR VPWR _0726_ sky130_fd_sc_hd__clkbuf_1
XFILLER_0_17_167 VGND VGND VPWR VPWR sky130_fd_sc_hd__fill_1
XFILLER_0_33_638 VGND VGND VPWR VPWR sky130_fd_sc_hd__fill_1
X_5647_ _1737_ VGND VGND VPWR VPWR _2434_ sky130_fd_sc_hd__clkbuf_4
X_5578_ _1737_ VGND VGND VPWR VPWR _2366_ sky130_fd_sc_hd__clkbuf_4
X_8366_ _3046_ net956 _4160_ VGND VGND VPWR VPWR _4164_ sky130_fd_sc_hd__mux2_1
Xhold230 RF.reg_arr\[7\]\[28\] VGND VGND VPWR VPWR net312 sky130_fd_sc_hd__dlygate4sd3_1
X_4529_ RF.reg_arr\[16\]\[23\] RF.reg_arr\[17\]\[23\] RF.reg_arr\[18\]\[23\] RF.reg_arr\[19\]\[23\]
+ _1316_ _1304_ VGND VGND VPWR VPWR _1318_ sky130_fd_sc_hd__mux4_1
X_8297_ _4127_ VGND VGND VPWR VPWR _0661_ sky130_fd_sc_hd__clkbuf_1
Xhold241 RF.reg_arr\[4\]\[15\] VGND VGND VPWR VPWR net323 sky130_fd_sc_hd__dlygate4sd3_1
Xhold252 RF.reg_arr\[10\]\[10\] VGND VGND VPWR VPWR net334 sky130_fd_sc_hd__dlygate4sd3_1
X_7317_ _3082_ net491 _3605_ VGND VGND VPWR VPWR _3607_ sky130_fd_sc_hd__mux2_1
Xhold285 RF.reg_arr\[5\]\[27\] VGND VGND VPWR VPWR net367 sky130_fd_sc_hd__dlygate4sd3_1
Xhold263 RF.reg_arr\[6\]\[2\] VGND VGND VPWR VPWR net345 sky130_fd_sc_hd__dlygate4sd3_1
Xhold296 RF.reg_arr\[9\]\[16\] VGND VGND VPWR VPWR net378 sky130_fd_sc_hd__dlygate4sd3_1
Xhold274 RF.reg_arr\[2\]\[9\] VGND VGND VPWR VPWR net356 sky130_fd_sc_hd__dlygate4sd3_1
X_7248_ _3570_ VGND VGND VPWR VPWR _0169_ sky130_fd_sc_hd__clkbuf_1
X_7179_ _3533_ VGND VGND VPWR VPWR _0137_ sky130_fd_sc_hd__clkbuf_1
XFILLER_0_83_516 VGND VGND VPWR VPWR sky130_fd_sc_hd__decap_4
XFILLER_0_83_505 VGND VGND VPWR VPWR sky130_fd_sc_hd__decap_3
XTAP_TAPCELL_ROW_24_541 VGND VPWR sky130_fd_sc_hd__tapvpwrvgnd_1
XFILLER_0_36_421 VGND VGND VPWR VPWR sky130_fd_sc_hd__decap_3
XTAP_TAPCELL_ROW_52_872 VGND VPWR sky130_fd_sc_hd__tapvpwrvgnd_1
XFILLER_0_102_29 VGND VGND VPWR VPWR sky130_fd_sc_hd__fill_2
XFILLER_0_11_27 VGND VGND VPWR VPWR sky130_fd_sc_hd__fill_2
XFILLER_0_17_690 VGND VGND VPWR VPWR sky130_fd_sc_hd__fill_2
XFILLER_0_32_682 VGND VGND VPWR VPWR sky130_fd_sc_hd__fill_2
Xinput9 A3[0] VGND VGND VPWR VPWR net9 sky130_fd_sc_hd__buf_2
XFILLER_0_59_557 VGND VGND VPWR VPWR sky130_fd_sc_hd__decap_3
X_4880_ _1599_ VGND VGND VPWR VPWR _1669_ sky130_fd_sc_hd__clkbuf_4
XFILLER_0_74_505 VGND VGND VPWR VPWR sky130_fd_sc_hd__fill_2
XFILLER_0_52_89 VGND VGND VPWR VPWR sky130_fd_sc_hd__fill_2
X_6550_ net894 _3039_ _3182_ VGND VGND VPWR VPWR _3183_ sky130_fd_sc_hd__mux2_1
XFILLER_0_39_281 VGND VGND VPWR VPWR sky130_fd_sc_hd__decap_3
X_5501_ _2288_ _2289_ _1610_ VGND VGND VPWR VPWR _2290_ sky130_fd_sc_hd__mux2_1
X_6481_ _3145_ VGND VGND VPWR VPWR _0851_ sky130_fd_sc_hd__clkbuf_1
X_5432_ _2219_ _2220_ _1610_ VGND VGND VPWR VPWR _2221_ sky130_fd_sc_hd__mux2_1
X_8220_ _4086_ VGND VGND VPWR VPWR _0625_ sky130_fd_sc_hd__clkbuf_1
XFILLER_0_42_468 VGND VGND VPWR VPWR sky130_fd_sc_hd__fill_1
XFILLER_0_100_507 VGND VGND VPWR VPWR sky130_fd_sc_hd__fill_1
XFILLER_0_23_671 VGND VGND VPWR VPWR sky130_fd_sc_hd__fill_1
X_8151_ net534 _3426_ _4041_ VGND VGND VPWR VPWR _4050_ sky130_fd_sc_hd__mux2_1
X_5363_ _1604_ _2151_ _1617_ VGND VGND VPWR VPWR _2152_ sky130_fd_sc_hd__o21a_1
XFILLER_0_100_518 VPWR VGND VPWR VGND sky130_ef_sc_hd__decap_12
XFILLER_0_2_587 VGND VGND VPWR VPWR sky130_fd_sc_hd__fill_1
X_7102_ _3492_ VGND VGND VPWR VPWR _0101_ sky130_fd_sc_hd__clkbuf_1
X_4314_ RF.reg_arr\[8\]\[0\] RF.reg_arr\[9\]\[0\] RF.reg_arr\[10\]\[0\] RF.reg_arr\[11\]\[0\]
+ _1027_ _1069_ VGND VGND VPWR VPWR _1103_ sky130_fd_sc_hd__mux4_1
XFILLER_0_77_86 VGND VGND VPWR VPWR sky130_fd_sc_hd__fill_2
XFILLER_0_10_365 VGND VGND VPWR VPWR sky130_fd_sc_hd__decap_3
X_8082_ _4013_ VGND VGND VPWR VPWR _0560_ sky130_fd_sc_hd__clkbuf_1
X_5294_ _1643_ _2074_ _2078_ _2082_ VGND VGND VPWR VPWR _2083_ sky130_fd_sc_hd__a2bb2o_2
X_4245_ _1033_ VGND VGND VPWR VPWR _1034_ sky130_fd_sc_hd__clkbuf_8
X_7033_ net489 _3401_ _3449_ VGND VGND VPWR VPWR _3456_ sky130_fd_sc_hd__mux2_1
X_8984_ clknet_leaf_34_CLK _0217_ VGND VGND VPWR VPWR RF.reg_arr\[31\]\[26\] sky130_fd_sc_hd__dfxtp_1
XFILLER_0_89_181 VGND VGND VPWR VPWR sky130_fd_sc_hd__fill_1
X_7935_ _3023_ net920 _3933_ VGND VGND VPWR VPWR _3936_ sky130_fd_sc_hd__mux2_1
X_7866_ _3899_ VGND VGND VPWR VPWR _0458_ sky130_fd_sc_hd__clkbuf_1
XFILLER_0_37_218 VGND VGND VPWR VPWR sky130_fd_sc_hd__decap_6
X_6817_ _3325_ VGND VGND VPWR VPWR _1007_ sky130_fd_sc_hd__clkbuf_1
XFILLER_0_107_106 VGND VGND VPWR VPWR sky130_fd_sc_hd__decap_6
XTAP_TAPCELL_ROW_21_500 VGND VPWR sky130_fd_sc_hd__tapvpwrvgnd_1
X_7797_ _3862_ VGND VGND VPWR VPWR _0426_ sky130_fd_sc_hd__clkbuf_1
XFILLER_0_80_519 VGND VGND VPWR VPWR sky130_fd_sc_hd__decap_8
XFILLER_0_9_197 VGND VGND VPWR VPWR sky130_fd_sc_hd__fill_1
X_6748_ _3288_ VGND VGND VPWR VPWR _0975_ sky130_fd_sc_hd__clkbuf_1
XFILLER_0_116_673 VPWR VGND VPWR VGND sky130_ef_sc_hd__decap_12
XTAP_TAPCELL_ROW_98_1432 VGND VPWR sky130_fd_sc_hd__tapvpwrvgnd_1
X_9467_ clknet_leaf_26_CLK _0700_ VGND VGND VPWR VPWR RF.reg_arr\[12\]\[29\] sky130_fd_sc_hd__dfxtp_1
X_6679_ _3094_ net1087 _3243_ VGND VGND VPWR VPWR _3251_ sky130_fd_sc_hd__mux2_1
X_9398_ clknet_leaf_51_CLK _0631_ VGND VGND VPWR VPWR RF.reg_arr\[13\]\[24\] sky130_fd_sc_hd__dfxtp_1
XFILLER_0_103_323 VGND VGND VPWR VPWR sky130_fd_sc_hd__decap_4
X_8418_ _4191_ VGND VGND VPWR VPWR _0718_ sky130_fd_sc_hd__clkbuf_1
X_8349_ _3029_ net866 _4149_ VGND VGND VPWR VPWR _4155_ sky130_fd_sc_hd__mux2_1
XTAP_TAPCELL_ROW_29_600 VGND VPWR sky130_fd_sc_hd__tapvpwrvgnd_1
XTAP_TAPCELL_ROW_57_931 VGND VPWR sky130_fd_sc_hd__tapvpwrvgnd_1
XFILLER_0_96_641 VGND VGND VPWR VPWR sky130_fd_sc_hd__decap_3
XFILLER_0_68_365 VPWR VGND VPWR VGND sky130_ef_sc_hd__decap_12
XFILLER_0_68_354 VGND VGND VPWR VPWR sky130_fd_sc_hd__fill_1
XFILLER_0_96_685 VGND VGND VPWR VPWR sky130_fd_sc_hd__fill_1
XFILLER_0_113_39 VGND VGND VPWR VPWR sky130_fd_sc_hd__decap_6
XFILLER_0_12_608 VPWR VGND VPWR VGND sky130_ef_sc_hd__decap_12
XFILLER_0_106_194 VGND VGND VPWR VPWR sky130_fd_sc_hd__fill_2
XTAP_TAPCELL_ROW_71_1104 VGND VPWR sky130_fd_sc_hd__tapvpwrvgnd_1
XFILLER_0_47_34 VGND VGND VPWR VPWR sky130_fd_sc_hd__fill_1
XPHY_EDGE_ROW_10_Right_10 VGND VGND VPWR VPWR sky130_fd_sc_hd__decap_3
X_5981_ _2418_ _2440_ VGND VGND VPWR VPWR _2752_ sky130_fd_sc_hd__nor2_1
XTAP_TAPCELL_ROW_69_1077 VGND VPWR sky130_fd_sc_hd__tapvpwrvgnd_1
X_4932_ RF.reg_arr\[16\]\[1\] RF.reg_arr\[17\]\[1\] RF.reg_arr\[18\]\[1\] RF.reg_arr\[19\]\[1\]
+ _1262_ _1045_ VGND VGND VPWR VPWR _1721_ sky130_fd_sc_hd__mux4_1
X_7720_ _3821_ VGND VGND VPWR VPWR _0390_ sky130_fd_sc_hd__clkbuf_1
XTAP_TAPCELL_ROW_82_1233 VGND VPWR sky130_fd_sc_hd__tapvpwrvgnd_1
X_7651_ _3073_ net816 _3777_ VGND VGND VPWR VPWR _3785_ sky130_fd_sc_hd__mux2_1
XTAP_TAPCELL_ROW_35_669 VGND VPWR sky130_fd_sc_hd__tapvpwrvgnd_1
XFILLER_0_47_538 VGND VGND VPWR VPWR sky130_fd_sc_hd__decap_4
XANTENNA_14 _1808_ VGND VGND VPWR VPWR sky130_fd_sc_hd__diode_2
X_4863_ RF.reg_arr\[28\]\[30\] RF.reg_arr\[29\]\[30\] RF.reg_arr\[30\]\[30\] RF.reg_arr\[31\]\[30\]
+ _1593_ _1600_ VGND VGND VPWR VPWR _1652_ sky130_fd_sc_hd__mux4_1
X_6602_ _3210_ VGND VGND VPWR VPWR _0907_ sky130_fd_sc_hd__clkbuf_1
X_4794_ _1206_ _1271_ _1449_ _1582_ VGND VGND VPWR VPWR _1583_ sky130_fd_sc_hd__or4_4
XFILLER_0_6_112 VGND VGND VPWR VPWR sky130_fd_sc_hd__decap_3
X_7582_ _3748_ VGND VGND VPWR VPWR _0325_ sky130_fd_sc_hd__clkbuf_1
XFILLER_0_55_571 VGND VGND VPWR VPWR sky130_fd_sc_hd__fill_1
XANTENNA_25 A3[2] VGND VGND VPWR VPWR sky130_fd_sc_hd__diode_2
XFILLER_0_70_530 VGND VGND VPWR VPWR sky130_fd_sc_hd__fill_2
X_6533_ net377 _3023_ _3171_ VGND VGND VPWR VPWR _3174_ sky130_fd_sc_hd__mux2_1
XFILLER_0_27_284 VGND VGND VPWR VPWR sky130_fd_sc_hd__fill_2
X_9321_ clknet_leaf_13_CLK _0554_ VGND VGND VPWR VPWR RF.reg_arr\[20\]\[11\] sky130_fd_sc_hd__dfxtp_1
XFILLER_0_55_593 VGND VGND VPWR VPWR sky130_fd_sc_hd__fill_1
X_9252_ clknet_leaf_83_CLK _0485_ VGND VGND VPWR VPWR RF.reg_arr\[21\]\[6\] sky130_fd_sc_hd__dfxtp_1
XFILLER_0_15_457 VGND VGND VPWR VPWR sky130_fd_sc_hd__fill_1
X_6464_ net107 VGND VGND VPWR VPWR _3137_ sky130_fd_sc_hd__clkbuf_1
XFILLER_0_88_52 VGND VGND VPWR VPWR sky130_fd_sc_hd__decap_8
X_5415_ RF.reg_arr\[28\]\[4\] RF.reg_arr\[29\]\[4\] RF.reg_arr\[30\]\[4\] RF.reg_arr\[31\]\[4\]
+ _2030_ _1858_ VGND VGND VPWR VPWR _2204_ sky130_fd_sc_hd__mux4_1
XFILLER_0_30_427 VGND VGND VPWR VPWR sky130_fd_sc_hd__fill_1
X_8203_ _3018_ net208 _4077_ VGND VGND VPWR VPWR _4078_ sky130_fd_sc_hd__mux2_1
XFILLER_0_100_304 VGND VGND VPWR VPWR sky130_fd_sc_hd__decap_4
X_9183_ clknet_leaf_56_CLK _0416_ VGND VGND VPWR VPWR RF.reg_arr\[24\]\[1\] sky130_fd_sc_hd__dfxtp_1
X_6395_ _3094_ net1116 _3080_ VGND VGND VPWR VPWR _3095_ sky130_fd_sc_hd__mux2_1
XFILLER_0_112_197 VGND VGND VPWR VPWR sky130_fd_sc_hd__decap_8
XFILLER_0_100_359 VGND VGND VPWR VPWR sky130_fd_sc_hd__fill_1
XTAP_TAPCELL_ROW_93_1373 VGND VPWR sky130_fd_sc_hd__tapvpwrvgnd_1
XTAP_TAPCELL_ROW_93_1362 VGND VPWR sky130_fd_sc_hd__tapvpwrvgnd_1
X_8134_ _4029_ VGND VGND VPWR VPWR _4041_ sky130_fd_sc_hd__clkbuf_8
XFILLER_0_10_162 VGND VGND VPWR VPWR sky130_fd_sc_hd__decap_8
XTAP_TAPCELL_ROW_7_339 VGND VPWR sky130_fd_sc_hd__tapvpwrvgnd_1
X_5346_ _1942_ _2134_ _1844_ VGND VGND VPWR VPWR _2135_ sky130_fd_sc_hd__o21a_1
X_8065_ _4004_ VGND VGND VPWR VPWR _0552_ sky130_fd_sc_hd__clkbuf_1
X_5277_ _1618_ _2065_ _1586_ VGND VGND VPWR VPWR _2066_ sky130_fd_sc_hd__a21oi_1
X_7016_ net212 _3385_ _3388_ VGND VGND VPWR VPWR _3446_ sky130_fd_sc_hd__mux2_1
XPHY_EDGE_ROW_106_Right_106 VGND VGND VPWR VPWR sky130_fd_sc_hd__decap_3
XFILLER_0_97_449 VPWR VGND VPWR VGND sky130_ef_sc_hd__decap_12
X_8967_ clknet_leaf_78_CLK _0200_ VGND VGND VPWR VPWR RF.reg_arr\[31\]\[9\] sky130_fd_sc_hd__dfxtp_1
XTAP_TAPCELL_ROW_54_901 VGND VPWR sky130_fd_sc_hd__tapvpwrvgnd_1
XFILLER_0_77_140 VGND VGND VPWR VPWR sky130_fd_sc_hd__fill_1
X_7918_ _3006_ net628 _3922_ VGND VGND VPWR VPWR _3927_ sky130_fd_sc_hd__mux2_1
XFILLER_0_38_516 VGND VGND VPWR VPWR sky130_fd_sc_hd__decap_3
XFILLER_0_38_538 VGND VGND VPWR VPWR sky130_fd_sc_hd__fill_2
X_8898_ clknet_leaf_66_CLK _0131_ VGND VGND VPWR VPWR RF.reg_arr\[7\]\[4\] sky130_fd_sc_hd__dfxtp_1
XFILLER_0_108_415 VGND VGND VPWR VPWR sky130_fd_sc_hd__decap_4
XFILLER_0_65_335 VGND VGND VPWR VPWR sky130_fd_sc_hd__fill_1
X_7849_ _3890_ VGND VGND VPWR VPWR _0450_ sky130_fd_sc_hd__clkbuf_1
XTAP_TAPCELL_ROW_102_1480 VGND VPWR sky130_fd_sc_hd__tapvpwrvgnd_1
XFILLER_0_65_379 VGND VGND VPWR VPWR sky130_fd_sc_hd__fill_1
XFILLER_0_73_390 VGND VGND VPWR VPWR sky130_fd_sc_hd__fill_2
X_9519_ clknet_leaf_1_CLK _0752_ VGND VGND VPWR VPWR RF.reg_arr\[10\]\[17\] sky130_fd_sc_hd__dfxtp_1
XFILLER_0_6_690 VGND VGND VPWR VPWR sky130_fd_sc_hd__fill_2
XFILLER_0_104_654 VGND VGND VPWR VPWR sky130_fd_sc_hd__fill_2
XFILLER_0_21_449 VGND VGND VPWR VPWR sky130_fd_sc_hd__decap_4
XTAP_TAPCELL_ROW_105_1509 VGND VPWR sky130_fd_sc_hd__tapvpwrvgnd_1
XFILLER_0_69_630 VGND VGND VPWR VPWR sky130_fd_sc_hd__fill_1
XFILLER_0_84_600 VGND VGND VPWR VPWR sky130_fd_sc_hd__fill_1
XFILLER_0_83_132 VGND VGND VPWR VPWR sky130_fd_sc_hd__fill_2
XTAP_TAPCELL_ROW_32_639 VGND VPWR sky130_fd_sc_hd__tapvpwrvgnd_1
XFILLER_0_84_677 VGND VGND VPWR VPWR sky130_fd_sc_hd__decap_4
XFILLER_0_71_305 VGND VGND VPWR VPWR sky130_fd_sc_hd__fill_1
XFILLER_0_114_418 VGND VGND VPWR VPWR sky130_fd_sc_hd__fill_2
Xinput12 A3[3] VGND VGND VPWR VPWR net12 sky130_fd_sc_hd__buf_1
Xinput34 WD3[28] VGND VGND VPWR VPWR net34 sky130_fd_sc_hd__buf_1
XTAP_TAPCELL_ROW_12_396 VGND VPWR sky130_fd_sc_hd__tapvpwrvgnd_1
XFILLER_0_4_638 VGND VGND VPWR VPWR sky130_fd_sc_hd__decap_6
Xinput23 WD3[18] VGND VGND VPWR VPWR net23 sky130_fd_sc_hd__buf_1
Xinput45 WD3[9] VGND VGND VPWR VPWR net45 sky130_fd_sc_hd__clkbuf_2
XTAP_TAPCELL_ROW_116_1649 VGND VPWR sky130_fd_sc_hd__tapvpwrvgnd_1
XTAP_TAPCELL_ROW_116_1638 VGND VPWR sky130_fd_sc_hd__tapvpwrvgnd_1
Xhold818 RF.reg_arr\[22\]\[25\] VGND VGND VPWR VPWR net900 sky130_fd_sc_hd__dlygate4sd3_1
Xhold807 RF.reg_arr\[31\]\[17\] VGND VGND VPWR VPWR net889 sky130_fd_sc_hd__dlygate4sd3_1
XFILLER_0_3_148 VGND VGND VPWR VPWR sky130_fd_sc_hd__decap_4
Xhold829 RF.reg_arr\[21\]\[26\] VGND VGND VPWR VPWR net911 sky130_fd_sc_hd__dlygate4sd3_1
XFILLER_0_110_657 VGND VGND VPWR VPWR sky130_fd_sc_hd__fill_2
X_6180_ _2916_ _2926_ _2939_ VGND VGND VPWR VPWR _2940_ sky130_fd_sc_hd__o21ai_1
X_5200_ RF.reg_arr\[4\]\[17\] RF.reg_arr\[5\]\[17\] RF.reg_arr\[6\]\[17\] RF.reg_arr\[7\]\[17\]
+ _1624_ _1597_ VGND VGND VPWR VPWR _1989_ sky130_fd_sc_hd__mux4_1
X_5131_ _1918_ _1919_ _1612_ VGND VGND VPWR VPWR _1920_ sky130_fd_sc_hd__mux2_1
XFILLER_0_20_493 VGND VGND VPWR VPWR sky130_fd_sc_hd__fill_1
X_5062_ _1850_ VGND VGND VPWR VPWR _1851_ sky130_fd_sc_hd__buf_4
XFILLER_0_74_32 VGND VGND VPWR VPWR sky130_fd_sc_hd__decap_4
X_8821_ clknet_leaf_42_CLK _0054_ VGND VGND VPWR VPWR RF.reg_arr\[4\]\[23\] sky130_fd_sc_hd__dfxtp_1
XFILLER_0_79_438 VGND VGND VPWR VPWR sky130_fd_sc_hd__fill_1
X_8752_ clknet_leaf_3_CLK _1009_ VGND VGND VPWR VPWR RF.reg_arr\[6\]\[18\] sky130_fd_sc_hd__dfxtp_1
X_5964_ _2727_ _2736_ VGND VGND VPWR VPWR _2737_ sky130_fd_sc_hd__xnor2_1
X_7703_ _2976_ _3342_ VGND VGND VPWR VPWR _3812_ sky130_fd_sc_hd__nor2_2
X_4915_ RF.reg_arr\[20\]\[28\] RF.reg_arr\[21\]\[28\] RF.reg_arr\[22\]\[28\] RF.reg_arr\[23\]\[28\]
+ _1592_ _1599_ VGND VGND VPWR VPWR _1704_ sky130_fd_sc_hd__mux4_1
X_5895_ _2669_ _2670_ _2643_ _1499_ _2447_ VGND VGND VPWR VPWR _2671_ sky130_fd_sc_hd__a221o_1
XFILLER_0_59_195 VGND VGND VPWR VPWR sky130_fd_sc_hd__fill_2
X_8683_ clknet_leaf_92_CLK _0940_ VGND VGND VPWR VPWR RF.reg_arr\[15\]\[13\] sky130_fd_sc_hd__dfxtp_1
XFILLER_0_47_335 VGND VGND VPWR VPWR sky130_fd_sc_hd__fill_1
XFILLER_0_114_82 VGND VGND VPWR VPWR sky130_fd_sc_hd__fill_2
X_7634_ _3775_ VGND VGND VPWR VPWR _0350_ sky130_fd_sc_hd__clkbuf_1
XFILLER_0_62_305 VGND VGND VPWR VPWR sky130_fd_sc_hd__decap_3
X_4846_ _1634_ VGND VGND VPWR VPWR _1635_ sky130_fd_sc_hd__clkbuf_8
XFILLER_0_7_421 VGND VGND VPWR VPWR sky130_fd_sc_hd__decap_3
XFILLER_0_74_187 VGND VGND VPWR VPWR sky130_fd_sc_hd__fill_1
X_7565_ net1106 _3385_ _3704_ VGND VGND VPWR VPWR _3739_ sky130_fd_sc_hd__mux2_1
X_9304_ clknet_leaf_35_CLK _0537_ VGND VGND VPWR VPWR RF.reg_arr\[25\]\[26\] sky130_fd_sc_hd__dfxtp_1
X_4777_ RF.reg_arr\[28\]\[24\] RF.reg_arr\[29\]\[24\] RF.reg_arr\[30\]\[24\] RF.reg_arr\[31\]\[24\]
+ _1302_ _1322_ VGND VGND VPWR VPWR _1566_ sky130_fd_sc_hd__mux4_1
X_6516_ net934 _3006_ _3160_ VGND VGND VPWR VPWR _3165_ sky130_fd_sc_hd__mux2_1
X_7496_ _3701_ VGND VGND VPWR VPWR _0286_ sky130_fd_sc_hd__clkbuf_1
X_9235_ clknet_leaf_48_CLK _0468_ VGND VGND VPWR VPWR RF.reg_arr\[22\]\[21\] sky130_fd_sc_hd__dfxtp_1
X_6447_ _3128_ VGND VGND VPWR VPWR _0834_ sky130_fd_sc_hd__clkbuf_1
XFILLER_0_3_671 VGND VGND VPWR VPWR sky130_fd_sc_hd__fill_1
XFILLER_0_100_123 VGND VGND VPWR VPWR sky130_fd_sc_hd__decap_8
XFILLER_0_2_170 VGND VGND VPWR VPWR sky130_fd_sc_hd__decap_4
XFILLER_0_30_279 VGND VGND VPWR VPWR sky130_fd_sc_hd__fill_1
X_9166_ clknet_leaf_9_CLK _0399_ VGND VGND VPWR VPWR RF.reg_arr\[9\]\[16\] sky130_fd_sc_hd__dfxtp_1
X_6378_ _3083_ VGND VGND VPWR VPWR _0810_ sky130_fd_sc_hd__clkbuf_1
X_8117_ _4032_ VGND VGND VPWR VPWR _0576_ sky130_fd_sc_hd__clkbuf_1
X_5329_ _2116_ _2117_ _1611_ VGND VGND VPWR VPWR _2118_ sky130_fd_sc_hd__mux2_1
X_9097_ clknet_leaf_13_CLK _0330_ VGND VGND VPWR VPWR RF.reg_arr\[2\]\[11\] sky130_fd_sc_hd__dfxtp_1
X_8048_ _3000_ net1041 _3994_ VGND VGND VPWR VPWR _3996_ sky130_fd_sc_hd__mux2_1
XFILLER_0_97_246 VGND VGND VPWR VPWR sky130_fd_sc_hd__decap_4
XFILLER_0_65_110 VGND VGND VPWR VPWR sky130_fd_sc_hd__fill_2
XFILLER_0_81_647 VGND VGND VPWR VPWR sky130_fd_sc_hd__decap_3
XFILLER_0_108_289 VGND VGND VPWR VPWR sky130_fd_sc_hd__decap_8
XFILLER_0_80_157 VGND VGND VPWR VPWR sky130_fd_sc_hd__decap_3
XFILLER_0_110_29 VGND VGND VPWR VPWR sky130_fd_sc_hd__decap_6
XFILLER_0_104_495 VPWR VGND VPWR VGND sky130_ef_sc_hd__decap_12
XTAP_TAPCELL_ROW_111_1579 VGND VPWR sky130_fd_sc_hd__tapvpwrvgnd_1
XFILLER_0_76_419 VGND VGND VPWR VPWR sky130_fd_sc_hd__fill_1
XTAP_TAPCELL_ROW_66_1047 VGND VPWR sky130_fd_sc_hd__tapvpwrvgnd_1
XTAP_TAPCELL_ROW_17_455 VGND VPWR sky130_fd_sc_hd__tapvpwrvgnd_1
XFILLER_0_29_313 VGND VGND VPWR VPWR sky130_fd_sc_hd__fill_1
XTAP_TAPCELL_ROW_45_786 VGND VPWR sky130_fd_sc_hd__tapvpwrvgnd_1
XTAP_TAPCELL_ROW_45_797 VGND VPWR sky130_fd_sc_hd__tapvpwrvgnd_1
X_5680_ _2367_ VGND VGND VPWR VPWR _2466_ sky130_fd_sc_hd__inv_2
X_4700_ _1487_ _1488_ _1042_ VGND VGND VPWR VPWR _1489_ sky130_fd_sc_hd__mux2_1
XFILLER_0_56_154 VGND VGND VPWR VPWR sky130_fd_sc_hd__fill_2
X_4631_ RF.reg_arr\[20\]\[27\] RF.reg_arr\[21\]\[27\] RF.reg_arr\[22\]\[27\] RF.reg_arr\[23\]\[27\]
+ _1175_ _1176_ VGND VGND VPWR VPWR _1420_ sky130_fd_sc_hd__mux4_1
X_7350_ _3115_ net976 _3616_ VGND VGND VPWR VPWR _3624_ sky130_fd_sc_hd__mux2_1
X_4562_ RF.reg_arr\[16\]\[21\] RF.reg_arr\[17\]\[21\] RF.reg_arr\[18\]\[21\] RF.reg_arr\[19\]\[21\]
+ _1082_ _1084_ VGND VGND VPWR VPWR _1351_ sky130_fd_sc_hd__mux4_1
XFILLER_0_8_35 VGND VGND VPWR VPWR sky130_fd_sc_hd__fill_1
X_7281_ _3587_ VGND VGND VPWR VPWR _0185_ sky130_fd_sc_hd__clkbuf_1
X_4493_ _1173_ VGND VGND VPWR VPWR _1282_ sky130_fd_sc_hd__clkbuf_4
XFILLER_0_12_246 VGND VGND VPWR VPWR sky130_fd_sc_hd__decap_6
XFILLER_0_12_213 VGND VGND VPWR VPWR sky130_fd_sc_hd__fill_2
Xhold604 RF.reg_arr\[13\]\[7\] VGND VGND VPWR VPWR net686 sky130_fd_sc_hd__dlygate4sd3_1
X_6301_ net22 VGND VGND VPWR VPWR _3033_ sky130_fd_sc_hd__buf_2
XFILLER_0_40_533 VGND VGND VPWR VPWR sky130_fd_sc_hd__decap_4
Xhold626 RF.reg_arr\[8\]\[11\] VGND VGND VPWR VPWR net708 sky130_fd_sc_hd__dlygate4sd3_1
Xhold615 RF.reg_arr\[13\]\[1\] VGND VGND VPWR VPWR net697 sky130_fd_sc_hd__dlygate4sd3_1
Xhold648 RF.reg_arr\[16\]\[26\] VGND VGND VPWR VPWR net730 sky130_fd_sc_hd__dlygate4sd3_1
XFILLER_0_100_62 VGND VGND VPWR VPWR sky130_fd_sc_hd__fill_1
X_6232_ _2985_ VGND VGND VPWR VPWR _0762_ sky130_fd_sc_hd__clkbuf_1
XTAP_TAPCELL_ROW_77_1176 VGND VPWR sky130_fd_sc_hd__tapvpwrvgnd_1
X_9020_ clknet_leaf_22_CLK _0253_ VGND VGND VPWR VPWR RF.reg_arr\[27\]\[30\] sky130_fd_sc_hd__dfxtp_1
Xhold637 RF.reg_arr\[29\]\[5\] VGND VGND VPWR VPWR net719 sky130_fd_sc_hd__dlygate4sd3_1
Xhold659 RF.reg_arr\[13\]\[14\] VGND VGND VPWR VPWR net741 sky130_fd_sc_hd__dlygate4sd3_1
XTAP_TAPCELL_ROW_90_1332 VGND VPWR sky130_fd_sc_hd__tapvpwrvgnd_1
XFILLER_0_0_641 VGND VGND VPWR VPWR sky130_fd_sc_hd__decap_3
X_6163_ _2890_ _2922_ _2923_ VGND VGND VPWR VPWR _2924_ sky130_fd_sc_hd__a21oi_1
XFILLER_0_0_685 VGND VGND VPWR VPWR sky130_fd_sc_hd__decap_6
X_6094_ _2799_ _1550_ _1385_ net1124 VGND VGND VPWR VPWR _2859_ sky130_fd_sc_hd__and4_1
X_5114_ RF.reg_arr\[8\]\[20\] RF.reg_arr\[9\]\[20\] RF.reg_arr\[10\]\[20\] RF.reg_arr\[11\]\[20\]
+ _1625_ _1598_ VGND VGND VPWR VPWR _1903_ sky130_fd_sc_hd__mux4_1
X_5045_ _1679_ VGND VGND VPWR VPWR _1834_ sky130_fd_sc_hd__clkbuf_4
XFILLER_0_26_3 VGND VGND VPWR VPWR sky130_fd_sc_hd__decap_6
X_6996_ net28 VGND VGND VPWR VPWR _3435_ sky130_fd_sc_hd__buf_2
X_8804_ clknet_leaf_88_CLK _0037_ VGND VGND VPWR VPWR RF.reg_arr\[4\]\[6\] sky130_fd_sc_hd__dfxtp_1
X_5947_ _1981_ _2158_ VGND VGND VPWR VPWR _2720_ sky130_fd_sc_hd__nand2_1
X_8735_ clknet_leaf_58_CLK _0992_ VGND VGND VPWR VPWR RF.reg_arr\[6\]\[1\] sky130_fd_sc_hd__dfxtp_1
X_8666_ clknet_leaf_28_CLK _0923_ VGND VGND VPWR VPWR RF.reg_arr\[8\]\[28\] sky130_fd_sc_hd__dfxtp_1
X_5878_ _2104_ _2254_ _1756_ VGND VGND VPWR VPWR _2655_ sky130_fd_sc_hd__mux2_1
X_7617_ net547 _3437_ _3763_ VGND VGND VPWR VPWR _3767_ sky130_fd_sc_hd__mux2_1
XFILLER_0_75_485 VGND VGND VPWR VPWR sky130_fd_sc_hd__decap_3
X_8597_ clknet_leaf_42_CLK _0854_ VGND VGND VPWR VPWR RF.reg_arr\[0\]\[23\] sky130_fd_sc_hd__dfxtp_1
X_4829_ _1617_ VGND VGND VPWR VPWR _1618_ sky130_fd_sc_hd__clkbuf_8
XFILLER_0_105_237 VGND VGND VPWR VPWR sky130_fd_sc_hd__fill_1
XFILLER_0_90_477 VGND VGND VPWR VPWR sky130_fd_sc_hd__decap_3
X_7548_ _3730_ VGND VGND VPWR VPWR _0309_ sky130_fd_sc_hd__clkbuf_1
X_7479_ _3107_ net420 _3689_ VGND VGND VPWR VPWR _3693_ sky130_fd_sc_hd__mux2_1
XFILLER_0_113_281 VGND VGND VPWR VPWR sky130_fd_sc_hd__fill_2
XFILLER_0_101_421 VGND VGND VPWR VPWR sky130_fd_sc_hd__decap_6
X_9218_ clknet_leaf_76_CLK _0451_ VGND VGND VPWR VPWR RF.reg_arr\[22\]\[4\] sky130_fd_sc_hd__dfxtp_1
X_9149_ clknet_leaf_21_CLK _0382_ VGND VGND VPWR VPWR RF.reg_arr\[30\]\[31\] sky130_fd_sc_hd__dfxtp_1
XFILLER_0_98_533 VGND VGND VPWR VPWR sky130_fd_sc_hd__decap_8
XFILLER_0_58_419 VGND VGND VPWR VPWR sky130_fd_sc_hd__fill_1
XFILLER_0_14_27 VGND VGND VPWR VPWR sky130_fd_sc_hd__fill_1
XFILLER_0_66_463 VGND VGND VPWR VPWR sky130_fd_sc_hd__fill_1
XTAP_TAPCELL_ROW_14_414 VGND VPWR sky130_fd_sc_hd__tapvpwrvgnd_1
XTAP_TAPCELL_ROW_14_425 VGND VPWR sky130_fd_sc_hd__tapvpwrvgnd_1
XTAP_TAPCELL_ROW_42_756 VGND VPWR sky130_fd_sc_hd__tapvpwrvgnd_1
XFILLER_0_66_496 VGND VGND VPWR VPWR sky130_fd_sc_hd__fill_1
XFILLER_0_38_165 VGND VGND VPWR VPWR sky130_fd_sc_hd__decap_4
XFILLER_0_53_113 VGND VGND VPWR VPWR sky130_fd_sc_hd__decap_3
XTAP_TAPCELL_ROW_113_1608 VGND VPWR sky130_fd_sc_hd__tapvpwrvgnd_1
XFILLER_0_89_500 VGND VGND VPWR VPWR sky130_fd_sc_hd__fill_1
X_6850_ _3342_ _3305_ VGND VGND VPWR VPWR _3343_ sky130_fd_sc_hd__nor2_4
X_5801_ _2580_ _2581_ VGND VGND VPWR VPWR _2582_ sky130_fd_sc_hd__nor2_1
X_6781_ _2971_ _3305_ VGND VGND VPWR VPWR _3306_ sky130_fd_sc_hd__nor2_4
XPHY_EDGE_ROW_8_Right_8 VGND VGND VPWR VPWR sky130_fd_sc_hd__decap_3
XFILLER_0_29_121 VGND VGND VPWR VPWR sky130_fd_sc_hd__fill_1
X_5732_ _1065_ _2515_ VGND VGND VPWR VPWR _2516_ sky130_fd_sc_hd__xor2_1
X_8520_ clknet_leaf_90_CLK _0777_ VGND VGND VPWR VPWR RF.reg_arr\[1\]\[10\] sky130_fd_sc_hd__dfxtp_1
XFILLER_0_72_400 VGND VGND VPWR VPWR sky130_fd_sc_hd__decap_3
XFILLER_0_45_614 VGND VGND VPWR VPWR sky130_fd_sc_hd__fill_2
X_8451_ _4208_ VGND VGND VPWR VPWR _0734_ sky130_fd_sc_hd__clkbuf_1
XTAP_TAPCELL_ROW_79_1205 VGND VPWR sky130_fd_sc_hd__tapvpwrvgnd_1
X_5663_ _2309_ _2449_ VGND VGND VPWR VPWR _2450_ sky130_fd_sc_hd__xnor2_1
XFILLER_0_111_50 VGND VGND VPWR VPWR sky130_fd_sc_hd__decap_6
X_5594_ _2198_ _2381_ VGND VGND VPWR VPWR _2382_ sky130_fd_sc_hd__or2_1
X_8382_ _2992_ net904 _4137_ VGND VGND VPWR VPWR _4172_ sky130_fd_sc_hd__mux2_1
XFILLER_0_72_477 VGND VGND VPWR VPWR sky130_fd_sc_hd__fill_2
X_4614_ RF.reg_arr\[16\]\[7\] RF.reg_arr\[17\]\[7\] RF.reg_arr\[18\]\[7\] RF.reg_arr\[19\]\[7\]
+ _1186_ _1188_ VGND VGND VPWR VPWR _1403_ sky130_fd_sc_hd__mux4_1
X_7402_ _3651_ VGND VGND VPWR VPWR _0242_ sky130_fd_sc_hd__clkbuf_1
X_4545_ RF.reg_arr\[20\]\[20\] RF.reg_arr\[21\]\[20\] RF.reg_arr\[22\]\[20\] RF.reg_arr\[23\]\[20\]
+ _1129_ _1130_ VGND VGND VPWR VPWR _1334_ sky130_fd_sc_hd__mux4_1
Xhold401 RF.reg_arr\[27\]\[15\] VGND VGND VPWR VPWR net483 sky130_fd_sc_hd__dlygate4sd3_1
XFILLER_0_25_382 VGND VGND VPWR VPWR sky130_fd_sc_hd__decap_3
XFILLER_0_25_393 VGND VGND VPWR VPWR sky130_fd_sc_hd__fill_2
X_7333_ _3098_ net995 _3605_ VGND VGND VPWR VPWR _3615_ sky130_fd_sc_hd__mux2_1
XFILLER_0_53_691 VGND VGND VPWR VPWR sky130_fd_sc_hd__fill_1
Xhold423 RF.reg_arr\[24\]\[25\] VGND VGND VPWR VPWR net505 sky130_fd_sc_hd__dlygate4sd3_1
Xhold434 RF.reg_arr\[21\]\[25\] VGND VGND VPWR VPWR net516 sky130_fd_sc_hd__dlygate4sd3_1
Xhold412 RF.reg_arr\[25\]\[15\] VGND VGND VPWR VPWR net494 sky130_fd_sc_hd__dlygate4sd3_1
Xhold445 RF.reg_arr\[11\]\[18\] VGND VGND VPWR VPWR net527 sky130_fd_sc_hd__dlygate4sd3_1
XFILLER_0_40_341 VGND VGND VPWR VPWR sky130_fd_sc_hd__decap_3
Xhold478 RF.reg_arr\[21\]\[29\] VGND VGND VPWR VPWR net560 sky130_fd_sc_hd__dlygate4sd3_1
Xhold467 RF.reg_arr\[29\]\[23\] VGND VGND VPWR VPWR net549 sky130_fd_sc_hd__dlygate4sd3_1
Xhold456 RF.reg_arr\[17\]\[30\] VGND VGND VPWR VPWR net538 sky130_fd_sc_hd__dlygate4sd3_1
X_7264_ _3578_ VGND VGND VPWR VPWR _0177_ sky130_fd_sc_hd__clkbuf_1
XFILLER_0_40_385 VGND VGND VPWR VPWR sky130_fd_sc_hd__fill_1
X_9003_ clknet_leaf_94_CLK _0236_ VGND VGND VPWR VPWR RF.reg_arr\[27\]\[13\] sky130_fd_sc_hd__dfxtp_1
X_4476_ _1059_ _1261_ _1264_ _1061_ VGND VGND VPWR VPWR _1265_ sky130_fd_sc_hd__o211a_1
Xhold489 RF.reg_arr\[15\]\[28\] VGND VGND VPWR VPWR net571 sky130_fd_sc_hd__dlygate4sd3_1
X_6215_ net13 VGND VGND VPWR VPWR _2972_ sky130_fd_sc_hd__clkbuf_4
X_7195_ _3541_ VGND VGND VPWR VPWR _0145_ sky130_fd_sc_hd__clkbuf_1
XPHY_EDGE_ROW_39_Right_39 VGND VGND VPWR VPWR sky130_fd_sc_hd__decap_3
X_6146_ _2877_ _2907_ _2276_ VGND VGND VPWR VPWR _2908_ sky130_fd_sc_hd__mux2_1
X_6077_ _2585_ _2558_ _2838_ _2842_ VGND VGND VPWR VPWR _2843_ sky130_fd_sc_hd__a211o_1
X_5028_ RF.reg_arr\[28\]\[2\] RF.reg_arr\[29\]\[2\] RF.reg_arr\[30\]\[2\] RF.reg_arr\[31\]\[2\]
+ _1262_ _1045_ VGND VGND VPWR VPWR _1817_ sky130_fd_sc_hd__mux4_1
XFILLER_0_36_603 VGND VGND VPWR VPWR sky130_fd_sc_hd__fill_1
X_6979_ _3423_ VGND VGND VPWR VPWR _0047_ sky130_fd_sc_hd__clkbuf_1
XPHY_EDGE_ROW_48_Right_48 VGND VGND VPWR VPWR sky130_fd_sc_hd__decap_3
XFILLER_0_75_271 VGND VGND VPWR VPWR sky130_fd_sc_hd__decap_8
XFILLER_0_63_422 VGND VGND VPWR VPWR sky130_fd_sc_hd__decap_3
XFILLER_0_35_113 VGND VGND VPWR VPWR sky130_fd_sc_hd__fill_1
X_8718_ clknet_leaf_3_CLK _0975_ VGND VGND VPWR VPWR RF.reg_arr\[14\]\[16\] sky130_fd_sc_hd__dfxtp_1
XFILLER_0_48_474 VGND VGND VPWR VPWR sky130_fd_sc_hd__fill_2
XFILLER_0_106_502 VGND VGND VPWR VPWR sky130_fd_sc_hd__decap_4
XFILLER_0_75_293 VGND VGND VPWR VPWR sky130_fd_sc_hd__decap_8
X_8649_ clknet_leaf_91_CLK _0906_ VGND VGND VPWR VPWR RF.reg_arr\[8\]\[11\] sky130_fd_sc_hd__dfxtp_1
XFILLER_0_106_546 VGND VGND VPWR VPWR sky130_fd_sc_hd__fill_1
XPHY_EDGE_ROW_57_Right_57 VGND VGND VPWR VPWR sky130_fd_sc_hd__decap_3
XFILLER_0_101_262 VGND VGND VPWR VPWR sky130_fd_sc_hd__fill_1
Xhold990 RF.reg_arr\[20\]\[31\] VGND VGND VPWR VPWR net1072 sky130_fd_sc_hd__dlygate4sd3_1
XTAP_TAPCELL_ROW_47_815 VGND VPWR sky130_fd_sc_hd__tapvpwrvgnd_1
XFILLER_0_98_374 VGND VGND VPWR VPWR sky130_fd_sc_hd__fill_2
XPHY_EDGE_ROW_66_Right_66 VGND VGND VPWR VPWR sky130_fd_sc_hd__decap_3
XTAP_TAPCELL_ROW_63_1006 VGND VPWR sky130_fd_sc_hd__tapvpwrvgnd_1
XTAP_TAPCELL_ROW_27_572 VGND VPWR sky130_fd_sc_hd__tapvpwrvgnd_1
XFILLER_0_109_384 VGND VGND VPWR VPWR sky130_fd_sc_hd__decap_8
XFILLER_0_54_477 VGND VGND VPWR VPWR sky130_fd_sc_hd__fill_2
XFILLER_0_112_516 VPWR VGND VPWR VGND sky130_ef_sc_hd__decap_12
XFILLER_0_81_296 VGND VGND VPWR VPWR sky130_fd_sc_hd__decap_3
XPHY_EDGE_ROW_75_Right_75 VGND VGND VPWR VPWR sky130_fd_sc_hd__decap_3
XFILLER_0_22_330 VGND VGND VPWR VPWR sky130_fd_sc_hd__fill_1
XTAP_TAPCELL_ROW_74_1135 VGND VPWR sky130_fd_sc_hd__tapvpwrvgnd_1
X_4330_ RF.reg_arr\[20\]\[16\] RF.reg_arr\[21\]\[16\] RF.reg_arr\[22\]\[16\] RF.reg_arr\[23\]\[16\]
+ _1117_ _1118_ VGND VGND VPWR VPWR _1119_ sky130_fd_sc_hd__mux4_1
X_4261_ _1026_ VGND VGND VPWR VPWR _1050_ sky130_fd_sc_hd__buf_8
X_6000_ _1206_ _2738_ net95 _2547_ VGND VGND VPWR VPWR _2770_ sky130_fd_sc_hd__o31a_1
XFILLER_0_89_330 VGND VGND VPWR VPWR sky130_fd_sc_hd__decap_6
XPHY_EDGE_ROW_84_Right_84 VGND VGND VPWR VPWR sky130_fd_sc_hd__decap_3
X_7951_ _3921_ VGND VGND VPWR VPWR _3944_ sky130_fd_sc_hd__clkbuf_8
XPHY_EDGE_ROW_19_Left_136 VGND VGND VPWR VPWR sky130_fd_sc_hd__decap_3
X_6902_ net30 VGND VGND VPWR VPWR _3371_ sky130_fd_sc_hd__buf_2
X_7882_ _3907_ VGND VGND VPWR VPWR _0466_ sky130_fd_sc_hd__clkbuf_1
X_6833_ net247 _2970_ _3329_ VGND VGND VPWR VPWR _3334_ sky130_fd_sc_hd__mux2_1
XFILLER_0_89_385 VGND VGND VPWR VPWR sky130_fd_sc_hd__decap_6
XTAP_TAPCELL_ROW_85_1275 VGND VPWR sky130_fd_sc_hd__tapvpwrvgnd_1
XFILLER_0_106_83 VGND VGND VPWR VPWR sky130_fd_sc_hd__fill_1
X_6764_ _3109_ net791 _3292_ VGND VGND VPWR VPWR _3297_ sky130_fd_sc_hd__mux2_1
XFILLER_0_57_260 VGND VGND VPWR VPWR sky130_fd_sc_hd__fill_1
X_6695_ _3259_ VGND VGND VPWR VPWR _0951_ sky130_fd_sc_hd__clkbuf_1
X_8503_ clknet_leaf_38_CLK _0760_ VGND VGND VPWR VPWR RF.reg_arr\[10\]\[25\] sky130_fd_sc_hd__dfxtp_1
X_5715_ _2216_ _2498_ VGND VGND VPWR VPWR _2500_ sky130_fd_sc_hd__nand2_1
X_9483_ clknet_leaf_91_CLK _0716_ VGND VGND VPWR VPWR RF.reg_arr\[11\]\[13\] sky130_fd_sc_hd__dfxtp_1
X_5646_ _2029_ _1666_ VGND VGND VPWR VPWR _2433_ sky130_fd_sc_hd__or2_1
XFILLER_0_93_3 VPWR VGND VPWR VGND sky130_ef_sc_hd__decap_12
X_8434_ net269 _3437_ _4196_ VGND VGND VPWR VPWR _4200_ sky130_fd_sc_hd__mux2_1
XPHY_EDGE_ROW_28_Left_145 VGND VGND VPWR VPWR sky130_fd_sc_hd__decap_3
XPHY_EDGE_ROW_93_Right_93 VGND VGND VPWR VPWR sky130_fd_sc_hd__decap_3
X_5577_ _2363_ _2364_ VGND VGND VPWR VPWR _2365_ sky130_fd_sc_hd__nand2_1
X_8365_ _4163_ VGND VGND VPWR VPWR _0693_ sky130_fd_sc_hd__clkbuf_1
Xhold220 RF.reg_arr\[6\]\[1\] VGND VGND VPWR VPWR net302 sky130_fd_sc_hd__dlygate4sd3_1
X_4528_ RF.reg_arr\[20\]\[23\] RF.reg_arr\[21\]\[23\] RF.reg_arr\[22\]\[23\] RF.reg_arr\[23\]\[23\]
+ _1316_ _1304_ VGND VGND VPWR VPWR _1317_ sky130_fd_sc_hd__mux4_1
X_8296_ net151 _3435_ _4124_ VGND VGND VPWR VPWR _4127_ sky130_fd_sc_hd__mux2_1
Xhold242 RF.reg_arr\[11\]\[2\] VGND VGND VPWR VPWR net324 sky130_fd_sc_hd__dlygate4sd3_1
X_7316_ _3606_ VGND VGND VPWR VPWR _0201_ sky130_fd_sc_hd__clkbuf_1
Xhold231 RF.reg_arr\[5\]\[19\] VGND VGND VPWR VPWR net313 sky130_fd_sc_hd__dlygate4sd3_1
Xhold253 RF.reg_arr\[14\]\[1\] VGND VGND VPWR VPWR net335 sky130_fd_sc_hd__dlygate4sd3_1
Xhold264 RF.reg_arr\[8\]\[28\] VGND VGND VPWR VPWR net346 sky130_fd_sc_hd__dlygate4sd3_1
Xhold286 RF.reg_arr\[2\]\[27\] VGND VGND VPWR VPWR net368 sky130_fd_sc_hd__dlygate4sd3_1
Xhold275 RF.reg_arr\[11\]\[7\] VGND VGND VPWR VPWR net357 sky130_fd_sc_hd__dlygate4sd3_1
XFILLER_0_40_182 VGND VGND VPWR VPWR sky130_fd_sc_hd__decap_3
X_7247_ _3079_ net410 _3569_ VGND VGND VPWR VPWR _3570_ sky130_fd_sc_hd__mux2_1
X_4459_ RF.reg_arr\[12\]\[10\] RF.reg_arr\[13\]\[10\] RF.reg_arr\[14\]\[10\] RF.reg_arr\[15\]\[10\]
+ _1229_ _1230_ VGND VGND VPWR VPWR _1248_ sky130_fd_sc_hd__mux4_1
Xhold297 RF.reg_arr\[6\]\[31\] VGND VGND VPWR VPWR net379 sky130_fd_sc_hd__dlygate4sd3_1
X_7178_ net678 _3409_ _3532_ VGND VGND VPWR VPWR _3533_ sky130_fd_sc_hd__mux2_1
X_6129_ _2890_ _2891_ VGND VGND VPWR VPWR _2892_ sky130_fd_sc_hd__nor2_1
XPHY_EDGE_ROW_37_Left_154 VGND VGND VPWR VPWR sky130_fd_sc_hd__decap_3
XFILLER_0_68_558 VGND VGND VPWR VPWR sky130_fd_sc_hd__fill_1
XTAP_TAPCELL_ROW_24_542 VGND VPWR sky130_fd_sc_hd__tapvpwrvgnd_1
XPHY_EDGE_ROW_46_Left_163 VGND VGND VPWR VPWR sky130_fd_sc_hd__decap_3
XTAP_TAPCELL_ROW_52_873 VGND VPWR sky130_fd_sc_hd__tapvpwrvgnd_1
XFILLER_0_91_561 VGND VGND VPWR VPWR sky130_fd_sc_hd__decap_3
XFILLER_0_106_343 VGND VGND VPWR VPWR sky130_fd_sc_hd__fill_1
XPHY_EDGE_ROW_55_Left_172 VGND VGND VPWR VPWR sky130_fd_sc_hd__decap_3
XFILLER_0_52_13 VGND VGND VPWR VPWR sky130_fd_sc_hd__fill_2
XPHY_EDGE_ROW_64_Left_181 VGND VGND VPWR VPWR sky130_fd_sc_hd__decap_3
XFILLER_0_82_561 VGND VGND VPWR VPWR sky130_fd_sc_hd__fill_2
X_5500_ RF.reg_arr\[0\]\[3\] RF.reg_arr\[1\]\[3\] RF.reg_arr\[2\]\[3\] RF.reg_arr\[3\]\[3\]
+ _1846_ _1849_ VGND VGND VPWR VPWR _2289_ sky130_fd_sc_hd__mux4_1
X_6480_ net117 VGND VGND VPWR VPWR _3145_ sky130_fd_sc_hd__clkbuf_1
XFILLER_0_42_425 VGND VGND VPWR VPWR sky130_fd_sc_hd__fill_1
XFILLER_0_2_533 VGND VGND VPWR VPWR sky130_fd_sc_hd__decap_6
X_5431_ RF.reg_arr\[16\]\[5\] RF.reg_arr\[17\]\[5\] RF.reg_arr\[18\]\[5\] RF.reg_arr\[19\]\[5\]
+ _1589_ _1834_ VGND VGND VPWR VPWR _2220_ sky130_fd_sc_hd__mux4_1
XFILLER_0_23_650 VGND VGND VPWR VPWR sky130_fd_sc_hd__decap_4
XFILLER_0_77_10 VGND VGND VPWR VPWR sky130_fd_sc_hd__decap_8
Xclkbuf_leaf_60_CLK clknet_3_7__leaf_CLK VGND VGND VPWR VPWR clknet_leaf_60_CLK sky130_fd_sc_hd__clkbuf_8
X_8150_ _4049_ VGND VGND VPWR VPWR _0592_ sky130_fd_sc_hd__clkbuf_1
X_5362_ RF.reg_arr\[0\]\[15\] RF.reg_arr\[1\]\[15\] RF.reg_arr\[2\]\[15\] RF.reg_arr\[3\]\[15\]
+ _1590_ _1835_ VGND VGND VPWR VPWR _2151_ sky130_fd_sc_hd__mux4_1
XFILLER_0_77_54 VGND VGND VPWR VPWR sky130_fd_sc_hd__fill_2
XPHY_EDGE_ROW_73_Left_190 VGND VGND VPWR VPWR sky130_fd_sc_hd__decap_3
X_8081_ _3033_ net1027 _4005_ VGND VGND VPWR VPWR _4013_ sky130_fd_sc_hd__mux2_1
X_7101_ net358 _3401_ _3485_ VGND VGND VPWR VPWR _3492_ sky130_fd_sc_hd__mux2_1
X_4313_ _1034_ _1101_ VGND VGND VPWR VPWR _1102_ sky130_fd_sc_hd__or2_1
X_5293_ _1618_ _2081_ _1586_ VGND VGND VPWR VPWR _2082_ sky130_fd_sc_hd__a21oi_1
X_7032_ _3455_ VGND VGND VPWR VPWR _0068_ sky130_fd_sc_hd__clkbuf_1
X_4244_ _1032_ VGND VGND VPWR VPWR _1033_ sky130_fd_sc_hd__clkbuf_8
X_8983_ clknet_leaf_31_CLK _0216_ VGND VGND VPWR VPWR RF.reg_arr\[31\]\[25\] sky130_fd_sc_hd__dfxtp_1
X_7934_ _3935_ VGND VGND VPWR VPWR _0490_ sky130_fd_sc_hd__clkbuf_1
X_7865_ _3082_ net984 _3897_ VGND VGND VPWR VPWR _3899_ sky130_fd_sc_hd__mux2_1
XFILLER_0_65_539 VGND VGND VPWR VPWR sky130_fd_sc_hd__decap_6
XFILLER_0_58_580 VGND VGND VPWR VPWR sky130_fd_sc_hd__decap_8
X_6816_ net517 _3031_ _3318_ VGND VGND VPWR VPWR _3325_ sky130_fd_sc_hd__mux2_1
X_7796_ _3082_ net997 _3860_ VGND VGND VPWR VPWR _3862_ sky130_fd_sc_hd__mux2_1
XFILLER_0_92_336 VGND VGND VPWR VPWR sky130_fd_sc_hd__fill_1
XTAP_TAPCELL_ROW_21_501 VGND VPWR sky130_fd_sc_hd__tapvpwrvgnd_1
X_6747_ _3092_ net1012 _3281_ VGND VGND VPWR VPWR _3288_ sky130_fd_sc_hd__mux2_1
XTAP_TAPCELL_ROW_98_1422 VGND VPWR sky130_fd_sc_hd__tapvpwrvgnd_1
XFILLER_0_73_561 VPWR VGND VPWR VGND sky130_ef_sc_hd__decap_12
XFILLER_0_116_641 VGND VGND VPWR VPWR sky130_fd_sc_hd__decap_3
X_9466_ clknet_leaf_28_CLK _0699_ VGND VGND VPWR VPWR RF.reg_arr\[12\]\[28\] sky130_fd_sc_hd__dfxtp_1
XTAP_TAPCELL_ROW_98_1433 VGND VPWR sky130_fd_sc_hd__tapvpwrvgnd_1
XFILLER_0_33_447 VGND VGND VPWR VPWR sky130_fd_sc_hd__fill_1
X_6678_ _3250_ VGND VGND VPWR VPWR _0943_ sky130_fd_sc_hd__clkbuf_1
XFILLER_0_116_685 VGND VGND VPWR VPWR sky130_fd_sc_hd__decap_6
X_5629_ _1092_ _2379_ _2416_ VGND VGND VPWR VPWR _2417_ sky130_fd_sc_hd__o21a_1
X_9397_ clknet_leaf_40_CLK _0630_ VGND VGND VPWR VPWR RF.reg_arr\[13\]\[23\] sky130_fd_sc_hd__dfxtp_1
X_8417_ net264 _3420_ _4185_ VGND VGND VPWR VPWR _4191_ sky130_fd_sc_hd__mux2_1
Xclkbuf_leaf_51_CLK clknet_3_6__leaf_CLK VGND VGND VPWR VPWR clknet_leaf_51_CLK sky130_fd_sc_hd__clkbuf_8
X_8348_ _4154_ VGND VGND VPWR VPWR _0685_ sky130_fd_sc_hd__clkbuf_1
X_8279_ net258 _3418_ _4113_ VGND VGND VPWR VPWR _4118_ sky130_fd_sc_hd__mux2_1
XTAP_TAPCELL_ROW_29_601 VGND VPWR sky130_fd_sc_hd__tapvpwrvgnd_1
XTAP_TAPCELL_ROW_57_932 VGND VPWR sky130_fd_sc_hd__tapvpwrvgnd_1
XTAP_TAPCELL_ROW_107_1540 VGND VPWR sky130_fd_sc_hd__tapvpwrvgnd_1
XFILLER_0_96_675 VGND VGND VPWR VPWR sky130_fd_sc_hd__fill_1
XFILLER_0_83_314 VGND VGND VPWR VPWR sky130_fd_sc_hd__fill_1
XFILLER_0_68_377 VGND VGND VPWR VPWR sky130_fd_sc_hd__fill_1
XFILLER_0_22_38 VGND VGND VPWR VPWR sky130_fd_sc_hd__decap_6
XFILLER_0_107_641 VGND VGND VPWR VPWR sky130_fd_sc_hd__decap_4
XFILLER_0_91_391 VGND VGND VPWR VPWR sky130_fd_sc_hd__fill_1
XFILLER_0_51_222 VGND VGND VPWR VPWR sky130_fd_sc_hd__fill_2
XFILLER_0_107_685 VGND VGND VPWR VPWR sky130_fd_sc_hd__decap_6
Xclkbuf_leaf_42_CLK clknet_3_3__leaf_CLK VGND VGND VPWR VPWR clknet_leaf_42_CLK sky130_fd_sc_hd__clkbuf_8
XFILLER_0_11_119 VGND VGND VPWR VPWR sky130_fd_sc_hd__fill_1
XTAP_TAPCELL_ROW_71_1105 VGND VPWR sky130_fd_sc_hd__tapvpwrvgnd_1
XFILLER_0_2_15 VPWR VGND VPWR VGND sky130_ef_sc_hd__decap_12
X_5980_ _2568_ _2745_ _2751_ VGND VGND VPWR VPWR net57 sky130_fd_sc_hd__o21ai_1
XTAP_TAPCELL_ROW_69_1078 VGND VPWR sky130_fd_sc_hd__tapvpwrvgnd_1
XFILLER_0_63_34 VGND VGND VPWR VPWR sky130_fd_sc_hd__fill_1
X_4931_ RF.reg_arr\[20\]\[1\] RF.reg_arr\[21\]\[1\] RF.reg_arr\[22\]\[1\] RF.reg_arr\[23\]\[1\]
+ _1262_ _1045_ VGND VGND VPWR VPWR _1720_ sky130_fd_sc_hd__mux4_1
XFILLER_0_87_686 VGND VGND VPWR VPWR sky130_fd_sc_hd__decap_6
XTAP_TAPCELL_ROW_82_1234 VGND VPWR sky130_fd_sc_hd__tapvpwrvgnd_1
XFILLER_0_74_303 VGND VGND VPWR VPWR sky130_fd_sc_hd__fill_1
X_4862_ RF.reg_arr\[16\]\[30\] RF.reg_arr\[17\]\[30\] RF.reg_arr\[18\]\[30\] RF.reg_arr\[19\]\[30\]
+ _1593_ _1600_ VGND VGND VPWR VPWR _1651_ sky130_fd_sc_hd__mux4_1
X_7650_ _3784_ VGND VGND VPWR VPWR _0357_ sky130_fd_sc_hd__clkbuf_1
XFILLER_0_19_219 VGND VGND VPWR VPWR sky130_fd_sc_hd__fill_1
XFILLER_0_74_336 VGND VGND VPWR VPWR sky130_fd_sc_hd__decap_8
X_6601_ net803 _3023_ _3207_ VGND VGND VPWR VPWR _3210_ sky130_fd_sc_hd__mux2_1
X_4793_ _1467_ _1483_ _1550_ _1581_ VGND VGND VPWR VPWR _1582_ sky130_fd_sc_hd__nand4_1
XANTENNA_26 _1158_ VGND VGND VPWR VPWR sky130_fd_sc_hd__diode_2
XANTENNA_15 _1842_ VGND VGND VPWR VPWR sky130_fd_sc_hd__diode_2
X_7581_ net262 _3401_ _3741_ VGND VGND VPWR VPWR _3748_ sky130_fd_sc_hd__mux2_1
X_9320_ clknet_leaf_94_CLK _0553_ VGND VGND VPWR VPWR RF.reg_arr\[20\]\[10\] sky130_fd_sc_hd__dfxtp_1
X_6532_ _3173_ VGND VGND VPWR VPWR _0874_ sky130_fd_sc_hd__clkbuf_1
X_9251_ clknet_leaf_79_CLK _0484_ VGND VGND VPWR VPWR RF.reg_arr\[21\]\[5\] sky130_fd_sc_hd__dfxtp_1
X_6463_ _3136_ VGND VGND VPWR VPWR _0842_ sky130_fd_sc_hd__clkbuf_1
XFILLER_0_70_597 VGND VGND VPWR VPWR sky130_fd_sc_hd__decap_3
X_5414_ _2201_ _2202_ _1863_ VGND VGND VPWR VPWR _2203_ sky130_fd_sc_hd__mux2_1
X_9182_ clknet_leaf_75_CLK _0415_ VGND VGND VPWR VPWR RF.reg_arr\[24\]\[0\] sky130_fd_sc_hd__dfxtp_1
X_8202_ _4065_ VGND VGND VPWR VPWR _4077_ sky130_fd_sc_hd__clkbuf_8
Xclkbuf_leaf_33_CLK clknet_3_3__leaf_CLK VGND VGND VPWR VPWR clknet_leaf_33_CLK sky130_fd_sc_hd__clkbuf_8
X_8133_ _4040_ VGND VGND VPWR VPWR _0584_ sky130_fd_sc_hd__clkbuf_1
XFILLER_0_2_363 VGND VGND VPWR VPWR sky130_fd_sc_hd__fill_1
X_6394_ net22 VGND VGND VPWR VPWR _3094_ sky130_fd_sc_hd__clkbuf_2
XTAP_TAPCELL_ROW_93_1363 VGND VPWR sky130_fd_sc_hd__tapvpwrvgnd_1
XFILLER_0_2_385 VGND VGND VPWR VPWR sky130_fd_sc_hd__decap_4
X_5345_ RF.reg_arr\[12\]\[14\] RF.reg_arr\[13\]\[14\] RF.reg_arr\[14\]\[14\] RF.reg_arr\[15\]\[14\]
+ _1883_ _1885_ VGND VGND VPWR VPWR _2134_ sky130_fd_sc_hd__mux4_1
XFILLER_0_56_3 VGND VGND VPWR VPWR sky130_fd_sc_hd__fill_1
X_8064_ _3016_ net848 _3994_ VGND VGND VPWR VPWR _4004_ sky130_fd_sc_hd__mux2_1
X_5276_ _2063_ _2064_ _1865_ VGND VGND VPWR VPWR _2065_ sky130_fd_sc_hd__mux2_1
X_7015_ _3445_ VGND VGND VPWR VPWR _0061_ sky130_fd_sc_hd__clkbuf_1
XFILLER_0_78_631 VGND VGND VPWR VPWR sky130_fd_sc_hd__decap_4
X_8966_ clknet_leaf_82_CLK _0199_ VGND VGND VPWR VPWR RF.reg_arr\[31\]\[8\] sky130_fd_sc_hd__dfxtp_1
XTAP_TAPCELL_ROW_54_902 VGND VPWR sky130_fd_sc_hd__tapvpwrvgnd_1
XFILLER_0_78_653 VGND VGND VPWR VPWR sky130_fd_sc_hd__fill_1
X_7917_ _3926_ VGND VGND VPWR VPWR _0482_ sky130_fd_sc_hd__clkbuf_1
XFILLER_0_38_528 VGND VGND VPWR VPWR sky130_fd_sc_hd__decap_4
X_8897_ clknet_leaf_64_CLK _0130_ VGND VGND VPWR VPWR RF.reg_arr\[7\]\[3\] sky130_fd_sc_hd__dfxtp_1
XFILLER_0_108_405 VGND VGND VPWR VPWR sky130_fd_sc_hd__fill_1
XFILLER_0_92_133 VGND VGND VPWR VPWR sky130_fd_sc_hd__fill_1
XFILLER_0_77_185 VGND VGND VPWR VPWR sky130_fd_sc_hd__fill_2
X_7848_ _3065_ net677 _3886_ VGND VGND VPWR VPWR _3890_ sky130_fd_sc_hd__mux2_1
XTAP_TAPCELL_ROW_102_1481 VGND VPWR sky130_fd_sc_hd__tapvpwrvgnd_1
XTAP_TAPCELL_ROW_102_1470 VGND VPWR sky130_fd_sc_hd__tapvpwrvgnd_1
XTAP_TAPCELL_ROW_62_990 VGND VPWR sky130_fd_sc_hd__tapvpwrvgnd_1
X_7779_ _3065_ net712 _3849_ VGND VGND VPWR VPWR _3853_ sky130_fd_sc_hd__mux2_1
X_9518_ clknet_leaf_5_CLK _0751_ VGND VGND VPWR VPWR RF.reg_arr\[10\]\[16\] sky130_fd_sc_hd__dfxtp_1
XFILLER_0_33_244 VGND VGND VPWR VPWR sky130_fd_sc_hd__decap_3
X_9449_ clknet_leaf_90_CLK _0682_ VGND VGND VPWR VPWR RF.reg_arr\[12\]\[11\] sky130_fd_sc_hd__dfxtp_1
XFILLER_0_103_110 VGND VGND VPWR VPWR sky130_fd_sc_hd__fill_2
Xclkbuf_leaf_24_CLK clknet_3_2__leaf_CLK VGND VGND VPWR VPWR clknet_leaf_24_CLK sky130_fd_sc_hd__clkbuf_8
XFILLER_0_108_18 VGND VGND VPWR VPWR sky130_fd_sc_hd__decap_8
XFILLER_0_84_645 VGND VGND VPWR VPWR sky130_fd_sc_hd__decap_6
XFILLER_0_83_166 VGND VGND VPWR VPWR sky130_fd_sc_hd__fill_2
XFILLER_0_37_561 VGND VGND VPWR VPWR sky130_fd_sc_hd__decap_4
Xinput13 A3[4] VGND VGND VPWR VPWR net13 sky130_fd_sc_hd__clkbuf_1
Xinput35 WD3[29] VGND VGND VPWR VPWR net35 sky130_fd_sc_hd__buf_1
Xinput46 WE3 VGND VGND VPWR VPWR net46 sky130_fd_sc_hd__buf_1
Xinput24 WD3[19] VGND VGND VPWR VPWR net24 sky130_fd_sc_hd__buf_1
XTAP_TAPCELL_ROW_116_1639 VGND VPWR sky130_fd_sc_hd__tapvpwrvgnd_1
XTAP_TAPCELL_ROW_12_397 VGND VPWR sky130_fd_sc_hd__tapvpwrvgnd_1
Xhold808 RF.reg_arr\[30\]\[6\] VGND VGND VPWR VPWR net890 sky130_fd_sc_hd__dlygate4sd3_1
Xhold819 RF.reg_arr\[13\]\[9\] VGND VGND VPWR VPWR net901 sky130_fd_sc_hd__dlygate4sd3_1
Xclkbuf_leaf_15_CLK clknet_3_3__leaf_CLK VGND VGND VPWR VPWR clknet_leaf_15_CLK sky130_fd_sc_hd__clkbuf_8
XFILLER_0_58_23 VGND VGND VPWR VPWR sky130_fd_sc_hd__fill_2
X_5130_ RF.reg_arr\[8\]\[21\] RF.reg_arr\[9\]\[21\] RF.reg_arr\[10\]\[21\] RF.reg_arr\[11\]\[21\]
+ _1591_ _1878_ VGND VGND VPWR VPWR _1919_ sky130_fd_sc_hd__mux4_1
X_5061_ _1849_ VGND VGND VPWR VPWR _1850_ sky130_fd_sc_hd__buf_4
XFILLER_0_74_66 VGND VGND VPWR VPWR sky130_fd_sc_hd__fill_2
XFILLER_0_79_417 VGND VGND VPWR VPWR sky130_fd_sc_hd__decap_6
X_8820_ clknet_leaf_44_CLK _0053_ VGND VGND VPWR VPWR RF.reg_arr\[4\]\[22\] sky130_fd_sc_hd__dfxtp_1
X_5963_ _2730_ _2732_ _2735_ VGND VGND VPWR VPWR _2736_ sky130_fd_sc_hd__nand3_2
X_8751_ clknet_leaf_1_CLK _1008_ VGND VGND VPWR VPWR RF.reg_arr\[6\]\[17\] sky130_fd_sc_hd__dfxtp_1
X_4914_ _1701_ _1702_ _1605_ VGND VGND VPWR VPWR _1703_ sky130_fd_sc_hd__mux2_1
XFILLER_0_75_601 VPWR VGND VPWR VGND sky130_ef_sc_hd__decap_12
X_7702_ _3811_ VGND VGND VPWR VPWR _0382_ sky130_fd_sc_hd__clkbuf_1
X_5894_ _1511_ _1515_ VGND VGND VPWR VPWR _2670_ sky130_fd_sc_hd__nand2_1
X_8682_ clknet_leaf_97_CLK _0939_ VGND VGND VPWR VPWR RF.reg_arr\[15\]\[12\] sky130_fd_sc_hd__dfxtp_1
X_7633_ net209 _3385_ _3740_ VGND VGND VPWR VPWR _3775_ sky130_fd_sc_hd__mux2_1
X_4845_ net4 VGND VGND VPWR VPWR _1634_ sky130_fd_sc_hd__clkbuf_8
X_4776_ RF.reg_arr\[24\]\[24\] RF.reg_arr\[25\]\[24\] RF.reg_arr\[26\]\[24\] RF.reg_arr\[27\]\[24\]
+ _1302_ _1322_ VGND VGND VPWR VPWR _1565_ sky130_fd_sc_hd__mux4_1
X_7564_ _3738_ VGND VGND VPWR VPWR _0317_ sky130_fd_sc_hd__clkbuf_1
XFILLER_0_99_63 VGND VGND VPWR VPWR sky130_fd_sc_hd__fill_1
X_9303_ clknet_leaf_32_CLK _0536_ VGND VGND VPWR VPWR RF.reg_arr\[25\]\[25\] sky130_fd_sc_hd__dfxtp_1
X_6515_ _3164_ VGND VGND VPWR VPWR _0866_ sky130_fd_sc_hd__clkbuf_1
XFILLER_0_55_391 VGND VGND VPWR VPWR sky130_fd_sc_hd__fill_1
X_7495_ _3123_ net1043 _3666_ VGND VGND VPWR VPWR _3701_ sky130_fd_sc_hd__mux2_1
XFILLER_0_101_614 VGND VGND VPWR VPWR sky130_fd_sc_hd__fill_2
XFILLER_0_70_383 VGND VGND VPWR VPWR sky130_fd_sc_hd__fill_1
X_9234_ clknet_leaf_15_CLK _0467_ VGND VGND VPWR VPWR RF.reg_arr\[22\]\[20\] sky130_fd_sc_hd__dfxtp_1
X_6446_ net105 VGND VGND VPWR VPWR _3128_ sky130_fd_sc_hd__clkbuf_1
XFILLER_0_101_647 VGND VGND VPWR VPWR sky130_fd_sc_hd__decap_8
X_9165_ clknet_leaf_103_CLK _0398_ VGND VGND VPWR VPWR RF.reg_arr\[9\]\[15\] sky130_fd_sc_hd__dfxtp_1
X_6377_ _3082_ net982 _3080_ VGND VGND VPWR VPWR _3083_ sky130_fd_sc_hd__mux2_1
X_8116_ net550 _3391_ _4030_ VGND VGND VPWR VPWR _4032_ sky130_fd_sc_hd__mux2_1
XFILLER_0_11_494 VGND VGND VPWR VPWR sky130_fd_sc_hd__decap_8
X_5328_ RF.reg_arr\[0\]\[9\] RF.reg_arr\[1\]\[9\] RF.reg_arr\[2\]\[9\] RF.reg_arr\[3\]\[9\]
+ _1675_ _1681_ VGND VGND VPWR VPWR _2117_ sky130_fd_sc_hd__mux4_1
X_9096_ clknet_leaf_90_CLK _0329_ VGND VGND VPWR VPWR RF.reg_arr\[2\]\[10\] sky130_fd_sc_hd__dfxtp_1
X_8047_ _3995_ VGND VGND VPWR VPWR _0543_ sky130_fd_sc_hd__clkbuf_1
X_5259_ _2047_ VGND VGND VPWR VPWR _2048_ sky130_fd_sc_hd__inv_2
X_8949_ clknet_leaf_17_CLK _0182_ VGND VGND VPWR VPWR RF.reg_arr\[29\]\[23\] sky130_fd_sc_hd__dfxtp_1
XFILLER_0_66_601 VGND VGND VPWR VPWR sky130_fd_sc_hd__decap_4
XFILLER_0_66_645 VGND VGND VPWR VPWR sky130_fd_sc_hd__decap_3
XFILLER_0_81_615 VGND VGND VPWR VPWR sky130_fd_sc_hd__fill_1
XFILLER_0_104_430 VGND VGND VPWR VPWR sky130_fd_sc_hd__fill_2
XFILLER_0_104_485 VGND VGND VPWR VPWR sky130_fd_sc_hd__decap_3
XFILLER_0_28_37 VGND VGND VPWR VPWR sky130_fd_sc_hd__fill_2
XFILLER_0_100_691 VGND VGND VPWR VPWR sky130_fd_sc_hd__fill_1
Xclkbuf_leaf_4_CLK clknet_3_0__leaf_CLK VGND VGND VPWR VPWR clknet_leaf_4_CLK sky130_fd_sc_hd__clkbuf_8
XTAP_TAPCELL_ROW_66_1048 VGND VPWR sky130_fd_sc_hd__tapvpwrvgnd_1
XFILLER_0_57_612 VGND VGND VPWR VPWR sky130_fd_sc_hd__decap_4
XFILLER_0_57_634 VGND VGND VPWR VPWR sky130_fd_sc_hd__fill_1
XTAP_TAPCELL_ROW_17_456 VGND VPWR sky130_fd_sc_hd__tapvpwrvgnd_1
XTAP_TAPCELL_ROW_45_787 VGND VPWR sky130_fd_sc_hd__tapvpwrvgnd_1
XFILLER_0_56_111 VGND VGND VPWR VPWR sky130_fd_sc_hd__fill_2
XFILLER_0_56_133 VGND VGND VPWR VPWR sky130_fd_sc_hd__fill_1
X_4630_ _1417_ _1418_ _1133_ VGND VGND VPWR VPWR _1419_ sky130_fd_sc_hd__mux2_1
XFILLER_0_60_68 VGND VGND VPWR VPWR sky130_fd_sc_hd__fill_1
XFILLER_0_114_3 VPWR VGND VPWR VGND sky130_ef_sc_hd__decap_12
XFILLER_0_25_520 VGND VGND VPWR VPWR sky130_fd_sc_hd__decap_3
XFILLER_0_37_380 VGND VGND VPWR VPWR sky130_fd_sc_hd__decap_3
X_4561_ RF.reg_arr\[20\]\[21\] RF.reg_arr\[21\]\[21\] RF.reg_arr\[22\]\[21\] RF.reg_arr\[23\]\[21\]
+ _1082_ _1084_ VGND VGND VPWR VPWR _1350_ sky130_fd_sc_hd__mux4_1
X_6300_ _3032_ VGND VGND VPWR VPWR _0783_ sky130_fd_sc_hd__clkbuf_1
X_7280_ _3113_ net405 _3580_ VGND VGND VPWR VPWR _3587_ sky130_fd_sc_hd__mux2_1
X_4492_ _1168_ VGND VGND VPWR VPWR _1281_ sky130_fd_sc_hd__buf_4
Xhold605 RF.reg_arr\[3\]\[30\] VGND VGND VPWR VPWR net687 sky130_fd_sc_hd__dlygate4sd3_1
XFILLER_0_69_55 VGND VGND VPWR VPWR sky130_fd_sc_hd__fill_1
XFILLER_0_12_236 VGND VGND VPWR VPWR sky130_fd_sc_hd__fill_1
Xhold616 RF.reg_arr\[16\]\[6\] VGND VGND VPWR VPWR net698 sky130_fd_sc_hd__dlygate4sd3_1
Xhold627 RF.reg_arr\[6\]\[4\] VGND VGND VPWR VPWR net709 sky130_fd_sc_hd__dlygate4sd3_1
X_6231_ net470 _2984_ _2978_ VGND VGND VPWR VPWR _2985_ sky130_fd_sc_hd__mux2_1
XTAP_TAPCELL_ROW_77_1177 VGND VPWR sky130_fd_sc_hd__tapvpwrvgnd_1
XFILLER_0_12_269 VGND VGND VPWR VPWR sky130_fd_sc_hd__fill_2
Xhold649 RF.reg_arr\[26\]\[10\] VGND VGND VPWR VPWR net731 sky130_fd_sc_hd__dlygate4sd3_1
Xhold638 RF.reg_arr\[7\]\[0\] VGND VGND VPWR VPWR net720 sky130_fd_sc_hd__dlygate4sd3_1
X_6162_ _2872_ _2892_ _2893_ _2902_ _2901_ VGND VGND VPWR VPWR _2923_ sky130_fd_sc_hd__a41o_1
XFILLER_0_110_466 VGND VGND VPWR VPWR sky130_fd_sc_hd__decap_6
XFILLER_0_100_96 VPWR VGND VPWR VGND sky130_ef_sc_hd__decap_12
XTAP_TAPCELL_ROW_90_1333 VGND VPWR sky130_fd_sc_hd__tapvpwrvgnd_1
XFILLER_0_110_477 VGND VGND VPWR VPWR sky130_fd_sc_hd__decap_8
X_5113_ _1898_ _1901_ _1845_ VGND VGND VPWR VPWR _1902_ sky130_fd_sc_hd__mux2_1
XFILLER_0_20_280 VGND VGND VPWR VPWR sky130_fd_sc_hd__decap_3
X_6093_ _2853_ _2857_ VGND VGND VPWR VPWR _2858_ sky130_fd_sc_hd__and2_1
X_5044_ _1649_ VGND VGND VPWR VPWR _1833_ sky130_fd_sc_hd__buf_2
X_8803_ clknet_leaf_73_CLK _0036_ VGND VGND VPWR VPWR RF.reg_arr\[4\]\[5\] sky130_fd_sc_hd__dfxtp_1
X_6995_ _3434_ VGND VGND VPWR VPWR _0052_ sky130_fd_sc_hd__clkbuf_1
X_5946_ _2616_ _2658_ _1738_ VGND VGND VPWR VPWR _2719_ sky130_fd_sc_hd__mux2_1
X_8734_ clknet_leaf_66_CLK _0991_ VGND VGND VPWR VPWR RF.reg_arr\[6\]\[0\] sky130_fd_sc_hd__dfxtp_1
XFILLER_0_48_634 VGND VGND VPWR VPWR sky130_fd_sc_hd__fill_1
X_8665_ clknet_leaf_49_CLK _0922_ VGND VGND VPWR VPWR RF.reg_arr\[8\]\[27\] sky130_fd_sc_hd__dfxtp_1
X_5877_ _2648_ _2653_ VGND VGND VPWR VPWR _2654_ sky130_fd_sc_hd__xnor2_1
X_7616_ _3766_ VGND VGND VPWR VPWR _0341_ sky130_fd_sc_hd__clkbuf_1
Xclone16 _1026_ VGND VGND VPWR VPWR net98 sky130_fd_sc_hd__clkbuf_16
X_4828_ _1616_ VGND VGND VPWR VPWR _1617_ sky130_fd_sc_hd__buf_4
X_8596_ clknet_leaf_62_CLK _0853_ VGND VGND VPWR VPWR RF.reg_arr\[0\]\[22\] sky130_fd_sc_hd__dfxtp_1
XFILLER_0_16_531 VGND VGND VPWR VPWR sky130_fd_sc_hd__fill_1
X_7547_ net509 _3435_ _3727_ VGND VGND VPWR VPWR _3730_ sky130_fd_sc_hd__mux2_1
X_4759_ _1542_ _1544_ _1547_ _1158_ _1159_ VGND VGND VPWR VPWR _1548_ sky130_fd_sc_hd__a221o_1
XFILLER_0_43_361 VGND VGND VPWR VPWR sky130_fd_sc_hd__decap_6
X_7478_ _3692_ VGND VGND VPWR VPWR _0277_ sky130_fd_sc_hd__clkbuf_1
XFILLER_0_43_383 VGND VGND VPWR VPWR sky130_fd_sc_hd__fill_1
X_6429_ _3117_ net824 _3101_ VGND VGND VPWR VPWR _3118_ sky130_fd_sc_hd__mux2_1
X_9217_ clknet_leaf_70_CLK _0450_ VGND VGND VPWR VPWR RF.reg_arr\[22\]\[3\] sky130_fd_sc_hd__dfxtp_1
X_9148_ clknet_leaf_21_CLK _0381_ VGND VGND VPWR VPWR RF.reg_arr\[30\]\[30\] sky130_fd_sc_hd__dfxtp_1
X_9079_ clknet_leaf_32_CLK _0312_ VGND VGND VPWR VPWR RF.reg_arr\[28\]\[25\] sky130_fd_sc_hd__dfxtp_1
XFILLER_0_39_634 VGND VGND VPWR VPWR sky130_fd_sc_hd__fill_1
XFILLER_0_109_511 VGND VGND VPWR VPWR sky130_fd_sc_hd__fill_2
XTAP_TAPCELL_ROW_14_415 VGND VPWR sky130_fd_sc_hd__tapvpwrvgnd_1
XTAP_TAPCELL_ROW_42_757 VGND VPWR sky130_fd_sc_hd__tapvpwrvgnd_1
XFILLER_0_54_615 VGND VGND VPWR VPWR sky130_fd_sc_hd__fill_2
Xclkbuf_3_7__f_CLK clknet_0_CLK VGND VGND VPWR VPWR clknet_3_7__leaf_CLK sky130_fd_sc_hd__clkbuf_16
XTAP_TAPCELL_ROW_113_1609 VGND VPWR sky130_fd_sc_hd__tapvpwrvgnd_1
XFILLER_0_22_578 VGND VGND VPWR VPWR sky130_fd_sc_hd__fill_2
XFILLER_0_22_589 VGND VGND VPWR VPWR sky130_fd_sc_hd__decap_6
XFILLER_0_55_24 VGND VGND VPWR VPWR sky130_fd_sc_hd__fill_2
XFILLER_0_55_35 VGND VGND VPWR VPWR sky130_fd_sc_hd__decap_3
XFILLER_0_89_578 VGND VGND VPWR VPWR sky130_fd_sc_hd__decap_8
X_5800_ _2574_ _2579_ VGND VGND VPWR VPWR _2581_ sky130_fd_sc_hd__nor2_1
XFILLER_0_71_45 VGND VGND VPWR VPWR sky130_fd_sc_hd__fill_2
X_6780_ _2972_ _2975_ _2973_ _2974_ VGND VGND VPWR VPWR _3305_ sky130_fd_sc_hd__or4bb_4
X_5731_ _1090_ _1736_ _1112_ _2420_ _2447_ VGND VGND VPWR VPWR _2515_ sky130_fd_sc_hd__a41o_1
X_8450_ net266 net38 _4173_ VGND VGND VPWR VPWR _4208_ sky130_fd_sc_hd__mux2_1
X_5662_ _1830_ _2448_ VGND VGND VPWR VPWR _2449_ sky130_fd_sc_hd__xnor2_1
X_5593_ _2380_ VGND VGND VPWR VPWR _2381_ sky130_fd_sc_hd__buf_2
X_8381_ _4171_ VGND VGND VPWR VPWR _0701_ sky130_fd_sc_hd__clkbuf_1
X_4613_ RF.reg_arr\[20\]\[7\] RF.reg_arr\[21\]\[7\] RF.reg_arr\[22\]\[7\] RF.reg_arr\[23\]\[7\]
+ _1186_ _1188_ VGND VGND VPWR VPWR _1402_ sky130_fd_sc_hd__mux4_1
X_7401_ _3098_ net1067 _3641_ VGND VGND VPWR VPWR _3651_ sky130_fd_sc_hd__mux2_1
XFILLER_0_102_208 VGND VGND VPWR VPWR sky130_fd_sc_hd__decap_6
X_4544_ _1163_ _1321_ _1326_ _1332_ VGND VGND VPWR VPWR _1333_ sky130_fd_sc_hd__a2bb2o_2
X_7332_ _3614_ VGND VGND VPWR VPWR _0209_ sky130_fd_sc_hd__clkbuf_1
Xhold402 RF.reg_arr\[8\]\[4\] VGND VGND VPWR VPWR net484 sky130_fd_sc_hd__dlygate4sd3_1
XFILLER_0_111_95 VGND VGND VPWR VPWR sky130_fd_sc_hd__fill_1
Xhold413 RF.reg_arr\[19\]\[11\] VGND VGND VPWR VPWR net495 sky130_fd_sc_hd__dlygate4sd3_1
XFILLER_0_4_288 VGND VGND VPWR VPWR sky130_fd_sc_hd__decap_4
X_7263_ _3096_ net652 _3569_ VGND VGND VPWR VPWR _3578_ sky130_fd_sc_hd__mux2_1
Xhold435 RF.reg_arr\[6\]\[16\] VGND VGND VPWR VPWR net517 sky130_fd_sc_hd__dlygate4sd3_1
Xhold424 RF.reg_arr\[24\]\[13\] VGND VGND VPWR VPWR net506 sky130_fd_sc_hd__dlygate4sd3_1
Xhold457 RF.reg_arr\[22\]\[24\] VGND VGND VPWR VPWR net539 sky130_fd_sc_hd__dlygate4sd3_1
Xhold468 RF.reg_arr\[18\]\[1\] VGND VGND VPWR VPWR net550 sky130_fd_sc_hd__dlygate4sd3_1
X_6214_ net9 net10 VGND VGND VPWR VPWR _2971_ sky130_fd_sc_hd__or2b_2
X_9002_ clknet_leaf_99_CLK _0235_ VGND VGND VPWR VPWR RF.reg_arr\[27\]\[12\] sky130_fd_sc_hd__dfxtp_1
Xhold446 RF.reg_arr\[5\]\[0\] VGND VGND VPWR VPWR net528 sky130_fd_sc_hd__dlygate4sd3_1
X_4475_ _1041_ _1263_ VGND VGND VPWR VPWR _1264_ sky130_fd_sc_hd__or2_1
Xhold479 RF.reg_arr\[23\]\[0\] VGND VGND VPWR VPWR net561 sky130_fd_sc_hd__dlygate4sd3_1
X_7194_ net562 _3426_ _3532_ VGND VGND VPWR VPWR _3541_ sky130_fd_sc_hd__mux2_1
X_6145_ _2355_ _2357_ VGND VGND VPWR VPWR _2907_ sky130_fd_sc_hd__nor2_1
X_6076_ _2381_ _2841_ _2716_ _2562_ VGND VGND VPWR VPWR _2842_ sky130_fd_sc_hd__a2bb2o_1
X_5027_ _1077_ _1815_ VGND VGND VPWR VPWR _1816_ sky130_fd_sc_hd__nand2_1
XFILLER_0_95_537 VPWR VGND VPWR VGND sky130_ef_sc_hd__decap_12
X_8717_ clknet_leaf_104_CLK _0974_ VGND VGND VPWR VPWR RF.reg_arr\[14\]\[15\] sky130_fd_sc_hd__dfxtp_1
X_6978_ net457 _3422_ _3410_ VGND VGND VPWR VPWR _3423_ sky130_fd_sc_hd__mux2_1
X_5929_ _2701_ _2696_ _2702_ VGND VGND VPWR VPWR _2703_ sky130_fd_sc_hd__a21bo_1
XFILLER_0_0_81 VGND VGND VPWR VPWR sky130_fd_sc_hd__decap_3
XFILLER_0_106_514 VGND VGND VPWR VPWR sky130_fd_sc_hd__decap_4
XFILLER_0_8_550 VGND VGND VPWR VPWR sky130_fd_sc_hd__fill_1
X_8648_ clknet_leaf_12_CLK _0905_ VGND VGND VPWR VPWR RF.reg_arr\[8\]\[10\] sky130_fd_sc_hd__dfxtp_1
XFILLER_0_106_558 VGND VGND VPWR VPWR sky130_fd_sc_hd__fill_1
XFILLER_0_90_275 VGND VGND VPWR VPWR sky130_fd_sc_hd__fill_1
XFILLER_0_90_253 VGND VGND VPWR VPWR sky130_fd_sc_hd__fill_1
X_8579_ clknet_leaf_80_CLK _0836_ VGND VGND VPWR VPWR RF.reg_arr\[0\]\[5\] sky130_fd_sc_hd__dfxtp_1
XFILLER_0_35_169 VGND VGND VPWR VPWR sky130_fd_sc_hd__decap_6
Xhold991 RF.reg_arr\[24\]\[30\] VGND VGND VPWR VPWR net1073 sky130_fd_sc_hd__dlygate4sd3_1
XFILLER_0_8_3 VPWR VGND VPWR VGND sky130_ef_sc_hd__decap_12
Xhold980 RF.reg_arr\[26\]\[8\] VGND VGND VPWR VPWR net1062 sky130_fd_sc_hd__dlygate4sd3_1
XFILLER_0_31_397 VGND VGND VPWR VPWR sky130_fd_sc_hd__fill_1
XFILLER_0_116_29 VPWR VGND VPWR VGND sky130_ef_sc_hd__decap_12
XTAP_TAPCELL_ROW_47_816 VGND VPWR sky130_fd_sc_hd__tapvpwrvgnd_1
XTAP_TAPCELL_ROW_63_1007 VGND VPWR sky130_fd_sc_hd__tapvpwrvgnd_1
XFILLER_0_39_420 VGND VGND VPWR VPWR sky130_fd_sc_hd__fill_1
XTAP_TAPCELL_ROW_27_573 VGND VPWR sky130_fd_sc_hd__tapvpwrvgnd_1
XFILLER_0_41_15 VPWR VGND VPWR VGND sky130_ef_sc_hd__decap_12
XFILLER_0_26_114 VGND VGND VPWR VPWR sky130_fd_sc_hd__fill_1
XFILLER_0_26_136 VGND VGND VPWR VPWR sky130_fd_sc_hd__decap_4
XFILLER_0_81_253 VPWR VGND VPWR VGND sky130_ef_sc_hd__decap_12
XFILLER_0_14_309 VGND VGND VPWR VPWR sky130_fd_sc_hd__decap_6
XFILLER_0_42_618 VGND VGND VPWR VPWR sky130_fd_sc_hd__decap_3
XFILLER_0_112_506 VGND VGND VPWR VPWR sky130_fd_sc_hd__decap_3
XFILLER_0_35_681 VGND VGND VPWR VPWR sky130_fd_sc_hd__fill_1
XFILLER_0_112_539 VPWR VGND VPWR VGND sky130_ef_sc_hd__decap_12
XFILLER_0_1_225 VGND VGND VPWR VPWR sky130_fd_sc_hd__fill_2
XFILLER_0_22_342 VGND VGND VPWR VPWR sky130_fd_sc_hd__fill_1
XTAP_TAPCELL_ROW_74_1136 VGND VPWR sky130_fd_sc_hd__tapvpwrvgnd_1
XFILLER_0_10_526 VGND VGND VPWR VPWR sky130_fd_sc_hd__decap_3
XFILLER_0_5_15 VPWR VGND VPWR VGND sky130_ef_sc_hd__decap_12
X_4260_ net6 VGND VGND VPWR VPWR _1049_ sky130_fd_sc_hd__buf_4
XFILLER_0_89_320 VGND VGND VPWR VPWR sky130_fd_sc_hd__fill_1
X_7950_ _3943_ VGND VGND VPWR VPWR _0498_ sky130_fd_sc_hd__clkbuf_1
X_6901_ _3370_ VGND VGND VPWR VPWR _0022_ sky130_fd_sc_hd__clkbuf_1
XFILLER_0_82_66 VGND VGND VPWR VPWR sky130_fd_sc_hd__fill_1
X_7881_ _3098_ net1118 _3897_ VGND VGND VPWR VPWR _3907_ sky130_fd_sc_hd__mux2_1
X_6832_ _3333_ VGND VGND VPWR VPWR _1014_ sky130_fd_sc_hd__clkbuf_1
XTAP_TAPCELL_ROW_85_1276 VGND VPWR sky130_fd_sc_hd__tapvpwrvgnd_1
XFILLER_0_77_559 VGND VGND VPWR VPWR sky130_fd_sc_hd__fill_1
XFILLER_0_15_82 VGND VGND VPWR VPWR sky130_fd_sc_hd__fill_1
X_6763_ _3296_ VGND VGND VPWR VPWR _0982_ sky130_fd_sc_hd__clkbuf_1
XFILLER_0_9_358 VGND VGND VPWR VPWR sky130_fd_sc_hd__fill_1
X_6694_ _3109_ net1049 _3254_ VGND VGND VPWR VPWR _3259_ sky130_fd_sc_hd__mux2_1
X_8502_ clknet_leaf_36_CLK _0759_ VGND VGND VPWR VPWR RF.reg_arr\[10\]\[24\] sky130_fd_sc_hd__dfxtp_1
X_5714_ _2216_ _2498_ VGND VGND VPWR VPWR _2499_ sky130_fd_sc_hd__nor2_1
X_9482_ clknet_leaf_96_CLK _0715_ VGND VGND VPWR VPWR RF.reg_arr\[11\]\[12\] sky130_fd_sc_hd__dfxtp_1
X_5645_ _2418_ _2422_ _2431_ VGND VGND VPWR VPWR _2432_ sky130_fd_sc_hd__or3_1
XFILLER_0_72_242 VGND VGND VPWR VPWR sky130_fd_sc_hd__decap_8
X_8433_ _4199_ VGND VGND VPWR VPWR _0725_ sky130_fd_sc_hd__clkbuf_1
XFILLER_0_86_3 VGND VGND VPWR VPWR sky130_fd_sc_hd__fill_1
XFILLER_0_32_139 VGND VGND VPWR VPWR sky130_fd_sc_hd__fill_1
X_5576_ _1792_ _1869_ VGND VGND VPWR VPWR _2364_ sky130_fd_sc_hd__nand2_1
X_8364_ _3044_ net842 _4160_ VGND VGND VPWR VPWR _4163_ sky130_fd_sc_hd__mux2_1
Xhold210 RF.reg_arr\[18\]\[7\] VGND VGND VPWR VPWR net292 sky130_fd_sc_hd__dlygate4sd3_1
X_4527_ _1175_ VGND VGND VPWR VPWR _1316_ sky130_fd_sc_hd__buf_6
Xhold243 RF.reg_arr\[10\]\[31\] VGND VGND VPWR VPWR net325 sky130_fd_sc_hd__dlygate4sd3_1
X_8295_ _4126_ VGND VGND VPWR VPWR _0660_ sky130_fd_sc_hd__clkbuf_1
Xhold221 RF.reg_arr\[9\]\[21\] VGND VGND VPWR VPWR net303 sky130_fd_sc_hd__dlygate4sd3_1
Xhold232 RF.reg_arr\[1\]\[6\] VGND VGND VPWR VPWR net314 sky130_fd_sc_hd__dlygate4sd3_1
X_7315_ _3079_ net988 _3605_ VGND VGND VPWR VPWR _3606_ sky130_fd_sc_hd__mux2_1
Xhold265 RF.reg_arr\[11\]\[24\] VGND VGND VPWR VPWR net347 sky130_fd_sc_hd__dlygate4sd3_1
Xhold287 RF.reg_arr\[31\]\[23\] VGND VGND VPWR VPWR net369 sky130_fd_sc_hd__dlygate4sd3_1
Xhold254 RF.reg_arr\[4\]\[22\] VGND VGND VPWR VPWR net336 sky130_fd_sc_hd__dlygate4sd3_1
Xhold276 RF.reg_arr\[3\]\[6\] VGND VGND VPWR VPWR net358 sky130_fd_sc_hd__dlygate4sd3_1
XFILLER_0_40_194 VGND VGND VPWR VPWR sky130_fd_sc_hd__fill_2
X_4458_ RF.reg_arr\[8\]\[10\] RF.reg_arr\[9\]\[10\] RF.reg_arr\[10\]\[10\] RF.reg_arr\[11\]\[10\]
+ _1027_ _1029_ VGND VGND VPWR VPWR _1247_ sky130_fd_sc_hd__mux4_1
X_7246_ _3557_ VGND VGND VPWR VPWR _3569_ sky130_fd_sc_hd__clkbuf_8
Xhold298 RF.reg_arr\[25\]\[1\] VGND VGND VPWR VPWR net380 sky130_fd_sc_hd__dlygate4sd3_1
X_7177_ _3520_ VGND VGND VPWR VPWR _3532_ sky130_fd_sc_hd__clkbuf_8
X_6128_ _1753_ _2889_ VGND VGND VPWR VPWR _2891_ sky130_fd_sc_hd__and2_1
X_4389_ _1168_ _1177_ VGND VGND VPWR VPWR _1178_ sky130_fd_sc_hd__or2_1
X_6059_ _2418_ _2528_ _2825_ VGND VGND VPWR VPWR _2826_ sky130_fd_sc_hd__o21ai_1
XTAP_TAPCELL_ROW_24_543 VGND VPWR sky130_fd_sc_hd__tapvpwrvgnd_1
XFILLER_0_36_401 VGND VGND VPWR VPWR sky130_fd_sc_hd__fill_2
XTAP_TAPCELL_ROW_52_874 VGND VPWR sky130_fd_sc_hd__tapvpwrvgnd_1
XFILLER_0_17_681 VGND VGND VPWR VPWR sky130_fd_sc_hd__fill_1
XFILLER_0_102_572 VGND VGND VPWR VPWR sky130_fd_sc_hd__decap_8
XFILLER_0_99_673 VGND VGND VPWR VPWR sky130_fd_sc_hd__decap_4
XFILLER_0_59_548 VGND VGND VPWR VPWR sky130_fd_sc_hd__decap_4
XFILLER_0_74_518 VGND VGND VPWR VPWR sky130_fd_sc_hd__fill_2
XFILLER_0_27_423 VGND VGND VPWR VPWR sky130_fd_sc_hd__fill_1
XFILLER_0_54_253 VGND VGND VPWR VPWR sky130_fd_sc_hd__fill_2
XFILLER_0_14_128 VGND VGND VPWR VPWR sky130_fd_sc_hd__decap_4
X_5430_ RF.reg_arr\[20\]\[5\] RF.reg_arr\[21\]\[5\] RF.reg_arr\[22\]\[5\] RF.reg_arr\[23\]\[5\]
+ _1589_ _1834_ VGND VGND VPWR VPWR _2219_ sky130_fd_sc_hd__mux4_1
XFILLER_0_42_415 VGND VGND VPWR VPWR sky130_fd_sc_hd__decap_4
XFILLER_0_42_448 VPWR VGND VPWR VGND sky130_ef_sc_hd__decap_12
XFILLER_0_23_673 VGND VGND VPWR VPWR sky130_fd_sc_hd__decap_3
X_5361_ _1942_ _2149_ VGND VGND VPWR VPWR _2150_ sky130_fd_sc_hd__or2_1
XFILLER_0_2_567 VGND VGND VPWR VPWR sky130_fd_sc_hd__decap_4
XFILLER_0_2_589 VPWR VGND VPWR VGND sky130_ef_sc_hd__decap_12
X_7100_ _3491_ VGND VGND VPWR VPWR _0100_ sky130_fd_sc_hd__clkbuf_1
X_4312_ RF.reg_arr\[12\]\[0\] RF.reg_arr\[13\]\[0\] RF.reg_arr\[14\]\[0\] RF.reg_arr\[15\]\[0\]
+ net1126 _1069_ VGND VGND VPWR VPWR _1101_ sky130_fd_sc_hd__mux4_1
X_8080_ _4012_ VGND VGND VPWR VPWR _0559_ sky130_fd_sc_hd__clkbuf_1
X_5292_ _2079_ _2080_ _1612_ VGND VGND VPWR VPWR _2081_ sky130_fd_sc_hd__mux2_1
XFILLER_0_58_7 VGND VGND VPWR VPWR sky130_fd_sc_hd__fill_2
X_7031_ net217 _3399_ _3449_ VGND VGND VPWR VPWR _3455_ sky130_fd_sc_hd__mux2_1
X_4243_ net6 VGND VGND VPWR VPWR _1032_ sky130_fd_sc_hd__inv_2
X_8982_ clknet_leaf_51_CLK _0215_ VGND VGND VPWR VPWR RF.reg_arr\[31\]\[24\] sky130_fd_sc_hd__dfxtp_1
X_7933_ _3021_ net326 _3933_ VGND VGND VPWR VPWR _3935_ sky130_fd_sc_hd__mux2_1
X_7864_ _3898_ VGND VGND VPWR VPWR _0457_ sky130_fd_sc_hd__clkbuf_1
X_6815_ _3324_ VGND VGND VPWR VPWR _1006_ sky130_fd_sc_hd__clkbuf_1
X_7795_ _3861_ VGND VGND VPWR VPWR _0425_ sky130_fd_sc_hd__clkbuf_1
X_6746_ _3287_ VGND VGND VPWR VPWR _0974_ sky130_fd_sc_hd__clkbuf_1
XTAP_TAPCELL_ROW_21_502 VGND VPWR sky130_fd_sc_hd__tapvpwrvgnd_1
XFILLER_0_73_573 VGND VGND VPWR VPWR sky130_fd_sc_hd__decap_3
XFILLER_0_115_141 VGND VGND VPWR VPWR sky130_fd_sc_hd__decap_3
X_9465_ clknet_leaf_50_CLK _0698_ VGND VGND VPWR VPWR RF.reg_arr\[12\]\[27\] sky130_fd_sc_hd__dfxtp_1
XTAP_TAPCELL_ROW_98_1423 VGND VPWR sky130_fd_sc_hd__tapvpwrvgnd_1
XFILLER_0_73_595 VGND VGND VPWR VPWR sky130_fd_sc_hd__decap_3
X_6677_ _3092_ net897 _3243_ VGND VGND VPWR VPWR _3250_ sky130_fd_sc_hd__mux2_1
X_5628_ _2382_ _2386_ _2415_ _1024_ VGND VGND VPWR VPWR _2416_ sky130_fd_sc_hd__o211a_1
X_9396_ clknet_leaf_42_CLK _0629_ VGND VGND VPWR VPWR RF.reg_arr\[13\]\[22\] sky130_fd_sc_hd__dfxtp_1
XFILLER_0_14_640 VGND VGND VPWR VPWR sky130_fd_sc_hd__decap_4
X_8416_ _4190_ VGND VGND VPWR VPWR _0717_ sky130_fd_sc_hd__clkbuf_1
XFILLER_0_115_185 VGND VGND VPWR VPWR sky130_fd_sc_hd__fill_2
X_5559_ _2337_ _2346_ VGND VGND VPWR VPWR _2347_ sky130_fd_sc_hd__xnor2_1
X_8347_ _3027_ net1100 _4149_ VGND VGND VPWR VPWR _4154_ sky130_fd_sc_hd__mux2_1
X_8278_ _4117_ VGND VGND VPWR VPWR _0652_ sky130_fd_sc_hd__clkbuf_1
XFILLER_0_111_391 VGND VGND VPWR VPWR sky130_fd_sc_hd__fill_1
X_7229_ _3560_ VGND VGND VPWR VPWR _0160_ sky130_fd_sc_hd__clkbuf_1
XTAP_TAPCELL_ROW_29_602 VGND VPWR sky130_fd_sc_hd__tapvpwrvgnd_1
XTAP_TAPCELL_ROW_57_933 VGND VPWR sky130_fd_sc_hd__tapvpwrvgnd_1
XTAP_TAPCELL_ROW_107_1541 VGND VPWR sky130_fd_sc_hd__tapvpwrvgnd_1
XTAP_TAPCELL_ROW_107_1530 VGND VPWR sky130_fd_sc_hd__tapvpwrvgnd_1
XTAP_TAPCELL_ROW_1_260 VGND VPWR sky130_fd_sc_hd__tapvpwrvgnd_1
XPHY_EDGE_ROW_1_Left_118 VGND VGND VPWR VPWR sky130_fd_sc_hd__decap_3
XTAP_TAPCELL_ROW_37_690 VGND VPWR sky130_fd_sc_hd__tapvpwrvgnd_1
XFILLER_0_83_337 VGND VGND VPWR VPWR sky130_fd_sc_hd__decap_4
XFILLER_0_106_141 VPWR VGND VPWR VGND sky130_ef_sc_hd__decap_12
XFILLER_0_36_297 VGND VGND VPWR VPWR sky130_fd_sc_hd__decap_8
XFILLER_0_106_174 VPWR VGND VPWR VGND sky130_ef_sc_hd__decap_12
Xclkbuf_0_CLK CLK VGND VGND VPWR VPWR clknet_0_CLK sky130_fd_sc_hd__clkbuf_16
XTAP_TAPCELL_ROW_71_1106 VGND VPWR sky130_fd_sc_hd__tapvpwrvgnd_1
XTAP_TAPCELL_ROW_9_360 VGND VPWR sky130_fd_sc_hd__tapvpwrvgnd_1
XFILLER_0_63_13 VGND VGND VPWR VPWR sky130_fd_sc_hd__fill_2
XFILLER_0_2_27 VGND VGND VPWR VPWR sky130_fd_sc_hd__fill_1
XTAP_TAPCELL_ROW_69_1079 VGND VPWR sky130_fd_sc_hd__tapvpwrvgnd_1
X_4930_ _1698_ _1718_ VGND VGND VPWR VPWR _1719_ sky130_fd_sc_hd__nand2_1
XFILLER_0_63_68 VGND VGND VPWR VPWR sky130_fd_sc_hd__fill_1
XFILLER_0_59_334 VGND VGND VPWR VPWR sky130_fd_sc_hd__fill_2
XFILLER_0_86_175 VGND VGND VPWR VPWR sky130_fd_sc_hd__decap_4
XTAP_TAPCELL_ROW_82_1235 VGND VPWR sky130_fd_sc_hd__tapvpwrvgnd_1
X_4861_ RF.reg_arr\[20\]\[30\] RF.reg_arr\[21\]\[30\] RF.reg_arr\[22\]\[30\] RF.reg_arr\[23\]\[30\]
+ _1627_ _1629_ VGND VGND VPWR VPWR _1650_ sky130_fd_sc_hd__mux4_1
XFILLER_0_7_615 VGND VGND VPWR VPWR sky130_fd_sc_hd__fill_1
X_6600_ _3209_ VGND VGND VPWR VPWR _0906_ sky130_fd_sc_hd__clkbuf_1
X_4792_ _1564_ _1580_ VGND VGND VPWR VPWR _1581_ sky130_fd_sc_hd__nor2_2
XANTENNA_16 _2103_ VGND VGND VPWR VPWR sky130_fd_sc_hd__diode_2
X_7580_ _3747_ VGND VGND VPWR VPWR _0324_ sky130_fd_sc_hd__clkbuf_1
XANTENNA_27 _1159_ VGND VGND VPWR VPWR sky130_fd_sc_hd__diode_2
XFILLER_0_27_264 VGND VGND VPWR VPWR sky130_fd_sc_hd__fill_1
X_6531_ net849 _3021_ _3171_ VGND VGND VPWR VPWR _3173_ sky130_fd_sc_hd__mux2_1
XFILLER_0_12_83 VGND VGND VPWR VPWR sky130_fd_sc_hd__fill_1
X_9250_ clknet_leaf_76_CLK _0483_ VGND VGND VPWR VPWR RF.reg_arr\[21\]\[4\] sky130_fd_sc_hd__dfxtp_1
X_6462_ net126 VGND VGND VPWR VPWR _3136_ sky130_fd_sc_hd__clkbuf_1
X_9181_ clknet_leaf_26_CLK _0414_ VGND VGND VPWR VPWR RF.reg_arr\[9\]\[31\] sky130_fd_sc_hd__dfxtp_1
XFILLER_0_70_565 VGND VGND VPWR VPWR sky130_fd_sc_hd__fill_1
X_5413_ RF.reg_arr\[16\]\[4\] RF.reg_arr\[17\]\[4\] RF.reg_arr\[18\]\[4\] RF.reg_arr\[19\]\[4\]
+ _2030_ _1858_ VGND VGND VPWR VPWR _2202_ sky130_fd_sc_hd__mux4_1
X_8201_ _4076_ VGND VGND VPWR VPWR _0616_ sky130_fd_sc_hd__clkbuf_1
X_6393_ _3093_ VGND VGND VPWR VPWR _0815_ sky130_fd_sc_hd__clkbuf_1
X_8132_ net239 _3407_ _4030_ VGND VGND VPWR VPWR _4040_ sky130_fd_sc_hd__mux2_1
X_5344_ _1604_ _2132_ VGND VGND VPWR VPWR _2133_ sky130_fd_sc_hd__or2_1
XTAP_TAPCELL_ROW_93_1364 VGND VPWR sky130_fd_sc_hd__tapvpwrvgnd_1
X_8063_ _4003_ VGND VGND VPWR VPWR _0551_ sky130_fd_sc_hd__clkbuf_1
X_5275_ RF.reg_arr\[0\]\[10\] RF.reg_arr\[1\]\[10\] RF.reg_arr\[2\]\[10\] RF.reg_arr\[3\]\[10\]
+ _1857_ _1860_ VGND VGND VPWR VPWR _2064_ sky130_fd_sc_hd__mux4_1
X_7014_ net574 _3383_ _3388_ VGND VGND VPWR VPWR _3445_ sky130_fd_sc_hd__mux2_1
XFILLER_0_10_197 VPWR VGND VPWR VGND sky130_ef_sc_hd__decap_12
XFILLER_0_97_418 VGND VGND VPWR VPWR sky130_fd_sc_hd__decap_8
X_8965_ clknet_leaf_99_CLK _0198_ VGND VGND VPWR VPWR RF.reg_arr\[31\]\[7\] sky130_fd_sc_hd__dfxtp_1
XTAP_TAPCELL_ROW_54_903 VGND VPWR sky130_fd_sc_hd__tapvpwrvgnd_1
XFILLER_0_78_643 VGND VGND VPWR VPWR sky130_fd_sc_hd__fill_1
X_8896_ clknet_leaf_60_CLK _0129_ VGND VGND VPWR VPWR RF.reg_arr\[7\]\[2\] sky130_fd_sc_hd__dfxtp_1
X_7916_ _3004_ net1035 _3922_ VGND VGND VPWR VPWR _3926_ sky130_fd_sc_hd__mux2_1
XFILLER_0_77_164 VGND VGND VPWR VPWR sky130_fd_sc_hd__decap_4
X_7847_ _3889_ VGND VGND VPWR VPWR _0449_ sky130_fd_sc_hd__clkbuf_1
XFILLER_0_93_635 VGND VGND VPWR VPWR sky130_fd_sc_hd__fill_1
XFILLER_0_65_337 VGND VGND VPWR VPWR sky130_fd_sc_hd__fill_2
XTAP_TAPCELL_ROW_34_660 VGND VPWR sky130_fd_sc_hd__tapvpwrvgnd_1
XTAP_TAPCELL_ROW_102_1471 VGND VPWR sky130_fd_sc_hd__tapvpwrvgnd_1
XFILLER_0_93_668 VGND VGND VPWR VPWR sky130_fd_sc_hd__decap_4
XTAP_TAPCELL_ROW_62_991 VGND VPWR sky130_fd_sc_hd__tapvpwrvgnd_1
X_7778_ _3852_ VGND VGND VPWR VPWR _0417_ sky130_fd_sc_hd__clkbuf_1
XFILLER_0_61_521 VGND VGND VPWR VPWR sky130_fd_sc_hd__fill_1
X_6729_ _3278_ VGND VGND VPWR VPWR _0966_ sky130_fd_sc_hd__clkbuf_1
X_9517_ clknet_leaf_103_CLK _0750_ VGND VGND VPWR VPWR RF.reg_arr\[10\]\[15\] sky130_fd_sc_hd__dfxtp_1
X_9448_ clknet_leaf_11_CLK _0681_ VGND VGND VPWR VPWR RF.reg_arr\[12\]\[10\] sky130_fd_sc_hd__dfxtp_1
XFILLER_0_61_576 VGND VGND VPWR VPWR sky130_fd_sc_hd__decap_4
X_9379_ clknet_leaf_79_CLK _0612_ VGND VGND VPWR VPWR RF.reg_arr\[13\]\[5\] sky130_fd_sc_hd__dfxtp_1
XFILLER_0_68_197 VGND VGND VPWR VPWR sky130_fd_sc_hd__fill_1
XFILLER_0_37_551 VGND VGND VPWR VPWR sky130_fd_sc_hd__decap_8
XFILLER_0_37_584 VGND VGND VPWR VPWR sky130_fd_sc_hd__fill_2
XFILLER_0_37_595 VGND VGND VPWR VPWR sky130_fd_sc_hd__decap_4
XFILLER_0_52_510 VGND VGND VPWR VPWR sky130_fd_sc_hd__decap_3
XFILLER_0_92_690 VGND VGND VPWR VPWR sky130_fd_sc_hd__fill_2
Xinput25 WD3[1] VGND VGND VPWR VPWR net25 sky130_fd_sc_hd__buf_1
Xinput36 WD3[2] VGND VGND VPWR VPWR net36 sky130_fd_sc_hd__buf_1
Xinput14 WD3[0] VGND VGND VPWR VPWR net14 sky130_fd_sc_hd__buf_1
Xhold809 RF.reg_arr\[21\]\[21\] VGND VGND VPWR VPWR net891 sky130_fd_sc_hd__dlygate4sd3_1
Xinput47 opcode[0] VGND VGND VPWR VPWR net47 sky130_fd_sc_hd__clkbuf_2
XTAP_TAPCELL_ROW_12_398 VGND VPWR sky130_fd_sc_hd__tapvpwrvgnd_1
XFILLER_0_110_626 VGND VGND VPWR VPWR sky130_fd_sc_hd__fill_1
X_5060_ _1594_ VGND VGND VPWR VPWR _1849_ sky130_fd_sc_hd__clkbuf_4
X_5962_ _2157_ _2699_ _2734_ VGND VGND VPWR VPWR _2735_ sky130_fd_sc_hd__o21a_1
X_8750_ clknet_leaf_9_CLK _1007_ VGND VGND VPWR VPWR RF.reg_arr\[6\]\[16\] sky130_fd_sc_hd__dfxtp_1
X_4913_ RF.reg_arr\[28\]\[28\] RF.reg_arr\[29\]\[28\] RF.reg_arr\[30\]\[28\] RF.reg_arr\[31\]\[28\]
+ _1592_ _1599_ VGND VGND VPWR VPWR _1702_ sky130_fd_sc_hd__mux4_1
XFILLER_0_75_613 VGND VGND VPWR VPWR sky130_fd_sc_hd__decap_3
X_7701_ _3123_ net1089 _3776_ VGND VGND VPWR VPWR _3811_ sky130_fd_sc_hd__mux2_1
XFILLER_0_87_495 VGND VGND VPWR VPWR sky130_fd_sc_hd__fill_2
X_5893_ _1272_ _1507_ VGND VGND VPWR VPWR _2669_ sky130_fd_sc_hd__nand2_1
X_8681_ clknet_leaf_13_CLK _0938_ VGND VGND VPWR VPWR RF.reg_arr\[15\]\[11\] sky130_fd_sc_hd__dfxtp_1
XFILLER_0_114_73 VGND VGND VPWR VPWR sky130_fd_sc_hd__fill_1
XFILLER_0_90_99 VPWR VGND VPWR VGND sky130_ef_sc_hd__decap_12
X_4844_ _1619_ _1632_ VGND VGND VPWR VPWR _1633_ sky130_fd_sc_hd__nor2_1
X_7632_ _3774_ VGND VGND VPWR VPWR _0349_ sky130_fd_sc_hd__clkbuf_1
XFILLER_0_7_401 VPWR VGND VPWR VGND sky130_ef_sc_hd__decap_12
X_4775_ _1272_ _1555_ _1559_ _1563_ VGND VGND VPWR VPWR _1564_ sky130_fd_sc_hd__a22o_4
X_7563_ net1059 _3383_ _3704_ VGND VGND VPWR VPWR _3738_ sky130_fd_sc_hd__mux2_1
X_9302_ clknet_leaf_51_CLK _0535_ VGND VGND VPWR VPWR RF.reg_arr\[25\]\[24\] sky130_fd_sc_hd__dfxtp_1
XFILLER_0_15_223 VGND VGND VPWR VPWR sky130_fd_sc_hd__fill_1
X_6514_ net235 _3004_ _3160_ VGND VGND VPWR VPWR _3164_ sky130_fd_sc_hd__mux2_1
X_7494_ _3700_ VGND VGND VPWR VPWR _0285_ sky130_fd_sc_hd__clkbuf_1
X_9233_ clknet_leaf_4_CLK _0466_ VGND VGND VPWR VPWR RF.reg_arr\[22\]\[19\] sky130_fd_sc_hd__dfxtp_1
X_6445_ _3127_ VGND VGND VPWR VPWR _0833_ sky130_fd_sc_hd__clkbuf_1
XFILLER_0_3_673 VPWR VGND VPWR VGND sky130_ef_sc_hd__decap_12
XFILLER_0_100_114 VGND VGND VPWR VPWR sky130_fd_sc_hd__fill_1
XFILLER_0_2_183 VGND VGND VPWR VPWR sky130_fd_sc_hd__fill_2
X_9164_ clknet_leaf_102_CLK _0397_ VGND VGND VPWR VPWR RF.reg_arr\[9\]\[14\] sky130_fd_sc_hd__dfxtp_1
X_6376_ net16 VGND VGND VPWR VPWR _3082_ sky130_fd_sc_hd__clkbuf_2
X_8115_ _4031_ VGND VGND VPWR VPWR _0575_ sky130_fd_sc_hd__clkbuf_1
X_5327_ RF.reg_arr\[4\]\[9\] RF.reg_arr\[5\]\[9\] RF.reg_arr\[6\]\[9\] RF.reg_arr\[7\]\[9\]
+ _1675_ _1681_ VGND VGND VPWR VPWR _2116_ sky130_fd_sc_hd__mux4_1
X_9095_ clknet_leaf_90_CLK _0328_ VGND VGND VPWR VPWR RF.reg_arr\[2\]\[9\] sky130_fd_sc_hd__dfxtp_1
X_8046_ _2994_ net1060 _3994_ VGND VGND VPWR VPWR _3995_ sky130_fd_sc_hd__mux2_1
X_5258_ _2029_ _2046_ VGND VGND VPWR VPWR _2047_ sky130_fd_sc_hd__nor2_1
X_5189_ _1976_ _1977_ _1865_ VGND VGND VPWR VPWR _1978_ sky130_fd_sc_hd__mux2_1
XTAP_TAPCELL_ROW_104_1500 VGND VPWR sky130_fd_sc_hd__tapvpwrvgnd_1
XFILLER_0_97_259 VGND VGND VPWR VPWR sky130_fd_sc_hd__fill_1
X_8948_ clknet_leaf_62_CLK _0181_ VGND VGND VPWR VPWR RF.reg_arr\[29\]\[22\] sky130_fd_sc_hd__dfxtp_1
X_8879_ clknet_leaf_1_CLK _0112_ VGND VGND VPWR VPWR RF.reg_arr\[3\]\[17\] sky130_fd_sc_hd__dfxtp_1
Xwire82 _1945_ VGND VGND VPWR VPWR net82 sky130_fd_sc_hd__buf_4
XFILLER_0_108_214 VGND VGND VPWR VPWR sky130_fd_sc_hd__fill_1
XFILLER_0_65_145 VGND VGND VPWR VPWR sky130_fd_sc_hd__fill_1
XPHY_EDGE_ROW_91_Left_208 VGND VGND VPWR VPWR sky130_fd_sc_hd__decap_3
XFILLER_0_65_178 VGND VGND VPWR VPWR sky130_fd_sc_hd__fill_2
XFILLER_0_34_587 VGND VGND VPWR VPWR sky130_fd_sc_hd__fill_1
XFILLER_0_104_453 VGND VGND VPWR VPWR sky130_fd_sc_hd__decap_8
XFILLER_0_61_373 VGND VGND VPWR VPWR sky130_fd_sc_hd__decap_3
XFILLER_0_0_109 VGND VGND VPWR VPWR sky130_fd_sc_hd__decap_3
XFILLER_0_104_475 VGND VGND VPWR VPWR sky130_fd_sc_hd__fill_1
XFILLER_0_44_15 VGND VGND VPWR VPWR sky130_fd_sc_hd__fill_2
XFILLER_0_44_26 VGND VGND VPWR VPWR sky130_fd_sc_hd__fill_2
XFILLER_0_88_248 VGND VGND VPWR VPWR sky130_fd_sc_hd__decap_4
XFILLER_0_44_37 VGND VGND VPWR VPWR sky130_fd_sc_hd__decap_4
XTAP_TAPCELL_ROW_66_1049 VGND VPWR sky130_fd_sc_hd__tapvpwrvgnd_1
XTAP_TAPCELL_ROW_66_1038 VGND VPWR sky130_fd_sc_hd__tapvpwrvgnd_1
XFILLER_0_84_421 VPWR VGND VPWR VGND sky130_ef_sc_hd__decap_12
XTAP_TAPCELL_ROW_17_457 VGND VPWR sky130_fd_sc_hd__tapvpwrvgnd_1
XFILLER_0_29_337 VGND VGND VPWR VPWR sky130_fd_sc_hd__fill_2
XTAP_TAPCELL_ROW_45_788 VGND VPWR sky130_fd_sc_hd__tapvpwrvgnd_1
XFILLER_0_37_370 VGND VGND VPWR VPWR sky130_fd_sc_hd__fill_1
XFILLER_0_44_307 VGND VGND VPWR VPWR sky130_fd_sc_hd__fill_1
XFILLER_0_72_649 VGND VGND VPWR VPWR sky130_fd_sc_hd__fill_1
X_4560_ _1116_ _1338_ _1348_ VGND VGND VPWR VPWR _1349_ sky130_fd_sc_hd__o21ai_4
XFILLER_0_107_3 VPWR VGND VPWR VGND sky130_ef_sc_hd__decap_12
XFILLER_0_8_15 VPWR VGND VPWR VGND sky130_ef_sc_hd__decap_12
XFILLER_0_25_565 VGND VGND VPWR VPWR sky130_fd_sc_hd__fill_1
X_4491_ RF.reg_arr\[24\]\[28\] RF.reg_arr\[25\]\[28\] RF.reg_arr\[26\]\[28\] RF.reg_arr\[27\]\[28\]
+ _1274_ _1276_ VGND VGND VPWR VPWR _1280_ sky130_fd_sc_hd__mux4_1
Xhold617 RF.reg_arr\[18\]\[6\] VGND VGND VPWR VPWR net699 sky130_fd_sc_hd__dlygate4sd3_1
Xhold606 RF.reg_arr\[28\]\[13\] VGND VGND VPWR VPWR net688 sky130_fd_sc_hd__dlygate4sd3_1
X_6230_ net33 VGND VGND VPWR VPWR _2984_ sky130_fd_sc_hd__buf_2
XTAP_TAPCELL_ROW_77_1178 VGND VPWR sky130_fd_sc_hd__tapvpwrvgnd_1
Xhold628 RF.reg_arr\[29\]\[14\] VGND VGND VPWR VPWR net710 sky130_fd_sc_hd__dlygate4sd3_1
Xhold639 RF.reg_arr\[13\]\[18\] VGND VGND VPWR VPWR net721 sky130_fd_sc_hd__dlygate4sd3_1
X_6161_ _1772_ _2899_ VGND VGND VPWR VPWR _2922_ sky130_fd_sc_hd__nand2_1
XFILLER_0_100_75 VGND VGND VPWR VPWR sky130_fd_sc_hd__decap_8
XTAP_TAPCELL_ROW_90_1334 VGND VPWR sky130_fd_sc_hd__tapvpwrvgnd_1
XFILLER_0_85_22 VGND VGND VPWR VPWR sky130_fd_sc_hd__decap_3
X_5112_ _1899_ _1900_ _1865_ VGND VGND VPWR VPWR _1901_ sky130_fd_sc_hd__mux2_1
X_6092_ _2792_ _2854_ _2856_ net1127 VGND VGND VPWR VPWR _2857_ sky130_fd_sc_hd__a211oi_1
X_5043_ _1739_ _1812_ _1831_ VGND VGND VPWR VPWR _1832_ sky130_fd_sc_hd__mux2_1
XFILLER_0_79_204 VGND VGND VPWR VPWR sky130_fd_sc_hd__decap_8
X_8802_ clknet_leaf_66_CLK _0035_ VGND VGND VPWR VPWR RF.reg_arr\[4\]\[4\] sky130_fd_sc_hd__dfxtp_1
X_6994_ net395 _3433_ _3431_ VGND VGND VPWR VPWR _3434_ sky130_fd_sc_hd__mux2_1
X_5945_ _2021_ _2025_ VGND VGND VPWR VPWR _2718_ sky130_fd_sc_hd__or2_2
XFILLER_0_87_281 VGND VGND VPWR VPWR sky130_fd_sc_hd__fill_1
X_8733_ clknet_leaf_24_CLK _0990_ VGND VGND VPWR VPWR RF.reg_arr\[14\]\[31\] sky130_fd_sc_hd__dfxtp_1
X_8664_ clknet_leaf_36_CLK _0921_ VGND VGND VPWR VPWR RF.reg_arr\[8\]\[26\] sky130_fd_sc_hd__dfxtp_1
X_5876_ _2579_ _2649_ _2652_ VGND VGND VPWR VPWR _2653_ sky130_fd_sc_hd__o21bai_2
XFILLER_0_47_134 VGND VGND VPWR VPWR sky130_fd_sc_hd__fill_1
X_7615_ net276 _3435_ _3763_ VGND VGND VPWR VPWR _3766_ sky130_fd_sc_hd__mux2_1
Xclone17 net88 VGND VGND VPWR VPWR net1126 sky130_fd_sc_hd__clkbuf_16
XFILLER_0_35_307 VGND VGND VPWR VPWR sky130_fd_sc_hd__decap_6
XFILLER_0_47_167 VGND VGND VPWR VPWR sky130_fd_sc_hd__fill_1
XFILLER_0_47_178 VGND VGND VPWR VPWR sky130_fd_sc_hd__fill_1
X_4827_ net4 VGND VGND VPWR VPWR _1616_ sky130_fd_sc_hd__inv_2
X_8595_ clknet_leaf_47_CLK _0852_ VGND VGND VPWR VPWR RF.reg_arr\[0\]\[21\] sky130_fd_sc_hd__dfxtp_1
XFILLER_0_62_137 VGND VGND VPWR VPWR sky130_fd_sc_hd__decap_3
XFILLER_0_28_381 VGND VGND VPWR VPWR sky130_fd_sc_hd__fill_1
X_7546_ _3729_ VGND VGND VPWR VPWR _0308_ sky130_fd_sc_hd__clkbuf_1
X_4758_ _1545_ _1546_ _1128_ VGND VGND VPWR VPWR _1547_ sky130_fd_sc_hd__mux2_1
XFILLER_0_31_502 VGND VGND VPWR VPWR sky130_fd_sc_hd__fill_2
X_4689_ _1284_ _1477_ VGND VGND VPWR VPWR _1478_ sky130_fd_sc_hd__nor2_1
X_7477_ _3105_ net492 _3689_ VGND VGND VPWR VPWR _3692_ sky130_fd_sc_hd__mux2_1
X_6428_ net34 VGND VGND VPWR VPWR _3117_ sky130_fd_sc_hd__clkbuf_2
X_9216_ clknet_leaf_57_CLK _0449_ VGND VGND VPWR VPWR RF.reg_arr\[22\]\[2\] sky130_fd_sc_hd__dfxtp_1
XFILLER_0_31_568 VGND VGND VPWR VPWR sky130_fd_sc_hd__fill_1
X_9147_ clknet_leaf_29_CLK _0380_ VGND VGND VPWR VPWR RF.reg_arr\[30\]\[29\] sky130_fd_sc_hd__dfxtp_1
XFILLER_0_101_478 VGND VGND VPWR VPWR sky130_fd_sc_hd__decap_8
X_6359_ _3070_ VGND VGND VPWR VPWR _0804_ sky130_fd_sc_hd__clkbuf_1
XFILLER_0_11_281 VGND VGND VPWR VPWR sky130_fd_sc_hd__decap_6
X_9078_ clknet_leaf_52_CLK _0311_ VGND VGND VPWR VPWR RF.reg_arr\[28\]\[24\] sky130_fd_sc_hd__dfxtp_1
X_8029_ _3985_ VGND VGND VPWR VPWR _0535_ sky130_fd_sc_hd__clkbuf_1
XTAP_TAPCELL_ROW_110_1570 VGND VPWR sky130_fd_sc_hd__tapvpwrvgnd_1
XFILLER_0_98_557 VGND VGND VPWR VPWR sky130_fd_sc_hd__decap_3
XFILLER_0_85_229 VGND VGND VPWR VPWR sky130_fd_sc_hd__fill_1
XFILLER_0_66_410 VGND VGND VPWR VPWR sky130_fd_sc_hd__fill_1
XFILLER_0_66_421 VGND VGND VPWR VPWR sky130_fd_sc_hd__decap_6
XFILLER_0_14_29 VGND VGND VPWR VPWR sky130_fd_sc_hd__fill_1
XTAP_TAPCELL_ROW_14_416 VGND VPWR sky130_fd_sc_hd__tapvpwrvgnd_1
XFILLER_0_54_605 VGND VGND VPWR VPWR sky130_fd_sc_hd__fill_1
XFILLER_0_109_534 VPWR VGND VPWR VGND sky130_ef_sc_hd__decap_12
XTAP_TAPCELL_ROW_42_758 VGND VPWR sky130_fd_sc_hd__tapvpwrvgnd_1
XFILLER_0_93_284 VGND VGND VPWR VPWR sky130_fd_sc_hd__decap_4
XFILLER_0_53_148 VGND VGND VPWR VPWR sky130_fd_sc_hd__fill_2
XFILLER_0_81_479 VGND VGND VPWR VPWR sky130_fd_sc_hd__decap_8
XFILLER_0_104_250 VGND VGND VPWR VPWR sky130_fd_sc_hd__fill_2
X_5730_ _2381_ _2510_ _2513_ VGND VGND VPWR VPWR _2514_ sky130_fd_sc_hd__o21ai_1
XFILLER_0_29_178 VGND VGND VPWR VPWR sky130_fd_sc_hd__decap_6
X_5661_ _1736_ _1112_ _2447_ VGND VGND VPWR VPWR _2448_ sky130_fd_sc_hd__a21oi_1
XFILLER_0_72_424 VGND VGND VPWR VPWR sky130_fd_sc_hd__fill_2
X_7400_ _3650_ VGND VGND VPWR VPWR _0241_ sky130_fd_sc_hd__clkbuf_1
X_5592_ _2049_ _2025_ VGND VGND VPWR VPWR _2380_ sky130_fd_sc_hd__or2_1
X_8380_ _2990_ net814 _4137_ VGND VGND VPWR VPWR _4171_ sky130_fd_sc_hd__mux2_1
XFILLER_0_25_351 VGND VGND VPWR VPWR sky130_fd_sc_hd__decap_4
X_4612_ _1025_ _1392_ _1396_ _1400_ VGND VGND VPWR VPWR _1401_ sky130_fd_sc_hd__a2bb2o_2
XFILLER_0_115_559 VGND VGND VPWR VPWR sky130_fd_sc_hd__fill_1
XFILLER_0_111_74 VPWR VGND VPWR VGND sky130_ef_sc_hd__decap_12
X_4543_ _1284_ _1331_ _1272_ VGND VGND VPWR VPWR _1332_ sky130_fd_sc_hd__a21oi_1
XFILLER_0_4_267 VGND VGND VPWR VPWR sky130_fd_sc_hd__fill_2
X_7331_ _3096_ net923 _3605_ VGND VGND VPWR VPWR _3614_ sky130_fd_sc_hd__mux2_1
Xhold436 RF.reg_arr\[6\]\[23\] VGND VGND VPWR VPWR net518 sky130_fd_sc_hd__dlygate4sd3_1
XFILLER_0_80_490 VGND VGND VPWR VPWR sky130_fd_sc_hd__fill_1
Xhold425 RF.reg_arr\[5\]\[22\] VGND VGND VPWR VPWR net507 sky130_fd_sc_hd__dlygate4sd3_1
X_7262_ _3577_ VGND VGND VPWR VPWR _0176_ sky130_fd_sc_hd__clkbuf_1
XFILLER_0_20_83 VGND VGND VPWR VPWR sky130_fd_sc_hd__fill_1
Xhold414 RF.reg_arr\[12\]\[0\] VGND VGND VPWR VPWR net496 sky130_fd_sc_hd__dlygate4sd3_1
Xhold403 RF.reg_arr\[1\]\[19\] VGND VGND VPWR VPWR net485 sky130_fd_sc_hd__dlygate4sd3_1
X_6213_ net30 VGND VGND VPWR VPWR _2970_ sky130_fd_sc_hd__buf_2
XFILLER_0_110_231 VGND VGND VPWR VPWR sky130_fd_sc_hd__decap_3
Xhold458 RF.reg_arr\[22\]\[22\] VGND VGND VPWR VPWR net540 sky130_fd_sc_hd__dlygate4sd3_1
Xhold447 RF.reg_arr\[13\]\[15\] VGND VGND VPWR VPWR net529 sky130_fd_sc_hd__dlygate4sd3_1
Xhold469 RF.reg_arr\[9\]\[8\] VGND VGND VPWR VPWR net551 sky130_fd_sc_hd__dlygate4sd3_1
XFILLER_0_40_365 VGND VGND VPWR VPWR sky130_fd_sc_hd__decap_4
X_9001_ clknet_leaf_12_CLK _0234_ VGND VGND VPWR VPWR RF.reg_arr\[27\]\[11\] sky130_fd_sc_hd__dfxtp_1
X_4474_ RF.reg_arr\[12\]\[11\] RF.reg_arr\[13\]\[11\] RF.reg_arr\[14\]\[11\] RF.reg_arr\[15\]\[11\]
+ _1262_ _1083_ VGND VGND VPWR VPWR _1263_ sky130_fd_sc_hd__mux4_1
XFILLER_0_110_253 VGND VGND VPWR VPWR sky130_fd_sc_hd__decap_4
XFILLER_0_96_65 VGND VGND VPWR VPWR sky130_fd_sc_hd__fill_1
X_7193_ _3540_ VGND VGND VPWR VPWR _0144_ sky130_fd_sc_hd__clkbuf_1
XFILLER_0_110_297 VGND VGND VPWR VPWR sky130_fd_sc_hd__fill_1
X_6144_ _2051_ _2778_ VGND VGND VPWR VPWR _2906_ sky130_fd_sc_hd__and2_1
X_6075_ _2777_ _2840_ _2003_ VGND VGND VPWR VPWR _2841_ sky130_fd_sc_hd__mux2_1
XFILLER_0_29_92 VGND VGND VPWR VPWR sky130_fd_sc_hd__fill_1
X_5026_ _1813_ _1814_ _1033_ VGND VGND VPWR VPWR _1815_ sky130_fd_sc_hd__mux2_1
XFILLER_0_31_3 VPWR VGND VPWR VGND sky130_ef_sc_hd__decap_12
XFILLER_0_95_505 VGND VGND VPWR VPWR sky130_fd_sc_hd__decap_4
XFILLER_0_95_549 VGND VGND VPWR VPWR sky130_fd_sc_hd__decap_8
X_6977_ net21 VGND VGND VPWR VPWR _3422_ sky130_fd_sc_hd__buf_2
XFILLER_0_48_421 VGND VGND VPWR VPWR sky130_fd_sc_hd__fill_2
X_5928_ _2140_ _2692_ VGND VGND VPWR VPWR _2702_ sky130_fd_sc_hd__or2_1
X_8716_ clknet_leaf_95_CLK _0973_ VGND VGND VPWR VPWR RF.reg_arr\[14\]\[14\] sky130_fd_sc_hd__dfxtp_1
XFILLER_0_75_251 VGND VGND VPWR VPWR sky130_fd_sc_hd__decap_8
X_5859_ _1270_ _2636_ VGND VGND VPWR VPWR _2637_ sky130_fd_sc_hd__xnor2_1
X_8647_ clknet_leaf_64_CLK _0904_ VGND VGND VPWR VPWR RF.reg_arr\[8\]\[9\] sky130_fd_sc_hd__dfxtp_1
X_8578_ clknet_leaf_73_CLK _0835_ VGND VGND VPWR VPWR RF.reg_arr\[0\]\[4\] sky130_fd_sc_hd__dfxtp_1
X_7529_ _3720_ VGND VGND VPWR VPWR _0300_ sky130_fd_sc_hd__clkbuf_1
XFILLER_0_31_343 VGND VGND VPWR VPWR sky130_fd_sc_hd__decap_6
Xhold981 RF.reg_arr\[24\]\[8\] VGND VGND VPWR VPWR net1063 sky130_fd_sc_hd__dlygate4sd3_1
Xhold970 RF.reg_arr\[11\]\[16\] VGND VGND VPWR VPWR net1052 sky130_fd_sc_hd__dlygate4sd3_1
Xhold992 RF.reg_arr\[14\]\[3\] VGND VGND VPWR VPWR net1074 sky130_fd_sc_hd__dlygate4sd3_1
XTAP_TAPCELL_ROW_47_817 VGND VPWR sky130_fd_sc_hd__tapvpwrvgnd_1
XFILLER_0_25_28 VGND VGND VPWR VPWR sky130_fd_sc_hd__fill_2
XFILLER_0_98_398 VGND VGND VPWR VPWR sky130_fd_sc_hd__fill_1
XTAP_TAPCELL_ROW_63_1008 VGND VPWR sky130_fd_sc_hd__tapvpwrvgnd_1
XTAP_TAPCELL_ROW_27_574 VGND VPWR sky130_fd_sc_hd__tapvpwrvgnd_1
XFILLER_0_41_27 VPWR VGND VPWR VGND sky130_ef_sc_hd__decap_12
XFILLER_0_54_402 VPWR VGND VPWR VGND sky130_ef_sc_hd__decap_12
XFILLER_0_81_265 VGND VGND VPWR VPWR sky130_fd_sc_hd__decap_3
XFILLER_0_105_592 VGND VGND VPWR VPWR sky130_fd_sc_hd__decap_6
XTAP_TAPCELL_ROW_74_1137 VGND VPWR sky130_fd_sc_hd__tapvpwrvgnd_1
XFILLER_0_5_27 VPWR VGND VPWR VGND sky130_ef_sc_hd__decap_12
XFILLER_0_82_23 VGND VGND VPWR VPWR sky130_fd_sc_hd__decap_4
X_6900_ net520 _3046_ _3366_ VGND VGND VPWR VPWR _3370_ sky130_fd_sc_hd__mux2_1
XFILLER_0_82_56 VGND VGND VPWR VPWR sky130_fd_sc_hd__fill_1
XFILLER_0_77_505 VGND VGND VPWR VPWR sky130_fd_sc_hd__fill_2
X_7880_ _3906_ VGND VGND VPWR VPWR _0465_ sky130_fd_sc_hd__clkbuf_1
X_6831_ net518 _3046_ _3329_ VGND VGND VPWR VPWR _3333_ sky130_fd_sc_hd__mux2_1
XTAP_TAPCELL_ROW_85_1266 VGND VPWR sky130_fd_sc_hd__tapvpwrvgnd_1
XFILLER_0_106_96 VGND VGND VPWR VPWR sky130_fd_sc_hd__fill_2
XTAP_TAPCELL_ROW_85_1277 VGND VPWR sky130_fd_sc_hd__tapvpwrvgnd_1
XFILLER_0_85_571 VGND VGND VPWR VPWR sky130_fd_sc_hd__decap_4
X_6762_ _3107_ net725 _3292_ VGND VGND VPWR VPWR _3296_ sky130_fd_sc_hd__mux2_1
X_8501_ _4234_ VGND VGND VPWR VPWR _0758_ sky130_fd_sc_hd__clkbuf_1
XFILLER_0_9_337 VGND VGND VPWR VPWR sky130_fd_sc_hd__fill_2
X_6693_ _3258_ VGND VGND VPWR VPWR _0950_ sky130_fd_sc_hd__clkbuf_1
X_5713_ _1090_ _2497_ VGND VGND VPWR VPWR _2498_ sky130_fd_sc_hd__xor2_1
X_9481_ clknet_leaf_91_CLK _0714_ VGND VGND VPWR VPWR RF.reg_arr\[11\]\[11\] sky130_fd_sc_hd__dfxtp_1
XFILLER_0_57_273 VGND VGND VPWR VPWR sky130_fd_sc_hd__decap_6
X_5644_ _2050_ _2425_ _2429_ _2430_ VGND VGND VPWR VPWR _2431_ sky130_fd_sc_hd__a22o_1
X_8432_ net317 _3435_ _4196_ VGND VGND VPWR VPWR _4199_ sky130_fd_sc_hd__mux2_1
XFILLER_0_45_457 VGND VGND VPWR VPWR sky130_fd_sc_hd__fill_1
X_8363_ _4162_ VGND VGND VPWR VPWR _0692_ sky130_fd_sc_hd__clkbuf_1
XFILLER_0_60_438 VGND VGND VPWR VPWR sky130_fd_sc_hd__fill_2
X_5575_ _1648_ _1927_ VGND VGND VPWR VPWR _2363_ sky130_fd_sc_hd__nand2_1
XFILLER_0_79_3 VGND VGND VPWR VPWR sky130_fd_sc_hd__decap_3
Xhold200 RF.reg_arr\[7\]\[21\] VGND VGND VPWR VPWR net282 sky130_fd_sc_hd__dlygate4sd3_1
X_7314_ _3593_ VGND VGND VPWR VPWR _3605_ sky130_fd_sc_hd__clkbuf_8
Xhold211 RF.reg_arr\[5\]\[15\] VGND VGND VPWR VPWR net293 sky130_fd_sc_hd__dlygate4sd3_1
X_4526_ _1272_ _1301_ _1310_ _1314_ VGND VGND VPWR VPWR _1315_ sky130_fd_sc_hd__o2bb2a_2
X_8294_ net318 _3433_ _4124_ VGND VGND VPWR VPWR _4126_ sky130_fd_sc_hd__mux2_1
Xhold222 RF.reg_arr\[11\]\[5\] VGND VGND VPWR VPWR net304 sky130_fd_sc_hd__dlygate4sd3_1
Xhold244 RF.reg_arr\[21\]\[11\] VGND VGND VPWR VPWR net326 sky130_fd_sc_hd__dlygate4sd3_1
Xhold233 RF.reg_arr\[5\]\[3\] VGND VGND VPWR VPWR net315 sky130_fd_sc_hd__dlygate4sd3_1
Xhold255 RF.reg_arr\[16\]\[28\] VGND VGND VPWR VPWR net337 sky130_fd_sc_hd__dlygate4sd3_1
Xhold266 RF.reg_arr\[18\]\[23\] VGND VGND VPWR VPWR net348 sky130_fd_sc_hd__dlygate4sd3_1
Xhold277 RF.reg_arr\[18\]\[31\] VGND VGND VPWR VPWR net359 sky130_fd_sc_hd__dlygate4sd3_1
X_7245_ _3568_ VGND VGND VPWR VPWR _0168_ sky130_fd_sc_hd__clkbuf_1
X_4457_ _1242_ _1245_ _1061_ VGND VGND VPWR VPWR _1246_ sky130_fd_sc_hd__mux2_2
Xhold299 RF.reg_arr\[9\]\[9\] VGND VGND VPWR VPWR net381 sky130_fd_sc_hd__dlygate4sd3_1
XFILLER_0_0_281 VGND VGND VPWR VPWR sky130_fd_sc_hd__fill_1
Xhold288 RF.reg_arr\[3\]\[7\] VGND VGND VPWR VPWR net370 sky130_fd_sc_hd__dlygate4sd3_1
X_7176_ _3531_ VGND VGND VPWR VPWR _0136_ sky130_fd_sc_hd__clkbuf_1
X_6127_ _1753_ _2889_ VGND VGND VPWR VPWR _2890_ sky130_fd_sc_hd__nor2_1
X_4388_ RF.reg_arr\[4\]\[19\] RF.reg_arr\[5\]\[19\] RF.reg_arr\[6\]\[19\] RF.reg_arr\[7\]\[19\]
+ _1175_ _1176_ VGND VGND VPWR VPWR _1177_ sky130_fd_sc_hd__mux4_1
X_6058_ _2485_ _2525_ _2714_ _2445_ VGND VGND VPWR VPWR _2825_ sky130_fd_sc_hd__o31a_1
X_5009_ _1796_ _1797_ _1612_ VGND VGND VPWR VPWR _1798_ sky130_fd_sc_hd__mux2_1
XFILLER_0_76_571 VGND VGND VPWR VPWR sky130_fd_sc_hd__fill_1
XTAP_TAPCELL_ROW_24_544 VGND VPWR sky130_fd_sc_hd__tapvpwrvgnd_1
XFILLER_0_76_582 VGND VGND VPWR VPWR sky130_fd_sc_hd__decap_6
XTAP_TAPCELL_ROW_52_875 VGND VPWR sky130_fd_sc_hd__tapvpwrvgnd_1
XFILLER_0_106_356 VGND VGND VPWR VPWR sky130_fd_sc_hd__decap_4
XFILLER_0_91_596 VGND VGND VPWR VPWR sky130_fd_sc_hd__fill_2
XFILLER_0_63_276 VGND VGND VPWR VPWR sky130_fd_sc_hd__fill_1
XFILLER_0_31_184 VGND VGND VPWR VPWR sky130_fd_sc_hd__decap_3
XFILLER_0_36_27 VGND VGND VPWR VPWR sky130_fd_sc_hd__fill_1
XPHY_EDGE_ROW_101_Right_101 VGND VGND VPWR VPWR sky130_fd_sc_hd__decap_3
XFILLER_0_59_505 VGND VGND VPWR VPWR sky130_fd_sc_hd__decap_4
XFILLER_0_98_195 VGND VGND VPWR VPWR sky130_fd_sc_hd__fill_1
XFILLER_0_82_552 VGND VGND VPWR VPWR sky130_fd_sc_hd__decap_3
XFILLER_0_42_438 VGND VGND VPWR VPWR sky130_fd_sc_hd__fill_2
XFILLER_0_2_524 VGND VGND VPWR VPWR sky130_fd_sc_hd__decap_8
XFILLER_0_112_326 VGND VGND VPWR VPWR sky130_fd_sc_hd__fill_1
X_5360_ RF.reg_arr\[4\]\[15\] RF.reg_arr\[5\]\[15\] RF.reg_arr\[6\]\[15\] RF.reg_arr\[7\]\[15\]
+ _1883_ _1885_ VGND VGND VPWR VPWR _2149_ sky130_fd_sc_hd__mux4_1
X_4311_ _1099_ _1025_ VGND VGND VPWR VPWR _1100_ sky130_fd_sc_hd__nor2_4
XFILLER_0_50_493 VGND VGND VPWR VPWR sky130_fd_sc_hd__decap_4
X_5291_ RF.reg_arr\[0\]\[11\] RF.reg_arr\[1\]\[11\] RF.reg_arr\[2\]\[11\] RF.reg_arr\[3\]\[11\]
+ _1884_ _1886_ VGND VGND VPWR VPWR _2080_ sky130_fd_sc_hd__mux4_1
X_7030_ _3454_ VGND VGND VPWR VPWR _0067_ sky130_fd_sc_hd__clkbuf_1
X_4242_ RF.reg_arr\[16\]\[5\] RF.reg_arr\[17\]\[5\] RF.reg_arr\[18\]\[5\] RF.reg_arr\[19\]\[5\]
+ _1027_ _1029_ VGND VGND VPWR VPWR _1031_ sky130_fd_sc_hd__mux4_1
X_8981_ clknet_leaf_17_CLK _0214_ VGND VGND VPWR VPWR RF.reg_arr\[31\]\[23\] sky130_fd_sc_hd__dfxtp_1
X_7932_ _3934_ VGND VGND VPWR VPWR _0489_ sky130_fd_sc_hd__clkbuf_1
X_7863_ _3079_ net805 _3897_ VGND VGND VPWR VPWR _3898_ sky130_fd_sc_hd__mux2_1
XFILLER_0_9_134 VGND VGND VPWR VPWR sky130_fd_sc_hd__fill_2
X_6814_ net135 _3029_ _3318_ VGND VGND VPWR VPWR _3324_ sky130_fd_sc_hd__mux2_1
X_7794_ _3079_ net510 _3860_ VGND VGND VPWR VPWR _3861_ sky130_fd_sc_hd__mux2_1
X_6745_ _3090_ net915 _3281_ VGND VGND VPWR VPWR _3287_ sky130_fd_sc_hd__mux2_1
XTAP_TAPCELL_ROW_21_503 VGND VPWR sky130_fd_sc_hd__tapvpwrvgnd_1
XFILLER_0_42_70 VPWR VGND VPWR VGND sky130_ef_sc_hd__decap_12
X_9464_ clknet_leaf_36_CLK _0697_ VGND VGND VPWR VPWR RF.reg_arr\[12\]\[26\] sky130_fd_sc_hd__dfxtp_1
XFILLER_0_73_552 VGND VGND VPWR VPWR sky130_fd_sc_hd__decap_8
XTAP_TAPCELL_ROW_98_1424 VGND VPWR sky130_fd_sc_hd__tapvpwrvgnd_1
XFILLER_0_60_213 VGND VGND VPWR VPWR sky130_fd_sc_hd__fill_2
X_6676_ _3249_ VGND VGND VPWR VPWR _0942_ sky130_fd_sc_hd__clkbuf_1
X_8415_ net330 _3418_ _4185_ VGND VGND VPWR VPWR _4190_ sky130_fd_sc_hd__mux2_1
X_5627_ _2050_ _2401_ _2414_ _2334_ VGND VGND VPWR VPWR _2415_ sky130_fd_sc_hd__a211o_1
X_9395_ clknet_leaf_46_CLK _0628_ VGND VGND VPWR VPWR RF.reg_arr\[13\]\[21\] sky130_fd_sc_hd__dfxtp_1
XFILLER_0_33_449 VGND VGND VPWR VPWR sky130_fd_sc_hd__decap_6
XFILLER_0_103_337 VGND VGND VPWR VPWR sky130_fd_sc_hd__decap_8
X_5558_ _2330_ _2345_ VGND VGND VPWR VPWR _2346_ sky130_fd_sc_hd__xnor2_1
X_8346_ _4153_ VGND VGND VPWR VPWR _0684_ sky130_fd_sc_hd__clkbuf_1
X_4509_ RF.reg_arr\[28\]\[29\] RF.reg_arr\[29\]\[29\] RF.reg_arr\[30\]\[29\] RF.reg_arr\[31\]\[29\]
+ _1273_ _1275_ VGND VGND VPWR VPWR _1298_ sky130_fd_sc_hd__mux4_1
X_8277_ net497 _3416_ _4113_ VGND VGND VPWR VPWR _4117_ sky130_fd_sc_hd__mux2_1
X_7228_ _3061_ net944 _3558_ VGND VGND VPWR VPWR _3560_ sky130_fd_sc_hd__mux2_1
X_5489_ RF.reg_arr\[16\]\[3\] RF.reg_arr\[17\]\[3\] RF.reg_arr\[18\]\[3\] RF.reg_arr\[19\]\[3\]
+ _1622_ _1595_ VGND VGND VPWR VPWR _2278_ sky130_fd_sc_hd__mux4_1
X_7159_ net530 _3391_ _3521_ VGND VGND VPWR VPWR _3523_ sky130_fd_sc_hd__mux2_1
XTAP_TAPCELL_ROW_29_603 VGND VPWR sky130_fd_sc_hd__tapvpwrvgnd_1
XTAP_TAPCELL_ROW_57_934 VGND VPWR sky130_fd_sc_hd__tapvpwrvgnd_1
XTAP_TAPCELL_ROW_107_1531 VGND VPWR sky130_fd_sc_hd__tapvpwrvgnd_1
XTAP_TAPCELL_ROW_1_261 VGND VPWR sky130_fd_sc_hd__tapvpwrvgnd_1
XFILLER_0_96_666 VGND VGND VPWR VPWR sky130_fd_sc_hd__fill_1
XTAP_TAPCELL_ROW_37_691 VGND VPWR sky130_fd_sc_hd__tapvpwrvgnd_1
XFILLER_0_107_654 VGND VGND VPWR VPWR sky130_fd_sc_hd__decap_8
XFILLER_0_36_276 VGND VGND VPWR VPWR sky130_fd_sc_hd__fill_1
XFILLER_0_106_153 VGND VGND VPWR VPWR sky130_fd_sc_hd__decap_4
XFILLER_0_24_438 VGND VGND VPWR VPWR sky130_fd_sc_hd__fill_1
XFILLER_0_106_186 VGND VGND VPWR VPWR sky130_fd_sc_hd__decap_4
XPHY_EDGE_ROW_102_Left_219 VGND VGND VPWR VPWR sky130_fd_sc_hd__decap_3
XTAP_TAPCELL_ROW_71_1107 VGND VPWR sky130_fd_sc_hd__tapvpwrvgnd_1
XTAP_TAPCELL_ROW_9_361 VGND VPWR sky130_fd_sc_hd__tapvpwrvgnd_1
XFILLER_0_87_644 VGND VGND VPWR VPWR sky130_fd_sc_hd__decap_6
XPHY_EDGE_ROW_111_Left_228 VGND VGND VPWR VPWR sky130_fd_sc_hd__decap_3
X_4860_ _1583_ VGND VGND VPWR VPWR _1649_ sky130_fd_sc_hd__buf_4
XTAP_TAPCELL_ROW_82_1236 VGND VPWR sky130_fd_sc_hd__tapvpwrvgnd_1
X_4791_ _1272_ _1571_ _1579_ VGND VGND VPWR VPWR _1580_ sky130_fd_sc_hd__a21o_1
XANTENNA_17 _2120_ VGND VGND VPWR VPWR sky130_fd_sc_hd__diode_2
XANTENNA_28 _1159_ VGND VGND VPWR VPWR sky130_fd_sc_hd__diode_2
X_6530_ _3172_ VGND VGND VPWR VPWR _0873_ sky130_fd_sc_hd__clkbuf_1
XFILLER_0_82_382 VGND VGND VPWR VPWR sky130_fd_sc_hd__fill_1
X_6461_ _3135_ VGND VGND VPWR VPWR _0841_ sky130_fd_sc_hd__clkbuf_1
X_9180_ clknet_leaf_23_CLK _0413_ VGND VGND VPWR VPWR RF.reg_arr\[9\]\[30\] sky130_fd_sc_hd__dfxtp_1
X_5412_ RF.reg_arr\[20\]\[4\] RF.reg_arr\[21\]\[4\] RF.reg_arr\[22\]\[4\] RF.reg_arr\[23\]\[4\]
+ _2030_ _1858_ VGND VGND VPWR VPWR _2201_ sky130_fd_sc_hd__mux4_1
X_8200_ _3016_ net901 _4066_ VGND VGND VPWR VPWR _4076_ sky130_fd_sc_hd__mux2_1
X_6392_ _3092_ net905 _3080_ VGND VGND VPWR VPWR _3093_ sky130_fd_sc_hd__mux2_1
X_8131_ _4039_ VGND VGND VPWR VPWR _0583_ sky130_fd_sc_hd__clkbuf_1
X_5343_ RF.reg_arr\[8\]\[14\] RF.reg_arr\[9\]\[14\] RF.reg_arr\[10\]\[14\] RF.reg_arr\[11\]\[14\]
+ _1675_ _1681_ VGND VGND VPWR VPWR _2132_ sky130_fd_sc_hd__mux4_1
XFILLER_0_23_493 VGND VGND VPWR VPWR sky130_fd_sc_hd__decap_6
XTAP_TAPCELL_ROW_93_1365 VGND VPWR sky130_fd_sc_hd__tapvpwrvgnd_1
XFILLER_0_10_121 VGND VGND VPWR VPWR sky130_fd_sc_hd__fill_2
X_8062_ _3014_ net953 _3994_ VGND VGND VPWR VPWR _4003_ sky130_fd_sc_hd__mux2_1
X_5274_ RF.reg_arr\[4\]\[10\] RF.reg_arr\[5\]\[10\] RF.reg_arr\[6\]\[10\] RF.reg_arr\[7\]\[10\]
+ _1848_ _1851_ VGND VGND VPWR VPWR _2063_ sky130_fd_sc_hd__mux4_1
X_7013_ _3444_ VGND VGND VPWR VPWR _0060_ sky130_fd_sc_hd__clkbuf_1
X_8964_ clknet_leaf_83_CLK _0197_ VGND VGND VPWR VPWR RF.reg_arr\[31\]\[6\] sky130_fd_sc_hd__dfxtp_1
XTAP_TAPCELL_ROW_54_904 VGND VPWR sky130_fd_sc_hd__tapvpwrvgnd_1
X_7915_ _3925_ VGND VGND VPWR VPWR _0481_ sky130_fd_sc_hd__clkbuf_1
X_8895_ clknet_leaf_58_CLK _0128_ VGND VGND VPWR VPWR RF.reg_arr\[7\]\[1\] sky130_fd_sc_hd__dfxtp_1
X_7846_ _3063_ net466 _3886_ VGND VGND VPWR VPWR _3889_ sky130_fd_sc_hd__mux2_1
XFILLER_0_18_210 VGND VGND VPWR VPWR sky130_fd_sc_hd__fill_2
XTAP_TAPCELL_ROW_34_661 VGND VPWR sky130_fd_sc_hd__tapvpwrvgnd_1
X_4989_ RF.reg_arr\[28\]\[24\] RF.reg_arr\[29\]\[24\] RF.reg_arr\[30\]\[24\] RF.reg_arr\[31\]\[24\]
+ _1668_ _1669_ VGND VGND VPWR VPWR _1778_ sky130_fd_sc_hd__mux4_1
XTAP_TAPCELL_ROW_102_1472 VGND VPWR sky130_fd_sc_hd__tapvpwrvgnd_1
XTAP_TAPCELL_ROW_62_992 VGND VPWR sky130_fd_sc_hd__tapvpwrvgnd_1
X_7777_ _3063_ net733 _3849_ VGND VGND VPWR VPWR _3852_ sky130_fd_sc_hd__mux2_1
X_6728_ _3073_ net630 _3270_ VGND VGND VPWR VPWR _3278_ sky130_fd_sc_hd__mux2_1
X_9516_ clknet_leaf_102_CLK _0749_ VGND VGND VPWR VPWR RF.reg_arr\[10\]\[14\] sky130_fd_sc_hd__dfxtp_1
XFILLER_0_46_574 VGND VGND VPWR VPWR sky130_fd_sc_hd__fill_1
XFILLER_0_18_298 VGND VGND VPWR VPWR sky130_fd_sc_hd__decap_8
X_6659_ _3240_ VGND VGND VPWR VPWR _0934_ sky130_fd_sc_hd__clkbuf_1
X_9447_ clknet_leaf_65_CLK _0680_ VGND VGND VPWR VPWR RF.reg_arr\[12\]\[9\] sky130_fd_sc_hd__dfxtp_1
XFILLER_0_33_279 VGND VGND VPWR VPWR sky130_fd_sc_hd__fill_1
X_9378_ clknet_leaf_71_CLK _0611_ VGND VGND VPWR VPWR RF.reg_arr\[13\]\[4\] sky130_fd_sc_hd__dfxtp_1
XFILLER_0_104_668 VGND VGND VPWR VPWR sky130_fd_sc_hd__decap_6
X_8329_ _4144_ VGND VGND VPWR VPWR _0676_ sky130_fd_sc_hd__clkbuf_1
XFILLER_0_103_167 VGND VGND VPWR VPWR sky130_fd_sc_hd__fill_1
XTAP_TAPCELL_ROW_6_320 VGND VPWR sky130_fd_sc_hd__tapvpwrvgnd_1
Xclkbuf_leaf_101_CLK clknet_3_1__leaf_CLK VGND VGND VPWR VPWR clknet_leaf_101_CLK
+ sky130_fd_sc_hd__clkbuf_8
XFILLER_0_96_441 VGND VGND VPWR VPWR sky130_fd_sc_hd__fill_1
XFILLER_0_83_124 VGND VGND VPWR VPWR sky130_fd_sc_hd__decap_8
XFILLER_0_71_319 VGND VGND VPWR VPWR sky130_fd_sc_hd__fill_1
XFILLER_0_107_462 VGND VGND VPWR VPWR sky130_fd_sc_hd__fill_1
Xinput37 WD3[30] VGND VGND VPWR VPWR net37 sky130_fd_sc_hd__buf_1
Xinput26 WD3[20] VGND VGND VPWR VPWR net26 sky130_fd_sc_hd__dlymetal6s2s_1
Xinput15 WD3[10] VGND VGND VPWR VPWR net15 sky130_fd_sc_hd__dlymetal6s2s_1
XFILLER_0_107_495 VGND VGND VPWR VPWR sky130_fd_sc_hd__decap_8
Xinput48 opcode[1] VGND VGND VPWR VPWR net48 sky130_fd_sc_hd__buf_1
XTAP_TAPCELL_ROW_12_399 VGND VPWR sky130_fd_sc_hd__tapvpwrvgnd_1
XFILLER_0_3_129 VGND VGND VPWR VPWR sky130_fd_sc_hd__decap_3
XFILLER_0_20_474 VGND VGND VPWR VPWR sky130_fd_sc_hd__fill_2
X_5961_ _2693_ _2695_ _2700_ _2733_ _2702_ VGND VGND VPWR VPWR _2734_ sky130_fd_sc_hd__o32a_1
X_4912_ RF.reg_arr\[24\]\[28\] RF.reg_arr\[25\]\[28\] RF.reg_arr\[26\]\[28\] RF.reg_arr\[27\]\[28\]
+ _1626_ _1628_ VGND VGND VPWR VPWR _1701_ sky130_fd_sc_hd__mux4_1
XFILLER_0_90_23 VGND VGND VPWR VPWR sky130_fd_sc_hd__decap_4
X_7700_ _3810_ VGND VGND VPWR VPWR _0381_ sky130_fd_sc_hd__clkbuf_1
X_8680_ clknet_leaf_12_CLK _0937_ VGND VGND VPWR VPWR RF.reg_arr\[15\]\[10\] sky130_fd_sc_hd__dfxtp_1
XFILLER_0_114_41 VGND VGND VPWR VPWR sky130_fd_sc_hd__decap_8
X_7631_ net443 _3383_ _3740_ VGND VGND VPWR VPWR _3774_ sky130_fd_sc_hd__mux2_1
X_5892_ _2666_ _2535_ _2667_ _1516_ VGND VGND VPWR VPWR _2668_ sky130_fd_sc_hd__a211o_1
X_4843_ _1630_ _1631_ _1605_ VGND VGND VPWR VPWR _1632_ sky130_fd_sc_hd__mux2_1
XFILLER_0_7_413 VGND VGND VPWR VPWR sky130_fd_sc_hd__decap_8
XTAP_TAPCELL_ROW_31_620 VGND VPWR sky130_fd_sc_hd__tapvpwrvgnd_1
X_7562_ _3737_ VGND VGND VPWR VPWR _0316_ sky130_fd_sc_hd__clkbuf_1
X_4774_ _1282_ _1562_ _1163_ VGND VGND VPWR VPWR _1563_ sky130_fd_sc_hd__o21a_1
X_9301_ clknet_leaf_40_CLK _0534_ VGND VGND VPWR VPWR RF.reg_arr\[25\]\[23\] sky130_fd_sc_hd__dfxtp_1
X_7493_ _3121_ net786 _3666_ VGND VGND VPWR VPWR _3700_ sky130_fd_sc_hd__mux2_1
X_6513_ _3163_ VGND VGND VPWR VPWR _0865_ sky130_fd_sc_hd__clkbuf_1
XFILLER_0_70_330 VGND VGND VPWR VPWR sky130_fd_sc_hd__fill_2
X_6444_ net113 VGND VGND VPWR VPWR _3127_ sky130_fd_sc_hd__clkbuf_1
XFILLER_0_70_341 VGND VGND VPWR VPWR sky130_fd_sc_hd__fill_2
X_9232_ clknet_leaf_0_CLK _0465_ VGND VGND VPWR VPWR RF.reg_arr\[22\]\[18\] sky130_fd_sc_hd__dfxtp_1
XFILLER_0_3_641 VPWR VGND VPWR VGND sky130_ef_sc_hd__decap_12
XFILLER_0_101_638 VGND VGND VPWR VPWR sky130_fd_sc_hd__decap_3
XFILLER_0_101_627 VGND VGND VPWR VPWR sky130_fd_sc_hd__decap_6
XFILLER_0_61_3 VGND VGND VPWR VPWR sky130_fd_sc_hd__fill_2
XFILLER_0_3_685 VGND VGND VPWR VPWR sky130_fd_sc_hd__decap_6
X_6375_ _3081_ VGND VGND VPWR VPWR _0809_ sky130_fd_sc_hd__clkbuf_1
X_9163_ clknet_leaf_91_CLK _0396_ VGND VGND VPWR VPWR RF.reg_arr\[9\]\[13\] sky130_fd_sc_hd__dfxtp_1
X_8114_ net954 _3387_ _4030_ VGND VGND VPWR VPWR _4031_ sky130_fd_sc_hd__mux2_1
X_9094_ clknet_leaf_88_CLK _0327_ VGND VGND VPWR VPWR RF.reg_arr\[2\]\[8\] sky130_fd_sc_hd__dfxtp_1
X_5326_ _1845_ _2114_ VGND VGND VPWR VPWR _2115_ sky130_fd_sc_hd__nand2_1
X_5257_ _1115_ _2045_ VGND VGND VPWR VPWR _2046_ sky130_fd_sc_hd__nand2_1
X_8045_ _3993_ VGND VGND VPWR VPWR _3994_ sky130_fd_sc_hd__clkbuf_8
XTAP_TAPCELL_ROW_39_720 VGND VPWR sky130_fd_sc_hd__tapvpwrvgnd_1
X_5188_ RF.reg_arr\[0\]\[16\] RF.reg_arr\[1\]\[16\] RF.reg_arr\[2\]\[16\] RF.reg_arr\[3\]\[16\]
+ _1857_ _1860_ VGND VGND VPWR VPWR _1977_ sky130_fd_sc_hd__mux4_1
X_8947_ clknet_leaf_48_CLK _0180_ VGND VGND VPWR VPWR RF.reg_arr\[29\]\[21\] sky130_fd_sc_hd__dfxtp_1
XTAP_TAPCELL_ROW_104_1501 VGND VPWR sky130_fd_sc_hd__tapvpwrvgnd_1
XFILLER_0_78_452 VGND VGND VPWR VPWR sky130_fd_sc_hd__decap_4
XFILLER_0_38_327 VGND VGND VPWR VPWR sky130_fd_sc_hd__fill_2
X_8878_ clknet_leaf_9_CLK _0111_ VGND VGND VPWR VPWR RF.reg_arr\[3\]\[16\] sky130_fd_sc_hd__dfxtp_1
X_7829_ _3115_ net373 _3871_ VGND VGND VPWR VPWR _3879_ sky130_fd_sc_hd__mux2_1
XFILLER_0_81_639 VGND VGND VPWR VPWR sky130_fd_sc_hd__decap_4
XFILLER_0_34_511 VPWR VGND VPWR VGND sky130_ef_sc_hd__decap_12
XFILLER_0_80_138 VGND VGND VPWR VPWR sky130_fd_sc_hd__fill_2
XFILLER_0_34_533 VPWR VGND VPWR VGND sky130_ef_sc_hd__decap_12
XTAP_TAPCELL_ROW_115_1630 VGND VPWR sky130_fd_sc_hd__tapvpwrvgnd_1
XTAP_TAPCELL_ROW_66_1039 VGND VPWR sky130_fd_sc_hd__tapvpwrvgnd_1
XTAP_TAPCELL_ROW_17_458 VGND VPWR sky130_fd_sc_hd__tapvpwrvgnd_1
XFILLER_0_84_433 VGND VGND VPWR VPWR sky130_fd_sc_hd__decap_4
XTAP_TAPCELL_ROW_45_789 VGND VPWR sky130_fd_sc_hd__tapvpwrvgnd_1
XFILLER_0_84_499 VGND VGND VPWR VPWR sky130_fd_sc_hd__decap_8
XFILLER_0_72_628 VGND VGND VPWR VPWR sky130_fd_sc_hd__decap_6
XFILLER_0_107_281 VGND VGND VPWR VPWR sky130_fd_sc_hd__decap_4
XFILLER_0_107_270 VGND VGND VPWR VPWR sky130_fd_sc_hd__decap_8
XFILLER_0_8_27 VGND VGND VPWR VPWR sky130_fd_sc_hd__fill_1
X_4490_ RF.reg_arr\[28\]\[28\] RF.reg_arr\[29\]\[28\] RF.reg_arr\[30\]\[28\] RF.reg_arr\[31\]\[28\]
+ _1274_ _1276_ VGND VGND VPWR VPWR _1279_ sky130_fd_sc_hd__mux4_1
Xhold607 RF.reg_arr\[11\]\[25\] VGND VGND VPWR VPWR net689 sky130_fd_sc_hd__dlygate4sd3_1
XFILLER_0_69_24 VGND VGND VPWR VPWR sky130_fd_sc_hd__fill_1
Xhold618 RF.reg_arr\[23\]\[6\] VGND VGND VPWR VPWR net700 sky130_fd_sc_hd__dlygate4sd3_1
XFILLER_0_40_514 VGND VGND VPWR VPWR sky130_fd_sc_hd__fill_1
XTAP_TAPCELL_ROW_77_1179 VGND VPWR sky130_fd_sc_hd__tapvpwrvgnd_1
XFILLER_0_69_79 VGND VGND VPWR VPWR sky130_fd_sc_hd__fill_1
Xhold629 RF.reg_arr\[9\]\[7\] VGND VGND VPWR VPWR net711 sky130_fd_sc_hd__dlygate4sd3_1
X_6160_ _2853_ _2857_ _2919_ _2920_ VGND VGND VPWR VPWR _2921_ sky130_fd_sc_hd__a211o_1
XTAP_TAPCELL_ROW_90_1335 VGND VPWR sky130_fd_sc_hd__tapvpwrvgnd_1
X_5111_ RF.reg_arr\[24\]\[20\] RF.reg_arr\[25\]\[20\] RF.reg_arr\[26\]\[20\] RF.reg_arr\[27\]\[20\]
+ _1848_ _1851_ VGND VGND VPWR VPWR _1900_ sky130_fd_sc_hd__mux4_1
X_6091_ _2814_ _2817_ _2833_ _2855_ _2834_ VGND VGND VPWR VPWR _2856_ sky130_fd_sc_hd__a32o_1
X_5042_ _1830_ VGND VGND VPWR VPWR _1831_ sky130_fd_sc_hd__buf_4
X_8801_ clknet_leaf_65_CLK _0034_ VGND VGND VPWR VPWR RF.reg_arr\[4\]\[3\] sky130_fd_sc_hd__dfxtp_1
X_6993_ net27 VGND VGND VPWR VPWR _3433_ sky130_fd_sc_hd__buf_2
X_5944_ _2003_ _2313_ _2716_ _2340_ VGND VGND VPWR VPWR _2717_ sky130_fd_sc_hd__a31o_1
X_8732_ clknet_leaf_24_CLK _0989_ VGND VGND VPWR VPWR RF.reg_arr\[14\]\[30\] sky130_fd_sc_hd__dfxtp_1
X_8663_ clknet_leaf_38_CLK _0920_ VGND VGND VPWR VPWR RF.reg_arr\[8\]\[25\] sky130_fd_sc_hd__dfxtp_1
X_5875_ _2624_ _2625_ _2638_ _2650_ _2651_ VGND VGND VPWR VPWR _2652_ sky130_fd_sc_hd__a311o_1
XFILLER_0_75_444 VGND VGND VPWR VPWR sky130_fd_sc_hd__decap_4
XFILLER_0_48_658 VGND VGND VPWR VPWR sky130_fd_sc_hd__fill_1
X_7614_ _3765_ VGND VGND VPWR VPWR _0340_ sky130_fd_sc_hd__clkbuf_1
X_4826_ _1607_ _1608_ _1614_ VGND VGND VPWR VPWR _1615_ sky130_fd_sc_hd__mux2_1
X_8594_ clknet_leaf_13_CLK _0851_ VGND VGND VPWR VPWR RF.reg_arr\[0\]\[20\] sky130_fd_sc_hd__dfxtp_1
XFILLER_0_90_458 VPWR VGND VPWR VGND sky130_ef_sc_hd__decap_12
X_7545_ net573 _3433_ _3727_ VGND VGND VPWR VPWR _3729_ sky130_fd_sc_hd__mux2_1
XFILLER_0_75_499 VGND VGND VPWR VPWR sky130_fd_sc_hd__decap_4
XFILLER_0_7_254 VGND VGND VPWR VPWR sky130_fd_sc_hd__decap_3
X_4757_ RF.reg_arr\[0\]\[15\] RF.reg_arr\[1\]\[15\] RF.reg_arr\[2\]\[15\] RF.reg_arr\[3\]\[15\]
+ _1187_ _1189_ VGND VGND VPWR VPWR _1546_ sky130_fd_sc_hd__mux4_1
X_7476_ _3691_ VGND VGND VPWR VPWR _0276_ sky130_fd_sc_hd__clkbuf_1
X_4688_ _1475_ _1476_ _1308_ VGND VGND VPWR VPWR _1477_ sky130_fd_sc_hd__mux2_1
X_6427_ _3116_ VGND VGND VPWR VPWR _0826_ sky130_fd_sc_hd__clkbuf_1
X_9215_ clknet_leaf_56_CLK _0448_ VGND VGND VPWR VPWR RF.reg_arr\[22\]\[1\] sky130_fd_sc_hd__dfxtp_1
XFILLER_0_3_471 VGND VGND VPWR VPWR sky130_fd_sc_hd__fill_2
X_9146_ clknet_leaf_29_CLK _0379_ VGND VGND VPWR VPWR RF.reg_arr\[30\]\[28\] sky130_fd_sc_hd__dfxtp_1
XFILLER_0_101_457 VGND VGND VPWR VPWR sky130_fd_sc_hd__fill_2
X_6358_ _3069_ net950 _3059_ VGND VGND VPWR VPWR _3070_ sky130_fd_sc_hd__mux2_1
X_5309_ _1611_ _2097_ _1617_ VGND VGND VPWR VPWR _2098_ sky130_fd_sc_hd__o21a_1
X_9077_ clknet_leaf_16_CLK _0310_ VGND VGND VPWR VPWR RF.reg_arr\[28\]\[23\] sky130_fd_sc_hd__dfxtp_1
X_6289_ net18 VGND VGND VPWR VPWR _3025_ sky130_fd_sc_hd__buf_2
X_8028_ _2970_ net493 _3980_ VGND VGND VPWR VPWR _3985_ sky130_fd_sc_hd__mux2_1
XTAP_TAPCELL_ROW_110_1571 VGND VPWR sky130_fd_sc_hd__tapvpwrvgnd_1
XFILLER_0_98_569 VPWR VGND VPWR VGND sky130_ef_sc_hd__decap_12
XFILLER_0_66_400 VGND VGND VPWR VPWR sky130_fd_sc_hd__fill_2
XFILLER_0_38_113 VGND VGND VPWR VPWR sky130_fd_sc_hd__fill_2
XFILLER_0_39_614 VGND VGND VPWR VPWR sky130_fd_sc_hd__fill_2
XTAP_TAPCELL_ROW_14_417 VGND VPWR sky130_fd_sc_hd__tapvpwrvgnd_1
XFILLER_0_109_557 VGND VGND VPWR VPWR sky130_fd_sc_hd__decap_3
XFILLER_0_109_546 VGND VGND VPWR VPWR sky130_fd_sc_hd__decap_6
XFILLER_0_66_477 VGND VGND VPWR VPWR sky130_fd_sc_hd__decap_6
XTAP_TAPCELL_ROW_42_759 VGND VPWR sky130_fd_sc_hd__tapvpwrvgnd_1
XFILLER_0_19_393 VGND VGND VPWR VPWR sky130_fd_sc_hd__decap_4
XFILLER_0_62_683 VGND VGND VPWR VPWR sky130_fd_sc_hd__fill_1
XFILLER_0_104_295 VPWR VGND VPWR VGND sky130_ef_sc_hd__decap_12
XFILLER_0_89_525 VGND VGND VPWR VPWR sky130_fd_sc_hd__decap_6
XFILLER_0_97_591 VGND VGND VPWR VPWR sky130_fd_sc_hd__decap_3
XFILLER_0_71_69 VGND VGND VPWR VPWR sky130_fd_sc_hd__fill_1
X_5660_ _2343_ VGND VGND VPWR VPWR _2447_ sky130_fd_sc_hd__buf_2
XFILLER_0_115_505 VPWR VGND VPWR VGND sky130_ef_sc_hd__decap_12
X_4611_ _1110_ _1399_ _1141_ VGND VGND VPWR VPWR _1400_ sky130_fd_sc_hd__a21oi_1
X_5591_ _2362_ _2378_ _2022_ VGND VGND VPWR VPWR _2379_ sky130_fd_sc_hd__mux2_1
XFILLER_0_80_480 VGND VGND VPWR VPWR sky130_fd_sc_hd__decap_4
X_4542_ _1329_ _1330_ _1168_ VGND VGND VPWR VPWR _1331_ sky130_fd_sc_hd__mux2_1
XFILLER_0_13_503 VGND VGND VPWR VPWR sky130_fd_sc_hd__fill_1
X_7330_ _3613_ VGND VGND VPWR VPWR _0208_ sky130_fd_sc_hd__clkbuf_1
XFILLER_0_4_257 VGND VGND VPWR VPWR sky130_fd_sc_hd__fill_1
Xclkbuf_leaf_90_CLK clknet_3_4__leaf_CLK VGND VGND VPWR VPWR clknet_leaf_90_CLK sky130_fd_sc_hd__clkbuf_8
XFILLER_0_111_86 VGND VGND VPWR VPWR sky130_fd_sc_hd__decap_6
XFILLER_0_13_558 VGND VGND VPWR VPWR sky130_fd_sc_hd__fill_2
X_7261_ _3094_ net1075 _3569_ VGND VGND VPWR VPWR _3577_ sky130_fd_sc_hd__mux2_1
Xhold426 RF.reg_arr\[3\]\[12\] VGND VGND VPWR VPWR net508 sky130_fd_sc_hd__dlygate4sd3_1
Xhold415 RF.reg_arr\[17\]\[13\] VGND VGND VPWR VPWR net497 sky130_fd_sc_hd__dlygate4sd3_1
Xhold404 RF.reg_arr\[11\]\[3\] VGND VGND VPWR VPWR net486 sky130_fd_sc_hd__dlygate4sd3_1
X_4473_ A2[0] VGND VGND VPWR VPWR _1262_ sky130_fd_sc_hd__buf_4
X_6212_ _2443_ _2964_ _2969_ VGND VGND VPWR VPWR net73 sky130_fd_sc_hd__o21ai_1
Xhold437 RF.reg_arr\[5\]\[26\] VGND VGND VPWR VPWR net519 sky130_fd_sc_hd__dlygate4sd3_1
XFILLER_0_96_11 VGND VGND VPWR VPWR sky130_fd_sc_hd__fill_1
Xhold448 RF.reg_arr\[7\]\[1\] VGND VGND VPWR VPWR net530 sky130_fd_sc_hd__dlygate4sd3_1
X_9000_ clknet_leaf_10_CLK _0233_ VGND VGND VPWR VPWR RF.reg_arr\[27\]\[10\] sky130_fd_sc_hd__dfxtp_1
Xhold459 RF.reg_arr\[4\]\[13\] VGND VGND VPWR VPWR net541 sky130_fd_sc_hd__dlygate4sd3_1
XPHY_EDGE_ROW_115_Right_115 VGND VGND VPWR VPWR sky130_fd_sc_hd__decap_3
X_7192_ net716 _3424_ _3532_ VGND VGND VPWR VPWR _3540_ sky130_fd_sc_hd__mux2_1
X_6143_ _2903_ _2904_ VGND VGND VPWR VPWR _2905_ sky130_fd_sc_hd__nand2_1
XFILLER_0_0_474 VGND VGND VPWR VPWR sky130_fd_sc_hd__fill_2
X_6074_ _2806_ _2839_ _2001_ VGND VGND VPWR VPWR _2840_ sky130_fd_sc_hd__mux2_1
X_5025_ RF.reg_arr\[16\]\[2\] RF.reg_arr\[17\]\[2\] RF.reg_arr\[18\]\[2\] RF.reg_arr\[19\]\[2\]
+ _1043_ _1083_ VGND VGND VPWR VPWR _1814_ sky130_fd_sc_hd__mux4_1
XFILLER_0_24_3 VGND VGND VPWR VPWR sky130_fd_sc_hd__decap_3
X_6976_ _3421_ VGND VGND VPWR VPWR _0046_ sky130_fd_sc_hd__clkbuf_1
X_5927_ _2693_ VGND VGND VPWR VPWR _2701_ sky130_fd_sc_hd__inv_2
X_8715_ clknet_leaf_92_CLK _0972_ VGND VGND VPWR VPWR RF.reg_arr\[14\]\[13\] sky130_fd_sc_hd__dfxtp_1
XFILLER_0_48_477 VGND VGND VPWR VPWR sky130_fd_sc_hd__decap_6
XFILLER_0_90_200 VGND VGND VPWR VPWR sky130_fd_sc_hd__decap_4
X_5858_ _1255_ _2547_ _2622_ VGND VGND VPWR VPWR _2636_ sky130_fd_sc_hd__a21oi_1
XFILLER_0_63_447 VGND VGND VPWR VPWR sky130_fd_sc_hd__fill_1
X_8646_ clknet_leaf_86_CLK _0903_ VGND VGND VPWR VPWR RF.reg_arr\[8\]\[8\] sky130_fd_sc_hd__dfxtp_1
X_5789_ _1416_ _2533_ _2534_ _2535_ VGND VGND VPWR VPWR _2570_ sky130_fd_sc_hd__o31a_1
X_8577_ clknet_leaf_61_CLK _0834_ VGND VGND VPWR VPWR RF.reg_arr\[0\]\[3\] sky130_fd_sc_hd__dfxtp_1
XPHY_EDGE_ROW_17_Right_17 VGND VGND VPWR VPWR sky130_fd_sc_hd__decap_3
X_4809_ _1597_ VGND VGND VPWR VPWR _1598_ sky130_fd_sc_hd__buf_4
Xclkbuf_leaf_81_CLK clknet_3_5__leaf_CLK VGND VGND VPWR VPWR clknet_leaf_81_CLK sky130_fd_sc_hd__clkbuf_8
XFILLER_0_16_363 VGND VGND VPWR VPWR sky130_fd_sc_hd__fill_1
X_7528_ net688 _3416_ _3716_ VGND VGND VPWR VPWR _3720_ sky130_fd_sc_hd__mux2_1
XFILLER_0_31_333 VGND VGND VPWR VPWR sky130_fd_sc_hd__decap_3
X_7459_ _3682_ VGND VGND VPWR VPWR _0268_ sky130_fd_sc_hd__clkbuf_1
XTAP_TAPCELL_ROW_112_1600 VGND VPWR sky130_fd_sc_hd__tapvpwrvgnd_1
Xhold971 RF.reg_arr\[30\]\[1\] VGND VGND VPWR VPWR net1053 sky130_fd_sc_hd__dlygate4sd3_1
Xhold982 RF.reg_arr\[15\]\[12\] VGND VGND VPWR VPWR net1064 sky130_fd_sc_hd__dlygate4sd3_1
Xhold960 RF.reg_arr\[12\]\[10\] VGND VGND VPWR VPWR net1042 sky130_fd_sc_hd__dlygate4sd3_1
Xhold993 RF.reg_arr\[29\]\[17\] VGND VGND VPWR VPWR net1075 sky130_fd_sc_hd__dlygate4sd3_1
X_9129_ clknet_leaf_12_CLK _0362_ VGND VGND VPWR VPWR RF.reg_arr\[30\]\[11\] sky130_fd_sc_hd__dfxtp_1
XPHY_EDGE_ROW_26_Right_26 VGND VGND VPWR VPWR sky130_fd_sc_hd__decap_3
XTAP_TAPCELL_ROW_47_818 VGND VPWR sky130_fd_sc_hd__tapvpwrvgnd_1
XTAP_TAPCELL_ROW_63_1009 VGND VPWR sky130_fd_sc_hd__tapvpwrvgnd_1
XTAP_TAPCELL_ROW_27_575 VGND VPWR sky130_fd_sc_hd__tapvpwrvgnd_1
XFILLER_0_27_606 VGND VGND VPWR VPWR sky130_fd_sc_hd__fill_1
XFILLER_0_27_617 VGND VGND VPWR VPWR sky130_fd_sc_hd__decap_6
XFILLER_0_39_477 VGND VGND VPWR VPWR sky130_fd_sc_hd__decap_3
XFILLER_0_41_39 VGND VGND VPWR VPWR sky130_fd_sc_hd__decap_4
XFILLER_0_27_639 VGND VGND VPWR VPWR sky130_fd_sc_hd__fill_2
XPHY_EDGE_ROW_35_Right_35 VGND VGND VPWR VPWR sky130_fd_sc_hd__decap_3
XFILLER_0_54_414 VGND VGND VPWR VPWR sky130_fd_sc_hd__decap_6
Xclkbuf_leaf_72_CLK clknet_3_5__leaf_CLK VGND VGND VPWR VPWR clknet_leaf_72_CLK sky130_fd_sc_hd__clkbuf_8
XFILLER_0_50_675 VGND VGND VPWR VPWR sky130_fd_sc_hd__fill_1
XTAP_TAPCELL_ROW_74_1138 VGND VPWR sky130_fd_sc_hd__tapvpwrvgnd_1
XFILLER_0_5_39 VGND VGND VPWR VPWR sky130_fd_sc_hd__decap_6
XPHY_EDGE_ROW_44_Right_44 VGND VGND VPWR VPWR sky130_fd_sc_hd__decap_3
XFILLER_0_89_300 VGND VGND VPWR VPWR sky130_fd_sc_hd__decap_8
XFILLER_0_77_528 VPWR VGND VPWR VGND sky130_ef_sc_hd__decap_12
X_6830_ _3332_ VGND VGND VPWR VPWR _1013_ sky130_fd_sc_hd__clkbuf_1
XTAP_TAPCELL_ROW_85_1267 VGND VPWR sky130_fd_sc_hd__tapvpwrvgnd_1
X_6761_ _3295_ VGND VGND VPWR VPWR _0981_ sky130_fd_sc_hd__clkbuf_1
X_8500_ net543 net29 _2977_ VGND VGND VPWR VPWR _4234_ sky130_fd_sc_hd__mux2_1
X_5712_ _2021_ _1829_ _1736_ _1112_ _2447_ VGND VGND VPWR VPWR _2497_ sky130_fd_sc_hd__a41o_1
XPHY_EDGE_ROW_53_Right_53 VGND VGND VPWR VPWR sky130_fd_sc_hd__decap_3
X_6692_ _3107_ net1096 _3254_ VGND VGND VPWR VPWR _3258_ sky130_fd_sc_hd__mux2_1
X_9480_ clknet_leaf_12_CLK _0713_ VGND VGND VPWR VPWR RF.reg_arr\[11\]\[10\] sky130_fd_sc_hd__dfxtp_1
X_5643_ _2200_ VGND VGND VPWR VPWR _2430_ sky130_fd_sc_hd__buf_2
X_8431_ _4198_ VGND VGND VPWR VPWR _0724_ sky130_fd_sc_hd__clkbuf_1
XFILLER_0_45_447 VGND VGND VPWR VPWR sky130_fd_sc_hd__fill_1
X_5574_ _2353_ _2360_ _2361_ VGND VGND VPWR VPWR _2362_ sky130_fd_sc_hd__mux2_1
X_8362_ _3042_ net865 _4160_ VGND VGND VPWR VPWR _4162_ sky130_fd_sc_hd__mux2_1
XFILLER_0_72_288 VGND VGND VPWR VPWR sky130_fd_sc_hd__decap_3
Xclkbuf_leaf_63_CLK clknet_3_6__leaf_CLK VGND VGND VPWR VPWR clknet_leaf_63_CLK sky130_fd_sc_hd__clkbuf_8
X_4525_ _1282_ _1313_ _1163_ VGND VGND VPWR VPWR _1314_ sky130_fd_sc_hd__o21ai_1
X_7313_ _3604_ VGND VGND VPWR VPWR _0200_ sky130_fd_sc_hd__clkbuf_1
Xhold201 RF.reg_arr\[11\]\[9\] VGND VGND VPWR VPWR net283 sky130_fd_sc_hd__dlygate4sd3_1
Xhold223 RF.reg_arr\[1\]\[29\] VGND VGND VPWR VPWR net305 sky130_fd_sc_hd__dlygate4sd3_1
Xhold234 RF.reg_arr\[17\]\[27\] VGND VGND VPWR VPWR net316 sky130_fd_sc_hd__dlygate4sd3_1
Xhold212 RF.reg_arr\[17\]\[23\] VGND VGND VPWR VPWR net294 sky130_fd_sc_hd__dlygate4sd3_1
X_8293_ _4125_ VGND VGND VPWR VPWR _0659_ sky130_fd_sc_hd__clkbuf_1
XFILLER_0_40_141 VGND VGND VPWR VPWR sky130_fd_sc_hd__fill_1
Xhold267 RF.reg_arr\[28\]\[26\] VGND VGND VPWR VPWR net349 sky130_fd_sc_hd__dlygate4sd3_1
Xhold245 RF.reg_arr\[18\]\[28\] VGND VGND VPWR VPWR net327 sky130_fd_sc_hd__dlygate4sd3_1
Xhold256 RF.reg_arr\[24\]\[22\] VGND VGND VPWR VPWR net338 sky130_fd_sc_hd__dlygate4sd3_1
XPHY_EDGE_ROW_62_Right_62 VGND VGND VPWR VPWR sky130_fd_sc_hd__decap_3
Xhold278 RF.reg_arr\[4\]\[2\] VGND VGND VPWR VPWR net360 sky130_fd_sc_hd__dlygate4sd3_1
X_7244_ _3077_ net780 _3558_ VGND VGND VPWR VPWR _3568_ sky130_fd_sc_hd__mux2_1
X_4456_ _1243_ _1244_ _1033_ VGND VGND VPWR VPWR _1245_ sky130_fd_sc_hd__mux2_1
Xhold289 RF.reg_arr\[22\]\[23\] VGND VGND VPWR VPWR net371 sky130_fd_sc_hd__dlygate4sd3_1
X_7175_ net464 _3407_ _3521_ VGND VGND VPWR VPWR _3531_ sky130_fd_sc_hd__mux2_1
X_4387_ _1135_ VGND VGND VPWR VPWR _1176_ sky130_fd_sc_hd__clkbuf_4
X_6126_ net87 _2888_ VGND VGND VPWR VPWR _2889_ sky130_fd_sc_hd__xnor2_1
X_6057_ _2521_ _2823_ VGND VGND VPWR VPWR _2824_ sky130_fd_sc_hd__nor2_1
X_5008_ RF.reg_arr\[24\]\[25\] RF.reg_arr\[25\]\[25\] RF.reg_arr\[26\]\[25\] RF.reg_arr\[27\]\[25\]
+ _1677_ _1683_ VGND VGND VPWR VPWR _1797_ sky130_fd_sc_hd__mux4_1
XPHY_EDGE_ROW_71_Right_71 VGND VGND VPWR VPWR sky130_fd_sc_hd__decap_3
X_6959_ _3388_ VGND VGND VPWR VPWR _3410_ sky130_fd_sc_hd__clkbuf_8
XTAP_TAPCELL_ROW_24_534 VGND VPWR sky130_fd_sc_hd__tapvpwrvgnd_1
XTAP_TAPCELL_ROW_24_545 VGND VPWR sky130_fd_sc_hd__tapvpwrvgnd_1
XFILLER_0_48_230 VGND VGND VPWR VPWR sky130_fd_sc_hd__fill_1
XTAP_TAPCELL_ROW_52_876 VGND VPWR sky130_fd_sc_hd__tapvpwrvgnd_1
XFILLER_0_106_313 VGND VGND VPWR VPWR sky130_fd_sc_hd__fill_1
X_8629_ clknet_leaf_16_CLK _0886_ VGND VGND VPWR VPWR RF.reg_arr\[16\]\[23\] sky130_fd_sc_hd__dfxtp_1
XFILLER_0_106_335 VGND VGND VPWR VPWR sky130_fd_sc_hd__decap_8
Xclkbuf_leaf_54_CLK clknet_3_6__leaf_CLK VGND VGND VPWR VPWR clknet_leaf_54_CLK sky130_fd_sc_hd__clkbuf_8
XPHY_EDGE_ROW_15_Left_132 VGND VGND VPWR VPWR sky130_fd_sc_hd__decap_3
XPHY_EDGE_ROW_80_Right_80 VGND VGND VPWR VPWR sky130_fd_sc_hd__decap_3
XFILLER_0_102_552 VGND VGND VPWR VPWR sky130_fd_sc_hd__fill_1
XFILLER_0_31_163 VGND VGND VPWR VPWR sky130_fd_sc_hd__decap_4
Xhold790 RF.reg_arr\[25\]\[25\] VGND VGND VPWR VPWR net872 sky130_fd_sc_hd__dlygate4sd3_1
XFILLER_0_98_141 VGND VGND VPWR VPWR sky130_fd_sc_hd__decap_4
XPHY_EDGE_ROW_24_Left_141 VGND VGND VPWR VPWR sky130_fd_sc_hd__decap_3
XFILLER_0_86_325 VGND VGND VPWR VPWR sky130_fd_sc_hd__decap_6
XFILLER_0_52_27 VGND VGND VPWR VPWR sky130_fd_sc_hd__fill_1
XFILLER_0_54_200 VGND VGND VPWR VPWR sky130_fd_sc_hd__fill_1
XPHY_EDGE_ROW_33_Left_150 VGND VGND VPWR VPWR sky130_fd_sc_hd__decap_3
Xclkbuf_leaf_45_CLK clknet_3_6__leaf_CLK VGND VGND VPWR VPWR clknet_leaf_45_CLK sky130_fd_sc_hd__clkbuf_8
XFILLER_0_22_141 VGND VGND VPWR VPWR sky130_fd_sc_hd__decap_6
X_5290_ RF.reg_arr\[4\]\[11\] RF.reg_arr\[5\]\[11\] RF.reg_arr\[6\]\[11\] RF.reg_arr\[7\]\[11\]
+ _1884_ _1886_ VGND VGND VPWR VPWR _2079_ sky130_fd_sc_hd__mux4_1
X_4310_ _1095_ _1096_ _1097_ _1098_ _1041_ _1061_ VGND VGND VPWR VPWR _1099_ sky130_fd_sc_hd__mux4_2
X_4241_ RF.reg_arr\[20\]\[5\] RF.reg_arr\[21\]\[5\] RF.reg_arr\[22\]\[5\] RF.reg_arr\[23\]\[5\]
+ _1027_ _1029_ VGND VGND VPWR VPWR _1030_ sky130_fd_sc_hd__mux4_1
X_8980_ clknet_leaf_63_CLK _0213_ VGND VGND VPWR VPWR RF.reg_arr\[31\]\[22\] sky130_fd_sc_hd__dfxtp_1
X_7931_ _3018_ net427 _3933_ VGND VGND VPWR VPWR _3934_ sky130_fd_sc_hd__mux2_1
XFILLER_0_26_83 VGND VGND VPWR VPWR sky130_fd_sc_hd__fill_1
XFILLER_0_26_94 VGND VGND VPWR VPWR sky130_fd_sc_hd__decap_4
X_7862_ _3885_ VGND VGND VPWR VPWR _3897_ sky130_fd_sc_hd__clkbuf_8
XFILLER_0_9_113 VGND VGND VPWR VPWR sky130_fd_sc_hd__decap_4
X_6813_ _3323_ VGND VGND VPWR VPWR _1005_ sky130_fd_sc_hd__clkbuf_1
X_7793_ _3848_ VGND VGND VPWR VPWR _3860_ sky130_fd_sc_hd__clkbuf_8
X_6744_ _3286_ VGND VGND VPWR VPWR _0973_ sky130_fd_sc_hd__clkbuf_1
X_9463_ clknet_leaf_42_CLK _0696_ VGND VGND VPWR VPWR RF.reg_arr\[12\]\[25\] sky130_fd_sc_hd__dfxtp_1
X_6675_ _3090_ net614 _3243_ VGND VGND VPWR VPWR _3249_ sky130_fd_sc_hd__mux2_1
XTAP_TAPCELL_ROW_21_504 VGND VPWR sky130_fd_sc_hd__tapvpwrvgnd_1
XFILLER_0_42_82 VGND VGND VPWR VPWR sky130_fd_sc_hd__fill_2
XFILLER_0_115_110 VGND VGND VPWR VPWR sky130_fd_sc_hd__fill_2
XTAP_TAPCELL_ROW_98_1425 VGND VPWR sky130_fd_sc_hd__tapvpwrvgnd_1
XFILLER_0_91_3 VGND VGND VPWR VPWR sky130_fd_sc_hd__decap_8
X_5626_ _2200_ _2408_ _2413_ VGND VGND VPWR VPWR _2414_ sky130_fd_sc_hd__a21bo_1
X_8414_ _4189_ VGND VGND VPWR VPWR _0716_ sky130_fd_sc_hd__clkbuf_1
Xclkbuf_leaf_36_CLK clknet_3_3__leaf_CLK VGND VGND VPWR VPWR clknet_leaf_36_CLK sky130_fd_sc_hd__clkbuf_8
XFILLER_0_103_305 VGND VGND VPWR VPWR sky130_fd_sc_hd__fill_2
X_9394_ clknet_leaf_16_CLK _0627_ VGND VGND VPWR VPWR RF.reg_arr\[13\]\[20\] sky130_fd_sc_hd__dfxtp_1
X_5557_ _2028_ _2344_ VGND VGND VPWR VPWR _2345_ sky130_fd_sc_hd__xnor2_1
X_8345_ _3025_ net853 _4149_ VGND VGND VPWR VPWR _4153_ sky130_fd_sc_hd__mux2_1
X_4508_ _1294_ _1295_ _1296_ VGND VGND VPWR VPWR _1297_ sky130_fd_sc_hd__mux2_1
X_8276_ _4116_ VGND VGND VPWR VPWR _0651_ sky130_fd_sc_hd__clkbuf_1
X_5488_ RF.reg_arr\[20\]\[3\] RF.reg_arr\[21\]\[3\] RF.reg_arr\[22\]\[3\] RF.reg_arr\[23\]\[3\]
+ _1622_ _1595_ VGND VGND VPWR VPWR _2277_ sky130_fd_sc_hd__mux4_1
X_4439_ _1224_ _1225_ _1226_ _1227_ _1075_ _1061_ VGND VGND VPWR VPWR _1228_ sky130_fd_sc_hd__mux4_2
X_7227_ _3559_ VGND VGND VPWR VPWR _0159_ sky130_fd_sc_hd__clkbuf_1
XFILLER_0_111_393 VGND VGND VPWR VPWR sky130_fd_sc_hd__fill_1
X_7158_ _3522_ VGND VGND VPWR VPWR _0127_ sky130_fd_sc_hd__clkbuf_1
X_6109_ _2868_ _2871_ VGND VGND VPWR VPWR _2873_ sky130_fd_sc_hd__nand2_1
X_7089_ net184 _3387_ _3485_ VGND VGND VPWR VPWR _3486_ sky130_fd_sc_hd__mux2_1
XTAP_TAPCELL_ROW_29_604 VGND VPWR sky130_fd_sc_hd__tapvpwrvgnd_1
XTAP_TAPCELL_ROW_57_935 VGND VPWR sky130_fd_sc_hd__tapvpwrvgnd_1
XTAP_TAPCELL_ROW_107_1532 VGND VPWR sky130_fd_sc_hd__tapvpwrvgnd_1
XFILLER_0_96_601 VPWR VGND VPWR VGND sky130_ef_sc_hd__decap_12
XFILLER_0_68_314 VGND VGND VPWR VPWR sky130_fd_sc_hd__fill_1
XFILLER_0_96_645 VGND VGND VPWR VPWR sky130_fd_sc_hd__decap_4
XTAP_TAPCELL_ROW_1_262 VGND VPWR sky130_fd_sc_hd__tapvpwrvgnd_1
XTAP_TAPCELL_ROW_37_692 VGND VPWR sky130_fd_sc_hd__tapvpwrvgnd_1
XFILLER_0_36_211 VGND VGND VPWR VPWR sky130_fd_sc_hd__fill_1
XFILLER_0_106_132 VGND VGND VPWR VPWR sky130_fd_sc_hd__decap_8
XFILLER_0_8_190 VGND VGND VPWR VPWR sky130_fd_sc_hd__decap_3
Xclkbuf_leaf_27_CLK clknet_3_2__leaf_CLK VGND VGND VPWR VPWR clknet_leaf_27_CLK sky130_fd_sc_hd__clkbuf_8
XFILLER_0_102_371 VGND VGND VPWR VPWR sky130_fd_sc_hd__fill_1
XTAP_TAPCELL_ROW_71_1108 VGND VPWR sky130_fd_sc_hd__tapvpwrvgnd_1
XFILLER_0_20_645 VGND VGND VPWR VPWR sky130_fd_sc_hd__decap_4
XTAP_TAPCELL_ROW_9_362 VGND VPWR sky130_fd_sc_hd__tapvpwrvgnd_1
XFILLER_0_2_29 VPWR VGND VPWR VGND sky130_ef_sc_hd__decap_12
XFILLER_0_86_155 VGND VGND VPWR VPWR sky130_fd_sc_hd__decap_4
XTAP_TAPCELL_ROW_82_1237 VGND VPWR sky130_fd_sc_hd__tapvpwrvgnd_1
X_4790_ _1284_ _1574_ _1576_ _1578_ _1163_ VGND VGND VPWR VPWR _1579_ sky130_fd_sc_hd__o221a_1
XFILLER_0_27_211 VGND VGND VPWR VPWR sky130_fd_sc_hd__decap_8
XANTENNA_18 _3944_ VGND VGND VPWR VPWR sky130_fd_sc_hd__diode_2
XFILLER_0_12_52 VGND VGND VPWR VPWR sky130_fd_sc_hd__decap_4
Xclkbuf_leaf_18_CLK clknet_3_0__leaf_CLK VGND VGND VPWR VPWR clknet_leaf_18_CLK sky130_fd_sc_hd__clkbuf_8
XFILLER_0_12_85 VGND VGND VPWR VPWR sky130_fd_sc_hd__decap_8
X_6460_ net127 VGND VGND VPWR VPWR _3135_ sky130_fd_sc_hd__clkbuf_1
XFILLER_0_112_124 VGND VGND VPWR VPWR sky130_fd_sc_hd__decap_4
X_5411_ _2049_ _1830_ VGND VGND VPWR VPWR _2200_ sky130_fd_sc_hd__nor2_2
XFILLER_0_70_589 VGND VGND VPWR VPWR sky130_fd_sc_hd__fill_1
X_6391_ net21 VGND VGND VPWR VPWR _3092_ sky130_fd_sc_hd__clkbuf_2
XFILLER_0_42_269 VGND VGND VPWR VPWR sky130_fd_sc_hd__fill_2
X_5342_ _2127_ _2130_ _1635_ VGND VGND VPWR VPWR _2131_ sky130_fd_sc_hd__mux2_1
X_8130_ net432 _3405_ _4030_ VGND VGND VPWR VPWR _4039_ sky130_fd_sc_hd__mux2_1
XTAP_TAPCELL_ROW_93_1366 VGND VPWR sky130_fd_sc_hd__tapvpwrvgnd_1
X_8061_ _4002_ VGND VGND VPWR VPWR _0550_ sky130_fd_sc_hd__clkbuf_1
X_7012_ net675 _3381_ _3431_ VGND VGND VPWR VPWR _3444_ sky130_fd_sc_hd__mux2_1
X_5273_ _1636_ _2061_ VGND VGND VPWR VPWR _2062_ sky130_fd_sc_hd__nand2_1
X_8963_ clknet_leaf_75_CLK _0196_ VGND VGND VPWR VPWR RF.reg_arr\[31\]\[5\] sky130_fd_sc_hd__dfxtp_1
X_7914_ _3002_ net196 _3922_ VGND VGND VPWR VPWR _3925_ sky130_fd_sc_hd__mux2_1
X_8894_ clknet_leaf_66_CLK _0127_ VGND VGND VPWR VPWR RF.reg_arr\[7\]\[0\] sky130_fd_sc_hd__dfxtp_1
XTAP_TAPCELL_ROW_54_905 VGND VPWR sky130_fd_sc_hd__tapvpwrvgnd_1
XFILLER_0_93_615 VGND VGND VPWR VPWR sky130_fd_sc_hd__fill_1
XFILLER_0_78_689 VGND VGND VPWR VPWR sky130_fd_sc_hd__decap_3
X_7845_ _3888_ VGND VGND VPWR VPWR _0448_ sky130_fd_sc_hd__clkbuf_1
X_4988_ RF.reg_arr\[16\]\[24\] RF.reg_arr\[17\]\[24\] RF.reg_arr\[18\]\[24\] RF.reg_arr\[19\]\[24\]
+ _1668_ _1669_ VGND VGND VPWR VPWR _1777_ sky130_fd_sc_hd__mux4_1
XFILLER_0_108_419 VGND VGND VPWR VPWR sky130_fd_sc_hd__fill_1
XTAP_TAPCELL_ROW_102_1473 VGND VPWR sky130_fd_sc_hd__tapvpwrvgnd_1
XTAP_TAPCELL_ROW_62_993 VGND VPWR sky130_fd_sc_hd__tapvpwrvgnd_1
X_7776_ _3851_ VGND VGND VPWR VPWR _0416_ sky130_fd_sc_hd__clkbuf_1
XTAP_TAPCELL_ROW_34_662 VGND VPWR sky130_fd_sc_hd__tapvpwrvgnd_1
X_9515_ clknet_leaf_92_CLK _0748_ VGND VGND VPWR VPWR RF.reg_arr\[10\]\[13\] sky130_fd_sc_hd__dfxtp_1
X_6727_ _3277_ VGND VGND VPWR VPWR _0965_ sky130_fd_sc_hd__clkbuf_1
XFILLER_0_46_586 VGND VGND VPWR VPWR sky130_fd_sc_hd__fill_2
XFILLER_0_104_614 VGND VGND VPWR VPWR sky130_fd_sc_hd__fill_1
XFILLER_0_18_288 VGND VGND VPWR VPWR sky130_fd_sc_hd__fill_2
X_6658_ _3073_ net908 _3232_ VGND VGND VPWR VPWR _3240_ sky130_fd_sc_hd__mux2_1
X_9446_ clknet_leaf_80_CLK _0679_ VGND VGND VPWR VPWR RF.reg_arr\[12\]\[8\] sky130_fd_sc_hd__dfxtp_1
XFILLER_0_103_113 VGND VGND VPWR VPWR sky130_fd_sc_hd__decap_4
X_5609_ _1700_ _2193_ VGND VGND VPWR VPWR _2397_ sky130_fd_sc_hd__or2_1
X_9377_ clknet_leaf_65_CLK _0610_ VGND VGND VPWR VPWR RF.reg_arr\[13\]\[3\] sky130_fd_sc_hd__dfxtp_1
X_8328_ _3008_ net1103 _4138_ VGND VGND VPWR VPWR _4144_ sky130_fd_sc_hd__mux2_1
X_6589_ _3203_ VGND VGND VPWR VPWR _0901_ sky130_fd_sc_hd__clkbuf_1
XFILLER_0_112_691 VGND VGND VPWR VPWR sky130_fd_sc_hd__fill_1
X_8259_ _4107_ VGND VGND VPWR VPWR _0643_ sky130_fd_sc_hd__clkbuf_1
XTAP_TAPCELL_ROW_6_321 VGND VPWR sky130_fd_sc_hd__tapvpwrvgnd_1
XFILLER_0_17_19 VPWR VGND VPWR VGND sky130_ef_sc_hd__decap_12
XTAP_TAPCELL_ROW_68_1070 VGND VPWR sky130_fd_sc_hd__tapvpwrvgnd_1
XFILLER_0_96_475 VGND VGND VPWR VPWR sky130_fd_sc_hd__fill_1
XFILLER_0_84_626 VGND VGND VPWR VPWR sky130_fd_sc_hd__fill_2
XFILLER_0_84_615 VGND VGND VPWR VPWR sky130_fd_sc_hd__decap_3
Xinput27 WD3[21] VGND VGND VPWR VPWR net27 sky130_fd_sc_hd__dlymetal6s2s_1
XFILLER_0_64_383 VGND VGND VPWR VPWR sky130_fd_sc_hd__fill_1
Xinput16 WD3[11] VGND VGND VPWR VPWR net16 sky130_fd_sc_hd__clkbuf_2
Xinput38 WD3[31] VGND VGND VPWR VPWR net38 sky130_fd_sc_hd__buf_1
XFILLER_0_52_578 VGND VGND VPWR VPWR sky130_fd_sc_hd__fill_1
XFILLER_0_52_589 VGND VGND VPWR VPWR sky130_fd_sc_hd__decap_3
XFILLER_0_110_639 VGND VGND VPWR VPWR sky130_fd_sc_hd__decap_4
XFILLER_0_20_431 VGND VGND VPWR VPWR sky130_fd_sc_hd__fill_1
XFILLER_0_74_36 VGND VGND VPWR VPWR sky130_fd_sc_hd__fill_1
Xclkbuf_leaf_7_CLK clknet_3_0__leaf_CLK VGND VGND VPWR VPWR clknet_leaf_7_CLK sky130_fd_sc_hd__clkbuf_8
X_5960_ _2157_ _2699_ VGND VGND VPWR VPWR _2733_ sky130_fd_sc_hd__and2_1
X_4911_ _1699_ VGND VGND VPWR VPWR _1700_ sky130_fd_sc_hd__buf_2
X_5891_ _1499_ _2447_ VGND VGND VPWR VPWR _2667_ sky130_fd_sc_hd__nor2_1
X_7630_ _3773_ VGND VGND VPWR VPWR _0348_ sky130_fd_sc_hd__clkbuf_1
X_4842_ RF.reg_arr\[12\]\[31\] RF.reg_arr\[13\]\[31\] RF.reg_arr\[14\]\[31\] RF.reg_arr\[15\]\[31\]
+ _1627_ _1629_ VGND VGND VPWR VPWR _1631_ sky130_fd_sc_hd__mux4_1
XFILLER_0_23_51 VGND VGND VPWR VPWR sky130_fd_sc_hd__decap_4
X_7561_ net199 _3381_ _3727_ VGND VGND VPWR VPWR _3737_ sky130_fd_sc_hd__mux2_1
X_4773_ _1560_ _1561_ _1296_ VGND VGND VPWR VPWR _1562_ sky130_fd_sc_hd__mux2_1
XFILLER_0_62_309 VGND VGND VPWR VPWR sky130_fd_sc_hd__fill_1
XFILLER_0_28_586 VGND VGND VPWR VPWR sky130_fd_sc_hd__fill_2
XTAP_TAPCELL_ROW_31_621 VGND VPWR sky130_fd_sc_hd__tapvpwrvgnd_1
X_7492_ _3699_ VGND VGND VPWR VPWR _0284_ sky130_fd_sc_hd__clkbuf_1
X_6512_ net364 _3002_ _3160_ VGND VGND VPWR VPWR _3163_ sky130_fd_sc_hd__mux2_1
X_9300_ clknet_leaf_45_CLK _0533_ VGND VGND VPWR VPWR RF.reg_arr\[25\]\[22\] sky130_fd_sc_hd__dfxtp_1
XFILLER_0_15_203 VGND VGND VPWR VPWR sky130_fd_sc_hd__decap_4
X_6443_ _3126_ VGND VGND VPWR VPWR _0832_ sky130_fd_sc_hd__clkbuf_1
X_9231_ clknet_leaf_106_CLK _0464_ VGND VGND VPWR VPWR RF.reg_arr\[22\]\[17\] sky130_fd_sc_hd__dfxtp_1
XFILLER_0_3_653 VPWR VGND VPWR VGND sky130_ef_sc_hd__decap_12
XFILLER_0_113_466 VGND VGND VPWR VPWR sky130_fd_sc_hd__fill_1
XFILLER_0_101_617 VGND VGND VPWR VPWR sky130_fd_sc_hd__fill_1
X_9162_ clknet_leaf_96_CLK _0395_ VGND VGND VPWR VPWR RF.reg_arr\[9\]\[12\] sky130_fd_sc_hd__dfxtp_1
X_6374_ _3079_ net793 _3080_ VGND VGND VPWR VPWR _3081_ sky130_fd_sc_hd__mux2_1
X_8113_ _4029_ VGND VGND VPWR VPWR _4030_ sky130_fd_sc_hd__buf_6
X_9093_ clknet_leaf_88_CLK _0326_ VGND VGND VPWR VPWR RF.reg_arr\[2\]\[7\] sky130_fd_sc_hd__dfxtp_1
X_5325_ _2112_ _2113_ _1604_ VGND VGND VPWR VPWR _2114_ sky130_fd_sc_hd__mux2_1
X_5256_ _1584_ _2044_ VGND VGND VPWR VPWR _2045_ sky130_fd_sc_hd__and2b_1
X_8044_ _3702_ _3884_ VGND VGND VPWR VPWR _3993_ sky130_fd_sc_hd__nand2_4
X_5187_ RF.reg_arr\[4\]\[16\] RF.reg_arr\[5\]\[16\] RF.reg_arr\[6\]\[16\] RF.reg_arr\[7\]\[16\]
+ _1857_ _1860_ VGND VGND VPWR VPWR _1976_ sky130_fd_sc_hd__mux4_1
XTAP_TAPCELL_ROW_39_721 VGND VPWR sky130_fd_sc_hd__tapvpwrvgnd_1
X_8946_ clknet_leaf_15_CLK _0179_ VGND VGND VPWR VPWR RF.reg_arr\[29\]\[20\] sky130_fd_sc_hd__dfxtp_1
XTAP_TAPCELL_ROW_104_1502 VGND VPWR sky130_fd_sc_hd__tapvpwrvgnd_1
XFILLER_0_93_401 VGND VGND VPWR VPWR sky130_fd_sc_hd__decap_3
XFILLER_0_78_475 VGND VGND VPWR VPWR sky130_fd_sc_hd__fill_1
X_8877_ clknet_leaf_10_CLK _0110_ VGND VGND VPWR VPWR RF.reg_arr\[3\]\[15\] sky130_fd_sc_hd__dfxtp_1
X_7828_ _3878_ VGND VGND VPWR VPWR _0441_ sky130_fd_sc_hd__clkbuf_1
XFILLER_0_93_445 VGND VGND VPWR VPWR sky130_fd_sc_hd__decap_3
X_7759_ net139 _3375_ _3835_ VGND VGND VPWR VPWR _3842_ sky130_fd_sc_hd__mux2_1
XFILLER_0_74_670 VGND VGND VPWR VPWR sky130_fd_sc_hd__fill_1
XFILLER_0_19_586 VPWR VGND VPWR VGND sky130_ef_sc_hd__decap_12
X_9429_ clknet_leaf_16_CLK _0662_ VGND VGND VPWR VPWR RF.reg_arr\[17\]\[23\] sky130_fd_sc_hd__dfxtp_1
XTAP_TAPCELL_ROW_115_1631 VGND VPWR sky130_fd_sc_hd__tapvpwrvgnd_1
XFILLER_0_104_477 VGND VGND VPWR VPWR sky130_fd_sc_hd__decap_8
XFILLER_0_14_291 VGND VGND VPWR VPWR sky130_fd_sc_hd__decap_4
XFILLER_0_88_206 VGND VGND VPWR VPWR sky130_fd_sc_hd__decap_8
XFILLER_0_88_217 VGND VGND VPWR VPWR sky130_fd_sc_hd__decap_4
XFILLER_0_69_442 VGND VGND VPWR VPWR sky130_fd_sc_hd__decap_6
XFILLER_0_69_431 VGND VGND VPWR VPWR sky130_fd_sc_hd__fill_2
XFILLER_0_96_250 VGND VGND VPWR VPWR sky130_fd_sc_hd__fill_2
XTAP_TAPCELL_ROW_17_459 VGND VPWR sky130_fd_sc_hd__tapvpwrvgnd_1
XFILLER_0_56_158 VGND VGND VPWR VPWR sky130_fd_sc_hd__fill_2
XPHY_EDGE_ROW_7_Left_124 VGND VGND VPWR VPWR sky130_fd_sc_hd__decap_3
XFILLER_0_4_428 VGND VGND VPWR VPWR sky130_fd_sc_hd__decap_8
Xhold608 RF.reg_arr\[2\]\[17\] VGND VGND VPWR VPWR net690 sky130_fd_sc_hd__dlygate4sd3_1
Xhold619 RF.reg_arr\[22\]\[26\] VGND VGND VPWR VPWR net701 sky130_fd_sc_hd__dlygate4sd3_1
XFILLER_0_110_414 VGND VGND VPWR VPWR sky130_fd_sc_hd__decap_6
XFILLER_0_0_601 VPWR VGND VPWR VGND sky130_ef_sc_hd__decap_12
XFILLER_0_0_645 VPWR VGND VPWR VGND sky130_ef_sc_hd__decap_12
X_6090_ _2831_ VGND VGND VPWR VPWR _2855_ sky130_fd_sc_hd__inv_2
XTAP_TAPCELL_ROW_90_1336 VGND VPWR sky130_fd_sc_hd__tapvpwrvgnd_1
X_5110_ RF.reg_arr\[28\]\[20\] RF.reg_arr\[29\]\[20\] RF.reg_arr\[30\]\[20\] RF.reg_arr\[31\]\[20\]
+ _1848_ _1851_ VGND VGND VPWR VPWR _1899_ sky130_fd_sc_hd__mux4_1
X_5041_ _1829_ VGND VGND VPWR VPWR _1830_ sky130_fd_sc_hd__clkbuf_4
XFILLER_0_40_9 VGND VGND VPWR VPWR sky130_fd_sc_hd__decap_4
X_8800_ clknet_leaf_61_CLK _0033_ VGND VGND VPWR VPWR RF.reg_arr\[4\]\[2\] sky130_fd_sc_hd__dfxtp_1
X_8731_ clknet_leaf_28_CLK _0988_ VGND VGND VPWR VPWR RF.reg_arr\[14\]\[29\] sky130_fd_sc_hd__dfxtp_1
X_6992_ _3432_ VGND VGND VPWR VPWR _0051_ sky130_fd_sc_hd__clkbuf_1
XFILLER_0_19_6 VGND VGND VPWR VPWR sky130_fd_sc_hd__decap_3
X_5943_ _2715_ VGND VGND VPWR VPWR _2716_ sky130_fd_sc_hd__inv_2
X_8662_ clknet_leaf_50_CLK _0919_ VGND VGND VPWR VPWR RF.reg_arr\[8\]\[24\] sky130_fd_sc_hd__dfxtp_1
X_5874_ _2083_ _2637_ VGND VGND VPWR VPWR _2651_ sky130_fd_sc_hd__nor2_1
X_4825_ _1613_ VGND VGND VPWR VPWR _1614_ sky130_fd_sc_hd__buf_4
X_7613_ net268 _3433_ _3763_ VGND VGND VPWR VPWR _3765_ sky130_fd_sc_hd__mux2_1
X_8593_ clknet_leaf_12_CLK _0850_ VGND VGND VPWR VPWR RF.reg_arr\[0\]\[19\] sky130_fd_sc_hd__dfxtp_1
XFILLER_0_105_208 VGND VGND VPWR VPWR sky130_fd_sc_hd__fill_2
X_7544_ _3728_ VGND VGND VPWR VPWR _0307_ sky130_fd_sc_hd__clkbuf_1
X_4756_ RF.reg_arr\[4\]\[15\] RF.reg_arr\[5\]\[15\] RF.reg_arr\[6\]\[15\] RF.reg_arr\[7\]\[15\]
+ _1187_ _1189_ VGND VGND VPWR VPWR _1545_ sky130_fd_sc_hd__mux4_1
X_7475_ _3103_ net819 _3689_ VGND VGND VPWR VPWR _3691_ sky130_fd_sc_hd__mux2_1
X_4687_ RF.reg_arr\[12\]\[30\] RF.reg_arr\[13\]\[30\] RF.reg_arr\[14\]\[30\] RF.reg_arr\[15\]\[30\]
+ _1303_ _1305_ VGND VGND VPWR VPWR _1476_ sky130_fd_sc_hd__mux4_1
XFILLER_0_16_589 VGND VGND VPWR VPWR sky130_fd_sc_hd__decap_3
X_6426_ _3115_ net536 _3101_ VGND VGND VPWR VPWR _3116_ sky130_fd_sc_hd__mux2_1
XFILLER_0_70_194 VGND VGND VPWR VPWR sky130_fd_sc_hd__fill_2
XFILLER_0_3_461 VGND VGND VPWR VPWR sky130_fd_sc_hd__fill_1
X_9214_ clknet_leaf_74_CLK _0447_ VGND VGND VPWR VPWR RF.reg_arr\[22\]\[0\] sky130_fd_sc_hd__dfxtp_1
XFILLER_0_101_436 VPWR VGND VPWR VGND sky130_ef_sc_hd__decap_12
X_9145_ clknet_leaf_33_CLK _0378_ VGND VGND VPWR VPWR RF.reg_arr\[30\]\[27\] sky130_fd_sc_hd__dfxtp_1
X_6357_ net41 VGND VGND VPWR VPWR _3069_ sky130_fd_sc_hd__clkbuf_2
X_5308_ RF.reg_arr\[4\]\[8\] RF.reg_arr\[5\]\[8\] RF.reg_arr\[6\]\[8\] RF.reg_arr\[7\]\[8\]
+ _1847_ _1850_ VGND VGND VPWR VPWR _2097_ sky130_fd_sc_hd__mux4_1
X_9076_ clknet_leaf_62_CLK _0309_ VGND VGND VPWR VPWR RF.reg_arr\[28\]\[22\] sky130_fd_sc_hd__dfxtp_1
X_6288_ _3024_ VGND VGND VPWR VPWR _0779_ sky130_fd_sc_hd__clkbuf_1
XTAP_TAPCELL_ROW_110_1572 VGND VPWR sky130_fd_sc_hd__tapvpwrvgnd_1
X_8027_ _3984_ VGND VGND VPWR VPWR _0534_ sky130_fd_sc_hd__clkbuf_1
X_5239_ _1063_ _1723_ _1727_ _1731_ _1735_ VGND VGND VPWR VPWR _2028_ sky130_fd_sc_hd__a32oi_4
XFILLER_0_78_250 VGND VGND VPWR VPWR sky130_fd_sc_hd__fill_2
X_8929_ clknet_leaf_68_CLK _0162_ VGND VGND VPWR VPWR RF.reg_arr\[29\]\[3\] sky130_fd_sc_hd__dfxtp_1
XFILLER_0_109_503 VGND VGND VPWR VPWR sky130_fd_sc_hd__fill_1
XFILLER_0_66_445 VPWR VGND VPWR VGND sky130_ef_sc_hd__decap_12
XTAP_TAPCELL_ROW_14_418 VGND VPWR sky130_fd_sc_hd__tapvpwrvgnd_1
XFILLER_0_26_309 VGND VGND VPWR VPWR sky130_fd_sc_hd__fill_2
XFILLER_0_109_569 VGND VGND VPWR VPWR sky130_fd_sc_hd__fill_2
XFILLER_0_19_361 VGND VGND VPWR VPWR sky130_fd_sc_hd__decap_6
XFILLER_0_89_548 VGND VGND VPWR VPWR sky130_fd_sc_hd__fill_2
X_4610_ _1397_ _1398_ _1034_ VGND VGND VPWR VPWR _1399_ sky130_fd_sc_hd__mux2_1
XFILLER_0_115_517 VPWR VGND VPWR VGND sky130_ef_sc_hd__decap_12
XFILLER_0_112_3 VPWR VGND VPWR VGND sky130_ef_sc_hd__decap_12
X_5590_ _2198_ _2369_ _2377_ VGND VGND VPWR VPWR _2378_ sky130_fd_sc_hd__a21oi_1
XFILLER_0_88_9 VGND VGND VPWR VPWR sky130_fd_sc_hd__fill_2
X_4541_ RF.reg_arr\[0\]\[23\] RF.reg_arr\[1\]\[23\] RF.reg_arr\[2\]\[23\] RF.reg_arr\[3\]\[23\]
+ _1327_ _1328_ VGND VGND VPWR VPWR _1330_ sky130_fd_sc_hd__mux4_1
XFILLER_0_25_364 VPWR VGND VPWR VGND sky130_ef_sc_hd__decap_12
XFILLER_0_53_673 VGND VGND VPWR VPWR sky130_fd_sc_hd__fill_2
Xhold416 RF.reg_arr\[18\]\[2\] VGND VGND VPWR VPWR net498 sky130_fd_sc_hd__dlygate4sd3_1
Xhold427 RF.reg_arr\[28\]\[22\] VGND VGND VPWR VPWR net509 sky130_fd_sc_hd__dlygate4sd3_1
XFILLER_0_20_85 VGND VGND VPWR VPWR sky130_fd_sc_hd__fill_2
Xhold405 RF.reg_arr\[8\]\[18\] VGND VGND VPWR VPWR net487 sky130_fd_sc_hd__dlygate4sd3_1
X_4472_ RF.reg_arr\[8\]\[11\] RF.reg_arr\[9\]\[11\] RF.reg_arr\[10\]\[11\] RF.reg_arr\[11\]\[11\]
+ _1044_ _1046_ VGND VGND VPWR VPWR _1261_ sky130_fd_sc_hd__mux4_1
X_7260_ _3576_ VGND VGND VPWR VPWR _0175_ sky130_fd_sc_hd__clkbuf_1
XFILLER_0_52_194 VGND VGND VPWR VPWR sky130_fd_sc_hd__fill_2
X_6211_ _2709_ _2714_ _2928_ _2463_ _2968_ VGND VGND VPWR VPWR _2969_ sky130_fd_sc_hd__o221a_1
Xhold438 RF.reg_arr\[5\]\[23\] VGND VGND VPWR VPWR net520 sky130_fd_sc_hd__dlygate4sd3_1
Xhold449 RF.reg_arr\[18\]\[20\] VGND VGND VPWR VPWR net531 sky130_fd_sc_hd__dlygate4sd3_1
X_7191_ _3539_ VGND VGND VPWR VPWR _0143_ sky130_fd_sc_hd__clkbuf_1
X_6142_ _2890_ _2896_ _2902_ VGND VGND VPWR VPWR _2904_ sky130_fd_sc_hd__o21ai_1
XFILLER_0_21_570 VGND VGND VPWR VPWR sky130_fd_sc_hd__decap_8
X_6073_ _1115_ _1892_ _2364_ VGND VGND VPWR VPWR _2839_ sky130_fd_sc_hd__a21bo_1
X_5024_ RF.reg_arr\[20\]\[2\] RF.reg_arr\[21\]\[2\] RF.reg_arr\[22\]\[2\] RF.reg_arr\[23\]\[2\]
+ _1043_ _1083_ VGND VGND VPWR VPWR _1813_ sky130_fd_sc_hd__mux4_1
X_6975_ net323 _3420_ _3410_ VGND VGND VPWR VPWR _3421_ sky130_fd_sc_hd__mux2_1
XFILLER_0_48_412 VGND VGND VPWR VPWR sky130_fd_sc_hd__fill_2
X_5926_ _2157_ _2699_ VGND VGND VPWR VPWR _2700_ sky130_fd_sc_hd__xnor2_2
X_8714_ clknet_leaf_97_CLK _0971_ VGND VGND VPWR VPWR RF.reg_arr\[14\]\[12\] sky130_fd_sc_hd__dfxtp_1
XFILLER_0_48_445 VGND VGND VPWR VPWR sky130_fd_sc_hd__fill_2
X_8645_ clknet_leaf_84_CLK _0902_ VGND VGND VPWR VPWR RF.reg_arr\[8\]\[7\] sky130_fd_sc_hd__dfxtp_1
X_5857_ _2521_ _2634_ VGND VGND VPWR VPWR _2635_ sky130_fd_sc_hd__nor2_1
X_8576_ clknet_leaf_58_CLK _0833_ VGND VGND VPWR VPWR RF.reg_arr\[0\]\[2\] sky130_fd_sc_hd__dfxtp_1
X_4808_ _1596_ VGND VGND VPWR VPWR _1597_ sky130_fd_sc_hd__buf_4
XFILLER_0_28_191 VGND VGND VPWR VPWR sky130_fd_sc_hd__decap_4
X_5788_ _1159_ _1210_ _1214_ _1218_ _1222_ VGND VGND VPWR VPWR _2569_ sky130_fd_sc_hd__a32o_1
XFILLER_0_44_640 VGND VGND VPWR VPWR sky130_fd_sc_hd__fill_1
X_7527_ _3719_ VGND VGND VPWR VPWR _0299_ sky130_fd_sc_hd__clkbuf_1
X_4739_ _1168_ _1525_ _1527_ _1173_ VGND VGND VPWR VPWR _1528_ sky130_fd_sc_hd__o211a_1
XFILLER_0_43_194 VGND VGND VPWR VPWR sky130_fd_sc_hd__fill_2
X_7458_ _3086_ net938 _3678_ VGND VGND VPWR VPWR _3682_ sky130_fd_sc_hd__mux2_1
XTAP_TAPCELL_ROW_112_1601 VGND VPWR sky130_fd_sc_hd__tapvpwrvgnd_1
X_6409_ _3104_ VGND VGND VPWR VPWR _0820_ sky130_fd_sc_hd__clkbuf_1
Xhold961 RF.reg_arr\[26\]\[31\] VGND VGND VPWR VPWR net1043 sky130_fd_sc_hd__dlygate4sd3_1
Xhold972 RF.reg_arr\[27\]\[8\] VGND VGND VPWR VPWR net1054 sky130_fd_sc_hd__dlygate4sd3_1
X_7389_ _3086_ net810 _3641_ VGND VGND VPWR VPWR _3645_ sky130_fd_sc_hd__mux2_1
Xhold950 RF.reg_arr\[30\]\[3\] VGND VGND VPWR VPWR net1032 sky130_fd_sc_hd__dlygate4sd3_1
Xhold983 RF.reg_arr\[27\]\[7\] VGND VGND VPWR VPWR net1065 sky130_fd_sc_hd__dlygate4sd3_1
Xhold994 RF.reg_arr\[27\]\[5\] VGND VGND VPWR VPWR net1076 sky130_fd_sc_hd__dlygate4sd3_1
X_9128_ clknet_leaf_10_CLK _0361_ VGND VGND VPWR VPWR RF.reg_arr\[30\]\[10\] sky130_fd_sc_hd__dfxtp_1
X_9059_ clknet_leaf_74_CLK _0292_ VGND VGND VPWR VPWR RF.reg_arr\[28\]\[5\] sky130_fd_sc_hd__dfxtp_1
XTAP_TAPCELL_ROW_47_819 VGND VPWR sky130_fd_sc_hd__tapvpwrvgnd_1
XPHY_EDGE_ROW_88_Left_205 VGND VGND VPWR VPWR sky130_fd_sc_hd__decap_3
XTAP_TAPCELL_ROW_27_576 VGND VPWR sky130_fd_sc_hd__tapvpwrvgnd_1
XFILLER_0_66_253 VGND VGND VPWR VPWR sky130_fd_sc_hd__fill_1
XFILLER_0_66_275 VGND VGND VPWR VPWR sky130_fd_sc_hd__decap_6
XFILLER_0_109_399 VPWR VGND VPWR VGND sky130_ef_sc_hd__decap_12
XFILLER_0_41_109 VGND VGND VPWR VPWR sky130_fd_sc_hd__decap_3
XFILLER_0_105_561 VGND VGND VPWR VPWR sky130_fd_sc_hd__decap_8
XPHY_EDGE_ROW_97_Left_214 VGND VGND VPWR VPWR sky130_fd_sc_hd__decap_3
XFILLER_0_34_194 VGND VGND VPWR VPWR sky130_fd_sc_hd__fill_2
XTAP_TAPCELL_ROW_74_1139 VGND VPWR sky130_fd_sc_hd__tapvpwrvgnd_1
XFILLER_0_66_37 VGND VGND VPWR VPWR sky130_fd_sc_hd__decap_4
XFILLER_0_89_345 VGND VGND VPWR VPWR sky130_fd_sc_hd__decap_6
XFILLER_0_89_367 VGND VGND VPWR VPWR sky130_fd_sc_hd__fill_1
XTAP_TAPCELL_ROW_85_1268 VGND VPWR sky130_fd_sc_hd__tapvpwrvgnd_1
X_6760_ _3105_ net421 _3292_ VGND VGND VPWR VPWR _3295_ sky130_fd_sc_hd__mux2_1
X_5711_ _1092_ _2491_ _2495_ _2381_ _2443_ VGND VGND VPWR VPWR _2496_ sky130_fd_sc_hd__o221a_1
X_6691_ _3257_ VGND VGND VPWR VPWR _0949_ sky130_fd_sc_hd__clkbuf_1
XFILLER_0_115_314 VGND VGND VPWR VPWR sky130_fd_sc_hd__fill_2
X_5642_ _2428_ _2274_ _2276_ VGND VGND VPWR VPWR _2429_ sky130_fd_sc_hd__mux2_1
X_8430_ net185 _3433_ _4196_ VGND VGND VPWR VPWR _4198_ sky130_fd_sc_hd__mux2_1
X_5573_ _1830_ VGND VGND VPWR VPWR _2361_ sky130_fd_sc_hd__clkbuf_4
X_8361_ _4161_ VGND VGND VPWR VPWR _0691_ sky130_fd_sc_hd__clkbuf_1
XFILLER_0_72_278 VGND VGND VPWR VPWR sky130_fd_sc_hd__fill_1
X_4524_ _1311_ _1312_ _1281_ VGND VGND VPWR VPWR _1313_ sky130_fd_sc_hd__mux2_1
Xhold202 RF.reg_arr\[19\]\[30\] VGND VGND VPWR VPWR net284 sky130_fd_sc_hd__dlygate4sd3_1
XFILLER_0_5_578 VPWR VGND VPWR VGND sky130_ef_sc_hd__decap_12
X_7312_ _3077_ net798 _3594_ VGND VGND VPWR VPWR _3604_ sky130_fd_sc_hd__mux2_1
Xhold235 RF.reg_arr\[11\]\[22\] VGND VGND VPWR VPWR net317 sky130_fd_sc_hd__dlygate4sd3_1
X_8292_ net433 _3430_ _4124_ VGND VGND VPWR VPWR _4125_ sky130_fd_sc_hd__mux2_1
Xhold224 RF.reg_arr\[9\]\[1\] VGND VGND VPWR VPWR net306 sky130_fd_sc_hd__dlygate4sd3_1
Xhold213 RF.reg_arr\[2\]\[15\] VGND VGND VPWR VPWR net295 sky130_fd_sc_hd__dlygate4sd3_1
XFILLER_0_41_676 VGND VGND VPWR VPWR sky130_fd_sc_hd__fill_2
XFILLER_0_111_542 VPWR VGND VPWR VGND sky130_ef_sc_hd__decap_12
Xhold246 RF.reg_arr\[19\]\[27\] VGND VGND VPWR VPWR net328 sky130_fd_sc_hd__dlygate4sd3_1
Xhold268 RF.reg_arr\[6\]\[27\] VGND VGND VPWR VPWR net350 sky130_fd_sc_hd__dlygate4sd3_1
Xhold257 RF.reg_arr\[16\]\[25\] VGND VGND VPWR VPWR net339 sky130_fd_sc_hd__dlygate4sd3_1
X_7243_ _3567_ VGND VGND VPWR VPWR _0167_ sky130_fd_sc_hd__clkbuf_1
X_4455_ RF.reg_arr\[24\]\[10\] RF.reg_arr\[25\]\[10\] RF.reg_arr\[26\]\[10\] RF.reg_arr\[27\]\[10\]
+ _1026_ _1028_ VGND VGND VPWR VPWR _1244_ sky130_fd_sc_hd__mux4_1
Xhold279 RF.reg_arr\[5\]\[6\] VGND VGND VPWR VPWR net361 sky130_fd_sc_hd__dlygate4sd3_1
X_7174_ _3530_ VGND VGND VPWR VPWR _0135_ sky130_fd_sc_hd__clkbuf_1
X_4386_ _1134_ VGND VGND VPWR VPWR _1175_ sky130_fd_sc_hd__buf_8
X_6125_ _1581_ _2859_ _2759_ VGND VGND VPWR VPWR _2888_ sky130_fd_sc_hd__a21oi_1
X_6056_ _2688_ _2822_ _2022_ VGND VGND VPWR VPWR _2823_ sky130_fd_sc_hd__mux2_1
X_5007_ RF.reg_arr\[28\]\[25\] RF.reg_arr\[29\]\[25\] RF.reg_arr\[30\]\[25\] RF.reg_arr\[31\]\[25\]
+ _1677_ _1683_ VGND VGND VPWR VPWR _1796_ sky130_fd_sc_hd__mux4_1
XFILLER_0_95_337 VGND VGND VPWR VPWR sky130_fd_sc_hd__decap_4
XTAP_TAPCELL_ROW_24_535 VGND VPWR sky130_fd_sc_hd__tapvpwrvgnd_1
X_6958_ net15 VGND VGND VPWR VPWR _3409_ sky130_fd_sc_hd__buf_2
X_5909_ _2527_ _2586_ _2662_ _2433_ _2445_ VGND VGND VPWR VPWR _2684_ sky130_fd_sc_hd__o221a_1
X_6889_ net254 _3035_ _3355_ VGND VGND VPWR VPWR _3364_ sky130_fd_sc_hd__mux2_1
XFILLER_0_36_415 VGND VGND VPWR VPWR sky130_fd_sc_hd__decap_4
XTAP_TAPCELL_ROW_52_877 VGND VPWR sky130_fd_sc_hd__tapvpwrvgnd_1
X_8628_ clknet_leaf_60_CLK _0885_ VGND VGND VPWR VPWR RF.reg_arr\[16\]\[22\] sky130_fd_sc_hd__dfxtp_1
XFILLER_0_63_234 VGND VGND VPWR VPWR sky130_fd_sc_hd__fill_2
XFILLER_0_8_361 VGND VGND VPWR VPWR sky130_fd_sc_hd__decap_3
X_8559_ clknet_leaf_106_CLK _0816_ VGND VGND VPWR VPWR RF.reg_arr\[23\]\[17\] sky130_fd_sc_hd__dfxtp_1
XFILLER_0_17_673 VGND VGND VPWR VPWR sky130_fd_sc_hd__decap_8
Xhold791 RF.reg_arr\[13\]\[24\] VGND VGND VPWR VPWR net873 sky130_fd_sc_hd__dlygate4sd3_1
Xhold780 RF.reg_arr\[20\]\[20\] VGND VGND VPWR VPWR net862 sky130_fd_sc_hd__dlygate4sd3_1
XFILLER_0_6_3 VPWR VGND VPWR VGND sky130_ef_sc_hd__decap_12
XFILLER_0_99_687 VGND VGND VPWR VPWR sky130_fd_sc_hd__decap_4
XFILLER_0_59_529 VGND VGND VPWR VPWR sky130_fd_sc_hd__decap_3
XFILLER_0_98_197 VGND VGND VPWR VPWR sky130_fd_sc_hd__fill_1
XFILLER_0_52_17 VGND VGND VPWR VPWR sky130_fd_sc_hd__fill_1
XFILLER_0_82_598 VGND VGND VPWR VPWR sky130_fd_sc_hd__decap_8
XFILLER_0_82_576 VGND VGND VPWR VPWR sky130_fd_sc_hd__decap_4
XFILLER_0_14_109 VGND VGND VPWR VPWR sky130_fd_sc_hd__fill_2
XFILLER_0_2_515 VGND VGND VPWR VPWR sky130_fd_sc_hd__fill_1
XFILLER_0_22_120 VGND VGND VPWR VPWR sky130_fd_sc_hd__fill_2
XFILLER_0_23_654 VGND VGND VPWR VPWR sky130_fd_sc_hd__fill_1
XFILLER_0_50_440 VGND VGND VPWR VPWR sky130_fd_sc_hd__fill_1
XFILLER_0_22_197 VGND VGND VPWR VPWR sky130_fd_sc_hd__decap_8
X_4240_ _1028_ VGND VGND VPWR VPWR _1029_ sky130_fd_sc_hd__buf_4
X_7930_ _3921_ VGND VGND VPWR VPWR _3933_ sky130_fd_sc_hd__clkbuf_8
X_7861_ _3896_ VGND VGND VPWR VPWR _0456_ sky130_fd_sc_hd__clkbuf_1
XFILLER_0_77_337 VGND VGND VPWR VPWR sky130_fd_sc_hd__decap_4
X_6812_ net423 _3027_ _3318_ VGND VGND VPWR VPWR _3323_ sky130_fd_sc_hd__mux2_1
X_7792_ _3859_ VGND VGND VPWR VPWR _0424_ sky130_fd_sc_hd__clkbuf_1
X_6743_ _3088_ net959 _3281_ VGND VGND VPWR VPWR _3286_ sky130_fd_sc_hd__mux2_1
X_9462_ clknet_leaf_51_CLK _0695_ VGND VGND VPWR VPWR RF.reg_arr\[12\]\[24\] sky130_fd_sc_hd__dfxtp_1
XTAP_TAPCELL_ROW_21_505 VGND VPWR sky130_fd_sc_hd__tapvpwrvgnd_1
X_6674_ _3248_ VGND VGND VPWR VPWR _0941_ sky130_fd_sc_hd__clkbuf_1
XFILLER_0_116_645 VPWR VGND VPWR VGND sky130_ef_sc_hd__decap_12
XTAP_TAPCELL_ROW_98_1426 VGND VPWR sky130_fd_sc_hd__tapvpwrvgnd_1
X_5625_ _2385_ _2409_ _2412_ _2027_ VGND VGND VPWR VPWR _2413_ sky130_fd_sc_hd__a211o_1
X_8413_ net854 _3416_ _4185_ VGND VGND VPWR VPWR _4189_ sky130_fd_sc_hd__mux2_1
X_9393_ clknet_leaf_7_CLK _0626_ VGND VGND VPWR VPWR RF.reg_arr\[13\]\[19\] sky130_fd_sc_hd__dfxtp_1
X_5556_ _1100_ _1111_ _2343_ VGND VGND VPWR VPWR _2344_ sky130_fd_sc_hd__or3_1
XFILLER_0_14_654 VGND VGND VPWR VPWR sky130_fd_sc_hd__decap_4
X_8344_ _4152_ VGND VGND VPWR VPWR _0683_ sky130_fd_sc_hd__clkbuf_1
X_5487_ _2000_ VGND VGND VPWR VPWR _2276_ sky130_fd_sc_hd__clkbuf_4
X_4507_ _1168_ VGND VGND VPWR VPWR _1296_ sky130_fd_sc_hd__buf_4
X_8275_ net925 _3414_ _4113_ VGND VGND VPWR VPWR _4116_ sky130_fd_sc_hd__mux2_1
XFILLER_0_41_484 VPWR VGND VPWR VGND sky130_ef_sc_hd__decap_12
X_4438_ RF.reg_arr\[24\]\[9\] RF.reg_arr\[25\]\[9\] RF.reg_arr\[26\]\[9\] RF.reg_arr\[27\]\[9\]
+ _1105_ _1106_ VGND VGND VPWR VPWR _1227_ sky130_fd_sc_hd__mux4_1
X_7226_ _3056_ net807 _3558_ VGND VGND VPWR VPWR _3559_ sky130_fd_sc_hd__mux2_1
X_4369_ _1110_ VGND VGND VPWR VPWR _1158_ sky130_fd_sc_hd__clkbuf_8
X_7157_ net720 _3387_ _3521_ VGND VGND VPWR VPWR _3522_ sky130_fd_sc_hd__mux2_1
X_6108_ _2868_ _2871_ VGND VGND VPWR VPWR _2872_ sky130_fd_sc_hd__or2_1
X_7088_ _3484_ VGND VGND VPWR VPWR _3485_ sky130_fd_sc_hd__buf_4
X_6039_ _2776_ _2806_ _2001_ VGND VGND VPWR VPWR _2807_ sky130_fd_sc_hd__mux2_1
XTAP_TAPCELL_ROW_29_605 VGND VPWR sky130_fd_sc_hd__tapvpwrvgnd_1
XTAP_TAPCELL_ROW_57_936 VGND VPWR sky130_fd_sc_hd__tapvpwrvgnd_1
XTAP_TAPCELL_ROW_107_1533 VGND VPWR sky130_fd_sc_hd__tapvpwrvgnd_1
XFILLER_0_96_613 VGND VGND VPWR VPWR sky130_fd_sc_hd__decap_6
XFILLER_0_68_348 VGND VGND VPWR VPWR sky130_fd_sc_hd__decap_6
XFILLER_0_68_326 VGND VGND VPWR VPWR sky130_fd_sc_hd__fill_2
XTAP_TAPCELL_ROW_1_263 VGND VPWR sky130_fd_sc_hd__tapvpwrvgnd_1
XTAP_TAPCELL_ROW_37_693 VGND VPWR sky130_fd_sc_hd__tapvpwrvgnd_1
XFILLER_0_107_601 VGND VGND VPWR VPWR sky130_fd_sc_hd__fill_1
XFILLER_0_36_256 VPWR VGND VPWR VGND sky130_ef_sc_hd__decap_12
XTAP_TAPCELL_ROW_71_1109 VGND VPWR sky130_fd_sc_hd__tapvpwrvgnd_1
XTAP_TAPCELL_ROW_9_363 VGND VPWR sky130_fd_sc_hd__tapvpwrvgnd_1
XFILLER_0_87_602 VGND VGND VPWR VPWR sky130_fd_sc_hd__fill_2
XFILLER_0_86_101 VGND VGND VPWR VPWR sky130_fd_sc_hd__fill_2
XTAP_TAPCELL_ROW_82_1238 VGND VPWR sky130_fd_sc_hd__tapvpwrvgnd_1
XFILLER_0_74_307 VGND VGND VPWR VPWR sky130_fd_sc_hd__fill_1
XFILLER_0_67_370 VGND VGND VPWR VPWR sky130_fd_sc_hd__fill_2
XANTENNA_19 _4138_ VGND VGND VPWR VPWR sky130_fd_sc_hd__diode_2
XFILLER_0_55_543 VGND VGND VPWR VPWR sky130_fd_sc_hd__decap_8
XFILLER_0_103_66 VGND VGND VPWR VPWR sky130_fd_sc_hd__decap_3
XFILLER_0_103_55 VGND VGND VPWR VPWR sky130_fd_sc_hd__fill_1
XFILLER_0_27_278 VGND VGND VPWR VPWR sky130_fd_sc_hd__fill_2
XFILLER_0_113_626 VPWR VGND VPWR VGND sky130_ef_sc_hd__decap_12
XFILLER_0_113_615 VGND VGND VPWR VPWR sky130_fd_sc_hd__fill_1
X_5410_ _2124_ _2196_ _2198_ VGND VGND VPWR VPWR _2199_ sky130_fd_sc_hd__mux2_1
X_6390_ _3091_ VGND VGND VPWR VPWR _0814_ sky130_fd_sc_hd__clkbuf_1
XFILLER_0_2_334 VGND VGND VPWR VPWR sky130_fd_sc_hd__fill_1
X_5341_ _2128_ _2129_ _1864_ VGND VGND VPWR VPWR _2130_ sky130_fd_sc_hd__mux2_1
XFILLER_0_100_309 VPWR VGND VPWR VGND sky130_ef_sc_hd__decap_12
XTAP_TAPCELL_ROW_93_1367 VGND VPWR sky130_fd_sc_hd__tapvpwrvgnd_1
X_8060_ _3012_ net1099 _3994_ VGND VGND VPWR VPWR _4002_ sky130_fd_sc_hd__mux2_1
X_7011_ _3443_ VGND VGND VPWR VPWR _0059_ sky130_fd_sc_hd__clkbuf_1
X_5272_ _2059_ _2060_ _1854_ VGND VGND VPWR VPWR _2061_ sky130_fd_sc_hd__mux2_1
X_8962_ clknet_leaf_77_CLK _0195_ VGND VGND VPWR VPWR RF.reg_arr\[31\]\[4\] sky130_fd_sc_hd__dfxtp_1
X_7913_ _3924_ VGND VGND VPWR VPWR _0480_ sky130_fd_sc_hd__clkbuf_1
X_8893_ clknet_leaf_27_CLK _0126_ VGND VGND VPWR VPWR RF.reg_arr\[3\]\[31\] sky130_fd_sc_hd__dfxtp_1
XFILLER_0_78_635 VGND VGND VPWR VPWR sky130_fd_sc_hd__fill_1
XFILLER_0_78_668 VGND VGND VPWR VPWR sky130_fd_sc_hd__decap_3
X_7844_ _3061_ net790 _3886_ VGND VGND VPWR VPWR _3888_ sky130_fd_sc_hd__mux2_1
X_7775_ _3061_ net735 _3849_ VGND VGND VPWR VPWR _3851_ sky130_fd_sc_hd__mux2_1
X_4987_ RF.reg_arr\[20\]\[24\] RF.reg_arr\[21\]\[24\] RF.reg_arr\[22\]\[24\] RF.reg_arr\[23\]\[24\]
+ _1668_ _1669_ VGND VGND VPWR VPWR _1776_ sky130_fd_sc_hd__mux4_1
XTAP_TAPCELL_ROW_62_994 VGND VPWR sky130_fd_sc_hd__tapvpwrvgnd_1
X_6726_ _3071_ net1000 _3270_ VGND VGND VPWR VPWR _3277_ sky130_fd_sc_hd__mux2_1
X_9514_ clknet_leaf_96_CLK _0747_ VGND VGND VPWR VPWR RF.reg_arr\[10\]\[12\] sky130_fd_sc_hd__dfxtp_1
XTAP_TAPCELL_ROW_34_663 VGND VPWR sky130_fd_sc_hd__tapvpwrvgnd_1
XTAP_TAPCELL_ROW_102_1474 VGND VPWR sky130_fd_sc_hd__tapvpwrvgnd_1
XFILLER_0_18_278 VGND VGND VPWR VPWR sky130_fd_sc_hd__fill_1
X_9445_ clknet_leaf_84_CLK _0678_ VGND VGND VPWR VPWR RF.reg_arr\[12\]\[7\] sky130_fd_sc_hd__dfxtp_1
X_6657_ _3239_ VGND VGND VPWR VPWR _0933_ sky130_fd_sc_hd__clkbuf_1
X_5608_ _2394_ _2395_ VGND VGND VPWR VPWR _2396_ sky130_fd_sc_hd__nand2_1
X_6588_ net948 _3010_ _3196_ VGND VGND VPWR VPWR _3203_ sky130_fd_sc_hd__mux2_1
X_9376_ clknet_leaf_67_CLK _0609_ VGND VGND VPWR VPWR RF.reg_arr\[13\]\[2\] sky130_fd_sc_hd__dfxtp_1
X_5539_ _2326_ _2327_ _1609_ VGND VGND VPWR VPWR _2328_ sky130_fd_sc_hd__mux2_1
X_8327_ _4143_ VGND VGND VPWR VPWR _0675_ sky130_fd_sc_hd__clkbuf_1
X_8258_ net927 _3397_ _4102_ VGND VGND VPWR VPWR _4107_ sky130_fd_sc_hd__mux2_1
XPHY_EDGE_ROW_52_Left_169 VGND VGND VPWR VPWR sky130_fd_sc_hd__decap_3
X_7209_ net251 _3373_ _3543_ VGND VGND VPWR VPWR _3549_ sky130_fd_sc_hd__mux2_1
XTAP_TAPCELL_ROW_6_322 VGND VPWR sky130_fd_sc_hd__tapvpwrvgnd_1
X_8189_ _4070_ VGND VGND VPWR VPWR _0610_ sky130_fd_sc_hd__clkbuf_1
XTAP_TAPCELL_ROW_68_1071 VGND VPWR sky130_fd_sc_hd__tapvpwrvgnd_1
XPHY_EDGE_ROW_61_Left_178 VGND VGND VPWR VPWR sky130_fd_sc_hd__decap_3
XFILLER_0_96_487 VGND VGND VPWR VPWR sky130_fd_sc_hd__fill_2
XFILLER_0_56_329 VGND VGND VPWR VPWR sky130_fd_sc_hd__decap_6
XFILLER_0_107_420 VPWR VGND VPWR VGND sky130_ef_sc_hd__decap_12
Xinput28 WD3[22] VGND VGND VPWR VPWR net28 sky130_fd_sc_hd__clkbuf_2
Xinput17 WD3[12] VGND VGND VPWR VPWR net17 sky130_fd_sc_hd__buf_1
Xinput39 WD3[3] VGND VGND VPWR VPWR net39 sky130_fd_sc_hd__buf_1
XPHY_EDGE_ROW_70_Left_187 VGND VGND VPWR VPWR sky130_fd_sc_hd__decap_3
XFILLER_0_110_607 VGND VGND VPWR VPWR sky130_fd_sc_hd__decap_8
XFILLER_0_103_670 VGND VGND VPWR VPWR sky130_fd_sc_hd__fill_2
XFILLER_0_20_421 VGND VGND VPWR VPWR sky130_fd_sc_hd__fill_1
XFILLER_0_20_465 VGND VGND VPWR VPWR sky130_fd_sc_hd__fill_1
XFILLER_0_20_487 VGND VGND VPWR VPWR sky130_fd_sc_hd__decap_6
X_5890_ _1416_ _2534_ _1271_ _2533_ VGND VGND VPWR VPWR _2666_ sky130_fd_sc_hd__or4_4
X_4910_ _1111_ _1100_ VGND VGND VPWR VPWR _1699_ sky130_fd_sc_hd__nor2_4
X_4841_ RF.reg_arr\[8\]\[31\] RF.reg_arr\[9\]\[31\] RF.reg_arr\[10\]\[31\] RF.reg_arr\[11\]\[31\]
+ _1627_ _1629_ VGND VGND VPWR VPWR _1630_ sky130_fd_sc_hd__mux4_1
XFILLER_0_87_487 VGND VGND VPWR VPWR sky130_fd_sc_hd__decap_8
XFILLER_0_87_476 VGND VGND VPWR VPWR sky130_fd_sc_hd__decap_4
XFILLER_0_47_329 VGND VGND VPWR VPWR sky130_fd_sc_hd__decap_6
X_7560_ _3736_ VGND VGND VPWR VPWR _0315_ sky130_fd_sc_hd__clkbuf_1
X_4772_ RF.reg_arr\[0\]\[25\] RF.reg_arr\[1\]\[25\] RF.reg_arr\[2\]\[25\] RF.reg_arr\[3\]\[25\]
+ _1302_ _1322_ VGND VGND VPWR VPWR _1561_ sky130_fd_sc_hd__mux4_1
XFILLER_0_83_671 VGND VGND VPWR VPWR sky130_fd_sc_hd__fill_1
XTAP_TAPCELL_ROW_31_622 VGND VPWR sky130_fd_sc_hd__tapvpwrvgnd_1
X_7491_ _3119_ net960 _3689_ VGND VGND VPWR VPWR _3699_ sky130_fd_sc_hd__mux2_1
X_6511_ _3162_ VGND VGND VPWR VPWR _0864_ sky130_fd_sc_hd__clkbuf_1
X_6442_ net110 VGND VGND VPWR VPWR _3126_ sky130_fd_sc_hd__clkbuf_1
XFILLER_0_3_621 VGND VGND VPWR VPWR sky130_fd_sc_hd__fill_1
XFILLER_0_43_557 VGND VGND VPWR VPWR sky130_fd_sc_hd__decap_3
X_9230_ clknet_leaf_6_CLK _0463_ VGND VGND VPWR VPWR RF.reg_arr\[22\]\[16\] sky130_fd_sc_hd__dfxtp_1
XFILLER_0_70_365 VGND VGND VPWR VPWR sky130_fd_sc_hd__decap_6
X_9161_ clknet_leaf_91_CLK _0394_ VGND VGND VPWR VPWR RF.reg_arr\[9\]\[11\] sky130_fd_sc_hd__dfxtp_1
XFILLER_0_101_607 VGND VGND VPWR VPWR sky130_fd_sc_hd__fill_1
X_8112_ _2971_ _3158_ VGND VGND VPWR VPWR _4029_ sky130_fd_sc_hd__nor2_2
XFILLER_0_3_665 VGND VGND VPWR VPWR sky130_fd_sc_hd__decap_6
XFILLER_0_23_281 VGND VGND VPWR VPWR sky130_fd_sc_hd__fill_1
X_6373_ _3058_ VGND VGND VPWR VPWR _3080_ sky130_fd_sc_hd__clkbuf_8
X_9092_ clknet_leaf_85_CLK _0325_ VGND VGND VPWR VPWR RF.reg_arr\[2\]\[6\] sky130_fd_sc_hd__dfxtp_1
X_5324_ RF.reg_arr\[12\]\[9\] RF.reg_arr\[13\]\[9\] RF.reg_arr\[14\]\[9\] RF.reg_arr\[15\]\[9\]
+ _1590_ _1835_ VGND VGND VPWR VPWR _2113_ sky130_fd_sc_hd__mux4_1
X_8043_ _3992_ VGND VGND VPWR VPWR _0542_ sky130_fd_sc_hd__clkbuf_1
X_5255_ _1641_ _2035_ _2039_ _2043_ VGND VGND VPWR VPWR _2044_ sky130_fd_sc_hd__o22a_1
X_5186_ _1618_ _1974_ VGND VGND VPWR VPWR _1975_ sky130_fd_sc_hd__nor2_1
XFILLER_0_3_73 VPWR VGND VPWR VGND sky130_ef_sc_hd__decap_12
XTAP_TAPCELL_ROW_39_722 VGND VPWR sky130_fd_sc_hd__tapvpwrvgnd_1
XFILLER_0_78_421 VGND VGND VPWR VPWR sky130_fd_sc_hd__fill_2
X_8945_ clknet_leaf_4_CLK _0178_ VGND VGND VPWR VPWR RF.reg_arr\[29\]\[19\] sky130_fd_sc_hd__dfxtp_1
XTAP_TAPCELL_ROW_104_1503 VGND VPWR sky130_fd_sc_hd__tapvpwrvgnd_1
X_8876_ clknet_leaf_95_CLK _0109_ VGND VGND VPWR VPWR RF.reg_arr\[3\]\[14\] sky130_fd_sc_hd__dfxtp_1
X_7827_ _3113_ net641 _3871_ VGND VGND VPWR VPWR _3878_ sky130_fd_sc_hd__mux2_1
XFILLER_0_66_638 VGND VGND VPWR VPWR sky130_fd_sc_hd__decap_6
XFILLER_0_38_307 VGND VGND VPWR VPWR sky130_fd_sc_hd__fill_1
XFILLER_0_59_690 VGND VGND VPWR VPWR sky130_fd_sc_hd__fill_2
X_7758_ _3841_ VGND VGND VPWR VPWR _0408_ sky130_fd_sc_hd__clkbuf_1
XFILLER_0_19_554 VGND VGND VPWR VPWR sky130_fd_sc_hd__decap_6
X_7689_ _3111_ net714 _3799_ VGND VGND VPWR VPWR _3805_ sky130_fd_sc_hd__mux2_1
X_6709_ _3266_ VGND VGND VPWR VPWR _0958_ sky130_fd_sc_hd__clkbuf_1
XFILLER_0_19_598 VGND VGND VPWR VPWR sky130_fd_sc_hd__decap_8
X_9428_ clknet_leaf_61_CLK _0661_ VGND VGND VPWR VPWR RF.reg_arr\[17\]\[22\] sky130_fd_sc_hd__dfxtp_1
XFILLER_0_6_470 VGND VGND VPWR VPWR sky130_fd_sc_hd__decap_6
XFILLER_0_116_294 VGND VGND VPWR VPWR sky130_fd_sc_hd__decap_6
XTAP_TAPCELL_ROW_115_1632 VGND VPWR sky130_fd_sc_hd__tapvpwrvgnd_1
X_9359_ clknet_leaf_106_CLK _0592_ VGND VGND VPWR VPWR RF.reg_arr\[18\]\[17\] sky130_fd_sc_hd__dfxtp_1
XFILLER_0_100_673 VGND VGND VPWR VPWR sky130_fd_sc_hd__fill_1
XFILLER_0_29_307 VGND VGND VPWR VPWR sky130_fd_sc_hd__decap_6
XFILLER_0_72_608 VGND VGND VPWR VPWR sky130_fd_sc_hd__fill_1
XFILLER_0_65_671 VGND VGND VPWR VPWR sky130_fd_sc_hd__fill_1
XFILLER_0_107_250 VGND VGND VPWR VPWR sky130_fd_sc_hd__decap_4
XFILLER_0_8_29 VGND VGND VPWR VPWR sky130_fd_sc_hd__decap_6
XFILLER_0_25_568 VGND VGND VPWR VPWR sky130_fd_sc_hd__fill_2
Xhold609 RF.reg_arr\[20\]\[4\] VGND VGND VPWR VPWR net691 sky130_fd_sc_hd__dlygate4sd3_1
XFILLER_0_52_365 VGND VGND VPWR VPWR sky130_fd_sc_hd__decap_6
XFILLER_0_52_376 VGND VGND VPWR VPWR sky130_fd_sc_hd__fill_2
XFILLER_0_100_23 VGND VGND VPWR VPWR sky130_fd_sc_hd__fill_1
XFILLER_0_0_613 VGND VGND VPWR VPWR sky130_fd_sc_hd__decap_3
XFILLER_0_20_240 VGND VGND VPWR VPWR sky130_fd_sc_hd__decap_3
XFILLER_0_20_251 VGND VGND VPWR VPWR sky130_fd_sc_hd__fill_1
Xclkbuf_3_2__f_CLK clknet_0_CLK VGND VGND VPWR VPWR clknet_3_2__leaf_CLK sky130_fd_sc_hd__clkbuf_16
XTAP_TAPCELL_ROW_90_1337 VGND VPWR sky130_fd_sc_hd__tapvpwrvgnd_1
XTAP_TAPCELL_ROW_90_1326 VGND VPWR sky130_fd_sc_hd__tapvpwrvgnd_1
XFILLER_0_0_657 VPWR VGND VPWR VGND sky130_ef_sc_hd__decap_12
XFILLER_0_20_273 VGND VGND VPWR VPWR sky130_fd_sc_hd__decap_4
X_5040_ _1159_ _1816_ _1820_ _1824_ _1828_ VGND VGND VPWR VPWR _1829_ sky130_fd_sc_hd__a32o_1
XPHY_EDGE_ROW_108_Left_225 VGND VGND VPWR VPWR sky130_fd_sc_hd__decap_3
X_6991_ net481 _3430_ _3431_ VGND VGND VPWR VPWR _3432_ sky130_fd_sc_hd__mux2_1
X_8730_ clknet_leaf_28_CLK _0987_ VGND VGND VPWR VPWR RF.reg_arr\[14\]\[28\] sky130_fd_sc_hd__dfxtp_1
X_5942_ _2049_ _2714_ VGND VGND VPWR VPWR _2715_ sky130_fd_sc_hd__or2_1
XFILLER_0_34_40 VGND VGND VPWR VPWR sky130_fd_sc_hd__fill_2
X_5873_ _2083_ _2637_ _2640_ VGND VGND VPWR VPWR _2650_ sky130_fd_sc_hd__a21oi_1
X_8661_ clknet_leaf_41_CLK _0918_ VGND VGND VPWR VPWR RF.reg_arr\[8\]\[23\] sky130_fd_sc_hd__dfxtp_1
XFILLER_0_75_424 VGND VGND VPWR VPWR sky130_fd_sc_hd__decap_4
X_4824_ _1612_ VGND VGND VPWR VPWR _1613_ sky130_fd_sc_hd__buf_4
X_7612_ _3764_ VGND VGND VPWR VPWR _0339_ sky130_fd_sc_hd__clkbuf_1
X_8592_ clknet_leaf_10_CLK _0849_ VGND VGND VPWR VPWR RF.reg_arr\[0\]\[18\] sky130_fd_sc_hd__dfxtp_1
XTAP_TAPCELL_ROW_44_780 VGND VPWR sky130_fd_sc_hd__tapvpwrvgnd_1
XFILLER_0_47_159 VGND VGND VPWR VPWR sky130_fd_sc_hd__decap_8
X_7543_ net836 _3430_ _3727_ VGND VGND VPWR VPWR _3728_ sky130_fd_sc_hd__mux2_1
X_4755_ _1133_ _1543_ _1062_ VGND VGND VPWR VPWR _1544_ sky130_fd_sc_hd__o21a_1
XFILLER_0_28_362 VGND VGND VPWR VPWR sky130_fd_sc_hd__fill_2
XFILLER_0_28_373 VGND VGND VPWR VPWR sky130_fd_sc_hd__decap_8
X_4686_ RF.reg_arr\[8\]\[30\] RF.reg_arr\[9\]\[30\] RF.reg_arr\[10\]\[30\] RF.reg_arr\[11\]\[30\]
+ _1303_ _1305_ VGND VGND VPWR VPWR _1475_ sky130_fd_sc_hd__mux4_1
X_9213_ clknet_leaf_22_CLK _0446_ VGND VGND VPWR VPWR RF.reg_arr\[24\]\[31\] sky130_fd_sc_hd__dfxtp_1
X_7474_ _3690_ VGND VGND VPWR VPWR _0275_ sky130_fd_sc_hd__clkbuf_1
X_6425_ net33 VGND VGND VPWR VPWR _3115_ sky130_fd_sc_hd__clkbuf_2
X_9144_ clknet_leaf_33_CLK _0377_ VGND VGND VPWR VPWR RF.reg_arr\[30\]\[26\] sky130_fd_sc_hd__dfxtp_1
XFILLER_0_11_251 VGND VGND VPWR VPWR sky130_fd_sc_hd__decap_3
X_6356_ _3068_ VGND VGND VPWR VPWR _0803_ sky130_fd_sc_hd__clkbuf_1
X_9075_ clknet_leaf_48_CLK _0308_ VGND VGND VPWR VPWR RF.reg_arr\[28\]\[21\] sky130_fd_sc_hd__dfxtp_1
XFILLER_0_11_262 VGND VGND VPWR VPWR sky130_fd_sc_hd__fill_1
X_5307_ _1603_ _2095_ VGND VGND VPWR VPWR _2096_ sky130_fd_sc_hd__or2_1
X_8026_ _3046_ net767 _3980_ VGND VGND VPWR VPWR _3984_ sky130_fd_sc_hd__mux2_1
X_6287_ net522 _3023_ _3019_ VGND VGND VPWR VPWR _3024_ sky130_fd_sc_hd__mux2_1
XTAP_TAPCELL_ROW_110_1573 VGND VPWR sky130_fd_sc_hd__tapvpwrvgnd_1
X_5238_ _2021_ _1830_ VGND VGND VPWR VPWR _2027_ sky130_fd_sc_hd__nand2_2
X_5169_ _1956_ _1957_ _1854_ VGND VGND VPWR VPWR _1958_ sky130_fd_sc_hd__mux2_1
XFILLER_0_98_549 VGND VGND VPWR VPWR sky130_fd_sc_hd__decap_8
XTAP_TAPCELL_ROW_65_1030 VGND VPWR sky130_fd_sc_hd__tapvpwrvgnd_1
X_8928_ clknet_leaf_68_CLK _0161_ VGND VGND VPWR VPWR RF.reg_arr\[29\]\[2\] sky130_fd_sc_hd__dfxtp_1
X_8859_ clknet_leaf_34_CLK _0092_ VGND VGND VPWR VPWR RF.reg_arr\[19\]\[29\] sky130_fd_sc_hd__dfxtp_1
XFILLER_0_78_273 VGND VGND VPWR VPWR sky130_fd_sc_hd__decap_4
XTAP_TAPCELL_ROW_14_419 VGND VPWR sky130_fd_sc_hd__tapvpwrvgnd_1
XFILLER_0_66_457 VGND VGND VPWR VPWR sky130_fd_sc_hd__decap_6
XFILLER_0_81_449 VGND VGND VPWR VPWR sky130_fd_sc_hd__decap_4
XFILLER_0_104_264 VGND VGND VPWR VPWR sky130_fd_sc_hd__fill_2
XFILLER_0_104_253 VGND VGND VPWR VPWR sky130_fd_sc_hd__fill_2
XFILLER_0_69_284 VGND VGND VPWR VPWR sky130_fd_sc_hd__decap_4
XFILLER_0_57_457 VGND VGND VPWR VPWR sky130_fd_sc_hd__fill_1
XFILLER_0_115_529 VPWR VGND VPWR VGND sky130_ef_sc_hd__decap_12
XFILLER_0_105_3 VPWR VGND VPWR VGND sky130_ef_sc_hd__decap_12
X_4540_ RF.reg_arr\[4\]\[23\] RF.reg_arr\[5\]\[23\] RF.reg_arr\[6\]\[23\] RF.reg_arr\[7\]\[23\]
+ _1327_ _1328_ VGND VGND VPWR VPWR _1329_ sky130_fd_sc_hd__mux4_1
XFILLER_0_80_471 VGND VGND VPWR VPWR sky130_fd_sc_hd__decap_4
XFILLER_0_25_376 VGND VGND VPWR VPWR sky130_fd_sc_hd__fill_1
Xhold406 RF.reg_arr\[13\]\[27\] VGND VGND VPWR VPWR net488 sky130_fd_sc_hd__dlygate4sd3_1
X_4471_ _1256_ _1257_ _1258_ _1259_ _1075_ _1061_ VGND VGND VPWR VPWR _1260_ sky130_fd_sc_hd__mux4_2
Xhold417 RF.reg_arr\[27\]\[2\] VGND VGND VPWR VPWR net499 sky130_fd_sc_hd__dlygate4sd3_1
X_6210_ _2485_ _2841_ _2967_ VGND VGND VPWR VPWR _2968_ sky130_fd_sc_hd__a21o_1
Xhold439 RF.reg_arr\[19\]\[12\] VGND VGND VPWR VPWR net521 sky130_fd_sc_hd__dlygate4sd3_1
Xhold428 RF.reg_arr\[24\]\[10\] VGND VGND VPWR VPWR net510 sky130_fd_sc_hd__dlygate4sd3_1
X_7190_ net931 _3422_ _3532_ VGND VGND VPWR VPWR _3539_ sky130_fd_sc_hd__mux2_1
X_6141_ _2890_ _2896_ _2902_ VGND VGND VPWR VPWR _2903_ sky130_fd_sc_hd__or3_1
XFILLER_0_110_267 VGND VGND VPWR VPWR sky130_fd_sc_hd__decap_3
X_6072_ _2707_ _2718_ _2445_ VGND VGND VPWR VPWR _2838_ sky130_fd_sc_hd__o21ai_1
XFILLER_0_29_84 VGND VGND VPWR VPWR sky130_fd_sc_hd__decap_8
X_5023_ _1775_ _1811_ _1738_ VGND VGND VPWR VPWR _1812_ sky130_fd_sc_hd__mux2_1
X_6974_ net20 VGND VGND VPWR VPWR _3420_ sky130_fd_sc_hd__buf_2
X_5925_ net84 _2698_ VGND VGND VPWR VPWR _2699_ sky130_fd_sc_hd__xnor2_2
XFILLER_0_0_41 VPWR VGND VPWR VGND sky130_ef_sc_hd__decap_12
X_8713_ clknet_leaf_13_CLK _0970_ VGND VGND VPWR VPWR RF.reg_arr\[14\]\[11\] sky130_fd_sc_hd__dfxtp_1
X_5856_ _2474_ _2489_ _2633_ _2050_ VGND VGND VPWR VPWR _2634_ sky130_fd_sc_hd__o22a_1
XFILLER_0_63_405 VGND VGND VPWR VPWR sky130_fd_sc_hd__fill_1
XFILLER_0_0_85 VPWR VGND VPWR VGND sky130_ef_sc_hd__decap_12
X_8644_ clknet_leaf_86_CLK _0901_ VGND VGND VPWR VPWR RF.reg_arr\[8\]\[6\] sky130_fd_sc_hd__dfxtp_1
XFILLER_0_90_213 VGND VGND VPWR VPWR sky130_fd_sc_hd__fill_1
X_4807_ _1595_ VGND VGND VPWR VPWR _1596_ sky130_fd_sc_hd__clkbuf_4
XPHY_EDGE_ROW_3_Right_3 VGND VGND VPWR VPWR sky130_fd_sc_hd__decap_3
X_5787_ _2445_ VGND VGND VPWR VPWR _2568_ sky130_fd_sc_hd__buf_2
XFILLER_0_106_518 VGND VGND VPWR VPWR sky130_fd_sc_hd__fill_1
X_8575_ clknet_leaf_59_CLK _0832_ VGND VGND VPWR VPWR RF.reg_arr\[0\]\[1\] sky130_fd_sc_hd__dfxtp_1
XFILLER_0_63_449 VGND VGND VPWR VPWR sky130_fd_sc_hd__decap_4
X_7526_ net867 _3414_ _3716_ VGND VGND VPWR VPWR _3719_ sky130_fd_sc_hd__mux2_1
XFILLER_0_16_365 VGND VGND VPWR VPWR sky130_fd_sc_hd__decap_4
X_4738_ _1049_ _1526_ VGND VGND VPWR VPWR _1527_ sky130_fd_sc_hd__or2_1
XFILLER_0_114_551 VPWR VGND VPWR VGND sky130_ef_sc_hd__decap_12
X_4669_ _1454_ _1457_ _1282_ VGND VGND VPWR VPWR _1458_ sky130_fd_sc_hd__mux2_1
X_7457_ _3681_ VGND VGND VPWR VPWR _0267_ sky130_fd_sc_hd__clkbuf_1
X_6408_ _3103_ net868 _3101_ VGND VGND VPWR VPWR _3104_ sky130_fd_sc_hd__mux2_1
Xhold940 RF.reg_arr\[26\]\[9\] VGND VGND VPWR VPWR net1022 sky130_fd_sc_hd__dlygate4sd3_1
XFILLER_0_3_270 VGND VGND VPWR VPWR sky130_fd_sc_hd__fill_2
Xhold951 RF.reg_arr\[22\]\[5\] VGND VGND VPWR VPWR net1033 sky130_fd_sc_hd__dlygate4sd3_1
Xhold973 RF.reg_arr\[25\]\[17\] VGND VGND VPWR VPWR net1055 sky130_fd_sc_hd__dlygate4sd3_1
X_9127_ clknet_leaf_78_CLK _0360_ VGND VGND VPWR VPWR RF.reg_arr\[30\]\[9\] sky130_fd_sc_hd__dfxtp_1
X_7388_ _3644_ VGND VGND VPWR VPWR _0235_ sky130_fd_sc_hd__clkbuf_1
Xhold962 RF.reg_arr\[24\]\[15\] VGND VGND VPWR VPWR net1044 sky130_fd_sc_hd__dlygate4sd3_1
Xhold995 RF.reg_arr\[27\]\[12\] VGND VGND VPWR VPWR net1077 sky130_fd_sc_hd__dlygate4sd3_1
Xhold984 RF.reg_arr\[21\]\[0\] VGND VGND VPWR VPWR net1066 sky130_fd_sc_hd__dlygate4sd3_1
X_6339_ net14 VGND VGND VPWR VPWR _3056_ sky130_fd_sc_hd__clkbuf_2
X_9058_ clknet_leaf_77_CLK _0291_ VGND VGND VPWR VPWR RF.reg_arr\[28\]\[4\] sky130_fd_sc_hd__dfxtp_1
X_8009_ _3029_ net494 _3969_ VGND VGND VPWR VPWR _3975_ sky130_fd_sc_hd__mux2_1
XFILLER_0_79_593 VGND VGND VPWR VPWR sky130_fd_sc_hd__fill_1
XTAP_TAPCELL_ROW_27_577 VGND VPWR sky130_fd_sc_hd__tapvpwrvgnd_1
XFILLER_0_94_541 VGND VGND VPWR VPWR sky130_fd_sc_hd__fill_1
XFILLER_0_62_471 VGND VGND VPWR VPWR sky130_fd_sc_hd__decap_4
XFILLER_0_77_519 VGND VGND VPWR VPWR sky130_fd_sc_hd__fill_2
XFILLER_0_106_88 VGND VGND VPWR VPWR sky130_fd_sc_hd__decap_8
XTAP_TAPCELL_ROW_85_1269 VGND VPWR sky130_fd_sc_hd__tapvpwrvgnd_1
X_5710_ _2198_ _2313_ _2494_ VGND VGND VPWR VPWR _2495_ sky130_fd_sc_hd__a21oi_1
X_6690_ _3105_ net615 _3254_ VGND VGND VPWR VPWR _3257_ sky130_fd_sc_hd__mux2_1
XFILLER_0_115_304 VGND VGND VPWR VPWR sky130_fd_sc_hd__fill_1
X_5641_ _2426_ _2427_ VGND VGND VPWR VPWR _2428_ sky130_fd_sc_hd__nand2_1
XFILLER_0_26_630 VGND VGND VPWR VPWR sky130_fd_sc_hd__decap_4
XFILLER_0_115_337 VGND VGND VPWR VPWR sky130_fd_sc_hd__fill_1
X_5572_ _2359_ VGND VGND VPWR VPWR _2360_ sky130_fd_sc_hd__inv_2
X_8360_ _3039_ net745 _4160_ VGND VGND VPWR VPWR _4161_ sky130_fd_sc_hd__mux2_1
XFILLER_0_5_535 VGND VGND VPWR VPWR sky130_fd_sc_hd__decap_4
X_4523_ RF.reg_arr\[0\]\[29\] RF.reg_arr\[1\]\[29\] RF.reg_arr\[2\]\[29\] RF.reg_arr\[3\]\[29\]
+ _1303_ _1305_ VGND VGND VPWR VPWR _1312_ sky130_fd_sc_hd__mux4_1
X_8291_ _4101_ VGND VGND VPWR VPWR _4124_ sky130_fd_sc_hd__clkbuf_8
XFILLER_0_13_302 VGND VGND VPWR VPWR sky130_fd_sc_hd__fill_2
X_7311_ _3603_ VGND VGND VPWR VPWR _0199_ sky130_fd_sc_hd__clkbuf_1
Xhold214 RF.reg_arr\[5\]\[30\] VGND VGND VPWR VPWR net296 sky130_fd_sc_hd__dlygate4sd3_1
Xhold203 RF.reg_arr\[1\]\[2\] VGND VGND VPWR VPWR net285 sky130_fd_sc_hd__dlygate4sd3_1
Xhold225 RF.reg_arr\[29\]\[22\] VGND VGND VPWR VPWR net307 sky130_fd_sc_hd__dlygate4sd3_1
X_7242_ _3075_ net969 _3558_ VGND VGND VPWR VPWR _3567_ sky130_fd_sc_hd__mux2_1
XFILLER_0_40_154 VGND VGND VPWR VPWR sky130_fd_sc_hd__fill_1
XFILLER_0_111_554 VGND VGND VPWR VPWR sky130_fd_sc_hd__decap_6
XTAP_TAPCELL_ROW_96_1398 VGND VPWR sky130_fd_sc_hd__tapvpwrvgnd_1
Xhold236 RF.reg_arr\[17\]\[21\] VGND VGND VPWR VPWR net318 sky130_fd_sc_hd__dlygate4sd3_1
Xhold247 RF.reg_arr\[2\]\[1\] VGND VGND VPWR VPWR net329 sky130_fd_sc_hd__dlygate4sd3_1
Xhold269 RF.reg_arr\[10\]\[14\] VGND VGND VPWR VPWR net351 sky130_fd_sc_hd__dlygate4sd3_1
X_4454_ RF.reg_arr\[28\]\[10\] RF.reg_arr\[29\]\[10\] RF.reg_arr\[30\]\[10\] RF.reg_arr\[31\]\[10\]
+ _1026_ _1028_ VGND VGND VPWR VPWR _1243_ sky130_fd_sc_hd__mux4_1
Xhold258 RF.reg_arr\[9\]\[11\] VGND VGND VPWR VPWR net340 sky130_fd_sc_hd__dlygate4sd3_1
X_7173_ net415 _3405_ _3521_ VGND VGND VPWR VPWR _3530_ sky130_fd_sc_hd__mux2_1
X_4385_ _1169_ _1172_ _1173_ VGND VGND VPWR VPWR _1174_ sky130_fd_sc_hd__mux2_2
X_6124_ _2619_ _2714_ VGND VGND VPWR VPWR _2887_ sky130_fd_sc_hd__nor2_1
X_6055_ _2755_ _2821_ _2361_ VGND VGND VPWR VPWR _2822_ sky130_fd_sc_hd__mux2_1
X_5006_ _1793_ _1794_ _1612_ VGND VGND VPWR VPWR _1795_ sky130_fd_sc_hd__mux2_1
X_6957_ _3408_ VGND VGND VPWR VPWR _0040_ sky130_fd_sc_hd__clkbuf_1
XTAP_TAPCELL_ROW_62_1000 VGND VPWR sky130_fd_sc_hd__tapvpwrvgnd_1
XTAP_TAPCELL_ROW_24_536 VGND VPWR sky130_fd_sc_hd__tapvpwrvgnd_1
X_5908_ _2340_ _2676_ _2683_ VGND VGND VPWR VPWR net53 sky130_fd_sc_hd__a21oi_1
X_6888_ _3363_ VGND VGND VPWR VPWR _0016_ sky130_fd_sc_hd__clkbuf_1
XTAP_TAPCELL_ROW_52_878 VGND VPWR sky130_fd_sc_hd__tapvpwrvgnd_1
X_5839_ _2524_ _2617_ _1831_ VGND VGND VPWR VPWR _2618_ sky130_fd_sc_hd__mux2_1
X_8627_ clknet_leaf_47_CLK _0884_ VGND VGND VPWR VPWR RF.reg_arr\[16\]\[21\] sky130_fd_sc_hd__dfxtp_1
XFILLER_0_91_577 VGND VGND VPWR VPWR sky130_fd_sc_hd__decap_3
XFILLER_0_8_384 VGND VGND VPWR VPWR sky130_fd_sc_hd__fill_2
X_8558_ clknet_leaf_6_CLK _0815_ VGND VGND VPWR VPWR RF.reg_arr\[23\]\[16\] sky130_fd_sc_hd__dfxtp_1
X_7509_ net659 _3397_ _3705_ VGND VGND VPWR VPWR _3710_ sky130_fd_sc_hd__mux2_1
XFILLER_0_44_493 VGND VGND VPWR VPWR sky130_fd_sc_hd__decap_4
X_8489_ _4228_ VGND VGND VPWR VPWR _0752_ sky130_fd_sc_hd__clkbuf_1
Xhold770 RF.reg_arr\[20\]\[22\] VGND VGND VPWR VPWR net852 sky130_fd_sc_hd__dlygate4sd3_1
Xhold781 RF.reg_arr\[21\]\[8\] VGND VGND VPWR VPWR net863 sky130_fd_sc_hd__dlygate4sd3_1
Xhold792 RF.reg_arr\[27\]\[4\] VGND VGND VPWR VPWR net874 sky130_fd_sc_hd__dlygate4sd3_1
XFILLER_0_99_655 VGND VGND VPWR VPWR sky130_fd_sc_hd__fill_1
XTAP_TAPCELL_ROW_4_294 VGND VPWR sky130_fd_sc_hd__tapvpwrvgnd_1
XFILLER_0_99_677 VGND VGND VPWR VPWR sky130_fd_sc_hd__fill_1
XFILLER_0_94_360 VGND VGND VPWR VPWR sky130_fd_sc_hd__decap_4
XFILLER_0_27_449 VGND VGND VPWR VPWR sky130_fd_sc_hd__fill_1
XFILLER_0_54_213 VGND VGND VPWR VPWR sky130_fd_sc_hd__decap_3
XFILLER_0_42_419 VGND VGND VPWR VPWR sky130_fd_sc_hd__fill_1
XFILLER_0_112_307 VGND VGND VPWR VPWR sky130_fd_sc_hd__fill_1
XFILLER_0_105_381 VGND VGND VPWR VPWR sky130_fd_sc_hd__fill_2
XFILLER_0_2_549 VGND VGND VPWR VPWR sky130_fd_sc_hd__fill_2
XFILLER_0_89_132 VGND VGND VPWR VPWR sky130_fd_sc_hd__fill_1
XFILLER_0_89_110 VGND VGND VPWR VPWR sky130_fd_sc_hd__fill_2
XFILLER_0_77_305 VGND VGND VPWR VPWR sky130_fd_sc_hd__fill_1
X_7860_ _3077_ net850 _3886_ VGND VGND VPWR VPWR _3896_ sky130_fd_sc_hd__mux2_1
X_6811_ _3322_ VGND VGND VPWR VPWR _1004_ sky130_fd_sc_hd__clkbuf_1
X_7791_ _3077_ net939 _3849_ VGND VGND VPWR VPWR _3859_ sky130_fd_sc_hd__mux2_1
XFILLER_0_58_563 VGND VGND VPWR VPWR sky130_fd_sc_hd__decap_8
X_6742_ _3285_ VGND VGND VPWR VPWR _0972_ sky130_fd_sc_hd__clkbuf_1
XFILLER_0_42_40 VGND VGND VPWR VPWR sky130_fd_sc_hd__fill_1
XFILLER_0_85_393 VGND VGND VPWR VPWR sky130_fd_sc_hd__decap_3
X_9461_ clknet_leaf_41_CLK _0694_ VGND VGND VPWR VPWR RF.reg_arr\[12\]\[23\] sky130_fd_sc_hd__dfxtp_1
XTAP_TAPCELL_ROW_21_506 VGND VPWR sky130_fd_sc_hd__tapvpwrvgnd_1
X_6673_ _3088_ net1003 _3243_ VGND VGND VPWR VPWR _3248_ sky130_fd_sc_hd__mux2_1
XTAP_TAPCELL_ROW_98_1427 VGND VPWR sky130_fd_sc_hd__tapvpwrvgnd_1
X_5624_ _2028_ _2410_ _2411_ VGND VGND VPWR VPWR _2412_ sky130_fd_sc_hd__and3_1
X_8412_ _4188_ VGND VGND VPWR VPWR _0715_ sky130_fd_sc_hd__clkbuf_1
X_9392_ clknet_leaf_1_CLK _0625_ VGND VGND VPWR VPWR RF.reg_arr\[13\]\[18\] sky130_fd_sc_hd__dfxtp_1
XFILLER_0_45_279 VGND VGND VPWR VPWR sky130_fd_sc_hd__fill_1
XFILLER_0_116_657 VPWR VGND VPWR VGND sky130_ef_sc_hd__decap_12
X_8343_ _3023_ net1085 _4149_ VGND VGND VPWR VPWR _4152_ sky130_fd_sc_hd__mux2_1
X_5555_ net47 _2339_ VGND VGND VPWR VPWR _2343_ sky130_fd_sc_hd__and2_1
XFILLER_0_41_441 VGND VGND VPWR VPWR sky130_fd_sc_hd__fill_1
X_4506_ RF.reg_arr\[16\]\[29\] RF.reg_arr\[17\]\[29\] RF.reg_arr\[18\]\[29\] RF.reg_arr\[19\]\[29\]
+ _1273_ _1275_ VGND VGND VPWR VPWR _1295_ sky130_fd_sc_hd__mux4_1
X_5486_ _2237_ _2274_ _2029_ VGND VGND VPWR VPWR _2275_ sky130_fd_sc_hd__mux2_1
X_8274_ _4115_ VGND VGND VPWR VPWR _0650_ sky130_fd_sc_hd__clkbuf_1
X_7225_ _3557_ VGND VGND VPWR VPWR _3558_ sky130_fd_sc_hd__clkbuf_8
X_4437_ RF.reg_arr\[28\]\[9\] RF.reg_arr\[29\]\[9\] RF.reg_arr\[30\]\[9\] RF.reg_arr\[31\]\[9\]
+ _1105_ _1106_ VGND VGND VPWR VPWR _1226_ sky130_fd_sc_hd__mux4_1
XFILLER_0_41_496 VGND VGND VPWR VPWR sky130_fd_sc_hd__decap_8
X_7156_ _3520_ VGND VGND VPWR VPWR _3521_ sky130_fd_sc_hd__buf_4
X_6107_ _1564_ _2870_ VGND VGND VPWR VPWR _2871_ sky130_fd_sc_hd__xnor2_1
X_4368_ _1155_ _1156_ _1128_ VGND VGND VPWR VPWR _1157_ sky130_fd_sc_hd__mux2_1
X_7087_ _2995_ _3057_ VGND VGND VPWR VPWR _3484_ sky130_fd_sc_hd__and2_4
X_4299_ _1059_ _1087_ _1055_ VGND VGND VPWR VPWR _1088_ sky130_fd_sc_hd__o21a_1
X_6038_ _2371_ _2363_ VGND VGND VPWR VPWR _2806_ sky130_fd_sc_hd__nand2_1
XTAP_TAPCELL_ROW_57_937 VGND VPWR sky130_fd_sc_hd__tapvpwrvgnd_1
XTAP_TAPCELL_ROW_107_1534 VGND VPWR sky130_fd_sc_hd__tapvpwrvgnd_1
XFILLER_0_95_113 VGND VGND VPWR VPWR sky130_fd_sc_hd__fill_1
XTAP_TAPCELL_ROW_1_264 VGND VPWR sky130_fd_sc_hd__tapvpwrvgnd_1
XFILLER_0_96_658 VGND VGND VPWR VPWR sky130_fd_sc_hd__decap_8
XFILLER_0_95_135 VGND VGND VPWR VPWR sky130_fd_sc_hd__fill_1
X_7989_ _3964_ VGND VGND VPWR VPWR _0516_ sky130_fd_sc_hd__clkbuf_1
XTAP_TAPCELL_ROW_37_694 VGND VPWR sky130_fd_sc_hd__tapvpwrvgnd_1
XFILLER_0_49_585 VGND VGND VPWR VPWR sky130_fd_sc_hd__fill_2
XFILLER_0_107_613 VGND VGND VPWR VPWR sky130_fd_sc_hd__decap_3
XFILLER_0_64_533 VGND VGND VPWR VPWR sky130_fd_sc_hd__fill_2
XFILLER_0_36_268 VGND VGND VPWR VPWR sky130_fd_sc_hd__decap_8
XFILLER_0_102_340 VGND VGND VPWR VPWR sky130_fd_sc_hd__fill_2
Xclkbuf_leaf_104_CLK clknet_3_1__leaf_CLK VGND VGND VPWR VPWR clknet_leaf_104_CLK
+ sky130_fd_sc_hd__clkbuf_8
XTAP_TAPCELL_ROW_9_364 VGND VPWR sky130_fd_sc_hd__tapvpwrvgnd_1
XFILLER_0_63_17 VGND VGND VPWR VPWR sky130_fd_sc_hd__decap_4
XFILLER_0_59_316 VGND VGND VPWR VPWR sky130_fd_sc_hd__fill_1
XFILLER_0_87_669 VGND VGND VPWR VPWR sky130_fd_sc_hd__decap_3
XFILLER_0_86_179 VGND VGND VPWR VPWR sky130_fd_sc_hd__fill_1
XTAP_TAPCELL_ROW_82_1239 VGND VPWR sky130_fd_sc_hd__tapvpwrvgnd_1
XFILLER_0_94_190 VGND VGND VPWR VPWR sky130_fd_sc_hd__decap_6
XFILLER_0_67_393 VGND VGND VPWR VPWR sky130_fd_sc_hd__decap_4
XFILLER_0_82_363 VGND VGND VPWR VPWR sky130_fd_sc_hd__fill_1
XFILLER_0_6_118 VGND VGND VPWR VPWR sky130_fd_sc_hd__fill_1
XFILLER_0_42_227 VGND VGND VPWR VPWR sky130_fd_sc_hd__fill_1
XFILLER_0_113_638 VPWR VGND VPWR VGND sky130_ef_sc_hd__decap_12
X_5340_ RF.reg_arr\[24\]\[14\] RF.reg_arr\[25\]\[14\] RF.reg_arr\[26\]\[14\] RF.reg_arr\[27\]\[14\]
+ _2087_ _1859_ VGND VGND VPWR VPWR _2129_ sky130_fd_sc_hd__mux4_1
XFILLER_0_2_324 VGND VGND VPWR VPWR sky130_fd_sc_hd__fill_1
XTAP_TAPCELL_ROW_93_1368 VGND VPWR sky130_fd_sc_hd__tapvpwrvgnd_1
X_5271_ RF.reg_arr\[12\]\[10\] RF.reg_arr\[13\]\[10\] RF.reg_arr\[14\]\[10\] RF.reg_arr\[15\]\[10\]
+ _1676_ _1682_ VGND VGND VPWR VPWR _2060_ sky130_fd_sc_hd__mux4_1
X_7010_ net713 _3379_ _3431_ VGND VGND VPWR VPWR _3443_ sky130_fd_sc_hd__mux2_1
X_8961_ clknet_leaf_68_CLK _0194_ VGND VGND VPWR VPWR RF.reg_arr\[31\]\[3\] sky130_fd_sc_hd__dfxtp_1
X_7912_ _3000_ net973 _3922_ VGND VGND VPWR VPWR _3924_ sky130_fd_sc_hd__mux2_1
X_8892_ clknet_leaf_23_CLK _0125_ VGND VGND VPWR VPWR RF.reg_arr\[3\]\[30\] sky130_fd_sc_hd__dfxtp_1
XFILLER_0_78_614 VGND VGND VPWR VPWR sky130_fd_sc_hd__fill_1
X_7843_ _3887_ VGND VGND VPWR VPWR _0447_ sky130_fd_sc_hd__clkbuf_1
X_4986_ _1755_ _1774_ VGND VGND VPWR VPWR _1775_ sky130_fd_sc_hd__nand2_1
X_7774_ _3850_ VGND VGND VPWR VPWR _0415_ sky130_fd_sc_hd__clkbuf_1
XTAP_TAPCELL_ROW_62_995 VGND VPWR sky130_fd_sc_hd__tapvpwrvgnd_1
X_6725_ _3276_ VGND VGND VPWR VPWR _0964_ sky130_fd_sc_hd__clkbuf_1
XFILLER_0_18_202 VGND VGND VPWR VPWR sky130_fd_sc_hd__fill_2
XTAP_TAPCELL_ROW_34_664 VGND VPWR sky130_fd_sc_hd__tapvpwrvgnd_1
X_9513_ clknet_leaf_91_CLK _0746_ VGND VGND VPWR VPWR RF.reg_arr\[10\]\[11\] sky130_fd_sc_hd__dfxtp_1
XFILLER_0_116_421 VGND VGND VPWR VPWR sky130_fd_sc_hd__fill_1
XTAP_TAPCELL_ROW_102_1475 VGND VPWR sky130_fd_sc_hd__tapvpwrvgnd_1
XFILLER_0_73_330 VGND VGND VPWR VPWR sky130_fd_sc_hd__fill_1
X_6656_ _3071_ net955 _3232_ VGND VGND VPWR VPWR _3239_ sky130_fd_sc_hd__mux2_1
X_9444_ clknet_leaf_86_CLK _0677_ VGND VGND VPWR VPWR RF.reg_arr\[12\]\[6\] sky130_fd_sc_hd__dfxtp_1
X_5607_ _1833_ _1980_ _1700_ VGND VGND VPWR VPWR _2395_ sky130_fd_sc_hd__o21ai_1
XFILLER_0_14_430 VGND VGND VPWR VPWR sky130_fd_sc_hd__decap_6
X_6587_ _3202_ VGND VGND VPWR VPWR _0900_ sky130_fd_sc_hd__clkbuf_1
X_9375_ clknet_leaf_68_CLK _0608_ VGND VGND VPWR VPWR RF.reg_arr\[13\]\[1\] sky130_fd_sc_hd__dfxtp_1
XFILLER_0_103_148 VGND VGND VPWR VPWR sky130_fd_sc_hd__decap_3
X_5538_ RF.reg_arr\[0\]\[1\] RF.reg_arr\[1\]\[1\] RF.reg_arr\[2\]\[1\] RF.reg_arr\[3\]\[1\]
+ _1621_ _1594_ VGND VGND VPWR VPWR _2327_ sky130_fd_sc_hd__mux4_1
X_8326_ _3006_ net638 _4138_ VGND VGND VPWR VPWR _4143_ sky130_fd_sc_hd__mux2_1
XFILLER_0_112_671 VPWR VGND VPWR VGND sky130_ef_sc_hd__decap_12
X_8257_ _4106_ VGND VGND VPWR VPWR _0642_ sky130_fd_sc_hd__clkbuf_1
X_7208_ _3548_ VGND VGND VPWR VPWR _0151_ sky130_fd_sc_hd__clkbuf_1
X_5469_ _2256_ _2257_ _1603_ VGND VGND VPWR VPWR _2258_ sky130_fd_sc_hd__mux2_1
XTAP_TAPCELL_ROW_6_323 VGND VPWR sky130_fd_sc_hd__tapvpwrvgnd_1
X_8188_ _3004_ net674 _4066_ VGND VGND VPWR VPWR _4070_ sky130_fd_sc_hd__mux2_1
X_7139_ net171 _3371_ _3507_ VGND VGND VPWR VPWR _3512_ sky130_fd_sc_hd__mux2_1
XFILLER_0_69_658 VGND VGND VPWR VPWR sky130_fd_sc_hd__decap_4
XTAP_TAPCELL_ROW_68_1072 VGND VPWR sky130_fd_sc_hd__tapvpwrvgnd_1
XFILLER_0_68_135 VGND VGND VPWR VPWR sky130_fd_sc_hd__fill_2
XFILLER_0_96_477 VGND VGND VPWR VPWR sky130_fd_sc_hd__decap_3
XFILLER_0_84_606 VGND VGND VPWR VPWR sky130_fd_sc_hd__decap_6
XFILLER_0_77_691 VGND VGND VPWR VPWR sky130_fd_sc_hd__fill_1
XFILLER_0_49_393 VGND VGND VPWR VPWR sky130_fd_sc_hd__fill_1
XFILLER_0_107_443 VGND VGND VPWR VPWR sky130_fd_sc_hd__decap_4
XFILLER_0_107_432 VGND VGND VPWR VPWR sky130_fd_sc_hd__decap_8
Xinput18 WD3[13] VGND VGND VPWR VPWR net18 sky130_fd_sc_hd__dlymetal6s2s_1
XFILLER_0_37_599 VGND VGND VPWR VPWR sky130_fd_sc_hd__fill_1
XFILLER_0_52_536 VGND VGND VPWR VPWR sky130_fd_sc_hd__fill_1
XFILLER_0_91_193 VGND VGND VPWR VPWR sky130_fd_sc_hd__decap_6
Xinput29 WD3[23] VGND VGND VPWR VPWR net29 sky130_fd_sc_hd__dlymetal6s2s_1
XFILLER_0_60_580 VGND VGND VPWR VPWR sky130_fd_sc_hd__fill_2
XFILLER_0_20_477 VGND VGND VPWR VPWR sky130_fd_sc_hd__fill_2
XFILLER_0_87_422 VGND VGND VPWR VPWR sky130_fd_sc_hd__decap_4
X_4840_ _1628_ VGND VGND VPWR VPWR _1629_ sky130_fd_sc_hd__clkbuf_4
XFILLER_0_75_617 VGND VGND VPWR VPWR sky130_fd_sc_hd__fill_2
XFILLER_0_74_138 VGND VGND VPWR VPWR sky130_fd_sc_hd__fill_2
X_4771_ RF.reg_arr\[4\]\[25\] RF.reg_arr\[5\]\[25\] RF.reg_arr\[6\]\[25\] RF.reg_arr\[7\]\[25\]
+ _1302_ _1322_ VGND VGND VPWR VPWR _1560_ sky130_fd_sc_hd__mux4_1
X_6510_ net271 _3000_ _3160_ VGND VGND VPWR VPWR _3162_ sky130_fd_sc_hd__mux2_1
XFILLER_0_23_75 VGND VGND VPWR VPWR sky130_fd_sc_hd__fill_2
XTAP_TAPCELL_ROW_31_623 VGND VPWR sky130_fd_sc_hd__tapvpwrvgnd_1
X_7490_ _3698_ VGND VGND VPWR VPWR _0283_ sky130_fd_sc_hd__clkbuf_1
XFILLER_0_99_46 VGND VGND VPWR VPWR sky130_fd_sc_hd__fill_1
XFILLER_0_99_57 VGND VGND VPWR VPWR sky130_fd_sc_hd__decap_6
XFILLER_0_82_182 VGND VGND VPWR VPWR sky130_fd_sc_hd__decap_4
X_6441_ _3125_ VGND VGND VPWR VPWR _0831_ sky130_fd_sc_hd__clkbuf_1
X_9160_ clknet_leaf_15_CLK _0393_ VGND VGND VPWR VPWR RF.reg_arr\[9\]\[10\] sky130_fd_sc_hd__dfxtp_1
XTAP_TAPCELL_ROW_11_380 VGND VPWR sky130_fd_sc_hd__tapvpwrvgnd_1
X_6372_ net15 VGND VGND VPWR VPWR _3079_ sky130_fd_sc_hd__clkbuf_2
X_8111_ _4028_ VGND VGND VPWR VPWR _0574_ sky130_fd_sc_hd__clkbuf_1
X_5323_ RF.reg_arr\[8\]\[9\] RF.reg_arr\[9\]\[9\] RF.reg_arr\[10\]\[9\] RF.reg_arr\[11\]\[9\]
+ _1590_ _1835_ VGND VGND VPWR VPWR _2112_ sky130_fd_sc_hd__mux4_1
X_9091_ clknet_leaf_86_CLK _0324_ VGND VGND VPWR VPWR RF.reg_arr\[2\]\[5\] sky130_fd_sc_hd__dfxtp_1
X_8042_ _2992_ net512 _3957_ VGND VGND VPWR VPWR _3992_ sky130_fd_sc_hd__mux2_1
X_5254_ _1634_ _2042_ net5 VGND VGND VPWR VPWR _2043_ sky130_fd_sc_hd__a21o_1
XFILLER_0_48_50 VGND VGND VPWR VPWR sky130_fd_sc_hd__decap_8
X_5185_ _1972_ _1973_ _1854_ VGND VGND VPWR VPWR _1974_ sky130_fd_sc_hd__mux2_1
XTAP_TAPCELL_ROW_39_723 VGND VPWR sky130_fd_sc_hd__tapvpwrvgnd_1
XFILLER_0_3_85 VPWR VGND VPWR VGND sky130_ef_sc_hd__decap_12
X_8944_ clknet_leaf_0_CLK _0177_ VGND VGND VPWR VPWR RF.reg_arr\[29\]\[18\] sky130_fd_sc_hd__dfxtp_1
XTAP_TAPCELL_ROW_104_1504 VGND VPWR sky130_fd_sc_hd__tapvpwrvgnd_1
X_8875_ clknet_leaf_90_CLK _0108_ VGND VGND VPWR VPWR RF.reg_arr\[3\]\[13\] sky130_fd_sc_hd__dfxtp_1
X_7826_ _3877_ VGND VGND VPWR VPWR _0440_ sky130_fd_sc_hd__clkbuf_1
XTAP_TAPCELL_ROW_19_480 VGND VPWR sky130_fd_sc_hd__tapvpwrvgnd_1
X_4969_ RF.reg_arr\[16\]\[27\] RF.reg_arr\[17\]\[27\] RF.reg_arr\[18\]\[27\] RF.reg_arr\[19\]\[27\]
+ _1592_ _1599_ VGND VGND VPWR VPWR _1758_ sky130_fd_sc_hd__mux4_1
X_7757_ net167 _3373_ _3835_ VGND VGND VPWR VPWR _3841_ sky130_fd_sc_hd__mux2_1
X_7688_ _3804_ VGND VGND VPWR VPWR _0375_ sky130_fd_sc_hd__clkbuf_1
X_6708_ _3123_ net645 _3231_ VGND VGND VPWR VPWR _3266_ sky130_fd_sc_hd__mux2_1
XFILLER_0_74_683 VGND VGND VPWR VPWR sky130_fd_sc_hd__fill_1
XFILLER_0_116_262 VGND VGND VPWR VPWR sky130_fd_sc_hd__fill_2
X_9427_ clknet_leaf_47_CLK _0660_ VGND VGND VPWR VPWR RF.reg_arr\[17\]\[21\] sky130_fd_sc_hd__dfxtp_1
X_6639_ _3229_ VGND VGND VPWR VPWR _0925_ sky130_fd_sc_hd__clkbuf_1
XFILLER_0_21_208 VGND VGND VPWR VPWR sky130_fd_sc_hd__decap_4
XTAP_TAPCELL_ROW_115_1633 VGND VPWR sky130_fd_sc_hd__tapvpwrvgnd_1
X_9358_ clknet_leaf_6_CLK _0591_ VGND VGND VPWR VPWR RF.reg_arr\[18\]\[16\] sky130_fd_sc_hd__dfxtp_1
X_8309_ _4133_ VGND VGND VPWR VPWR _0667_ sky130_fd_sc_hd__clkbuf_1
X_9289_ clknet_leaf_92_CLK _0522_ VGND VGND VPWR VPWR RF.reg_arr\[25\]\[11\] sky130_fd_sc_hd__dfxtp_1
XPHY_EDGE_ROW_110_Right_110 VGND VGND VPWR VPWR sky130_fd_sc_hd__decap_3
XFILLER_0_100_663 VGND VGND VPWR VPWR sky130_fd_sc_hd__decap_3
XFILLER_0_57_628 VGND VGND VPWR VPWR sky130_fd_sc_hd__decap_6
XFILLER_0_29_319 VGND VGND VPWR VPWR sky130_fd_sc_hd__decap_4
XFILLER_0_65_661 VGND VGND VPWR VPWR sky130_fd_sc_hd__fill_1
XFILLER_0_25_558 VGND VGND VPWR VPWR sky130_fd_sc_hd__fill_2
XFILLER_0_33_591 VGND VGND VPWR VPWR sky130_fd_sc_hd__fill_2
XFILLER_0_103_490 VPWR VGND VPWR VGND sky130_ef_sc_hd__decap_12
XTAP_TAPCELL_ROW_90_1327 VGND VPWR sky130_fd_sc_hd__tapvpwrvgnd_1
XFILLER_0_0_669 VGND VGND VPWR VPWR sky130_fd_sc_hd__decap_3
XFILLER_0_109_55 VGND VGND VPWR VPWR sky130_fd_sc_hd__fill_1
X_6990_ _3388_ VGND VGND VPWR VPWR _3431_ sky130_fd_sc_hd__buf_4
XFILLER_0_26_9 VGND VGND VPWR VPWR sky130_fd_sc_hd__fill_1
X_5941_ _2713_ VGND VGND VPWR VPWR _2714_ sky130_fd_sc_hd__buf_2
XFILLER_0_34_63 VGND VGND VPWR VPWR sky130_fd_sc_hd__decap_4
X_5872_ _2574_ _2611_ _2624_ _2638_ VGND VGND VPWR VPWR _2649_ sky130_fd_sc_hd__nand4b_1
X_8660_ clknet_leaf_43_CLK _0917_ VGND VGND VPWR VPWR RF.reg_arr\[8\]\[22\] sky130_fd_sc_hd__dfxtp_1
X_7611_ net256 _3430_ _3763_ VGND VGND VPWR VPWR _3764_ sky130_fd_sc_hd__mux2_1
X_8591_ clknet_leaf_103_CLK _0848_ VGND VGND VPWR VPWR RF.reg_arr\[0\]\[17\] sky130_fd_sc_hd__dfxtp_1
XTAP_TAPCELL_ROW_44_781 VGND VPWR sky130_fd_sc_hd__tapvpwrvgnd_1
X_4823_ _1611_ VGND VGND VPWR VPWR _1612_ sky130_fd_sc_hd__buf_4
X_7542_ _3704_ VGND VGND VPWR VPWR _3727_ sky130_fd_sc_hd__clkbuf_8
XFILLER_0_62_108 VGND VGND VPWR VPWR sky130_fd_sc_hd__fill_2
X_4754_ RF.reg_arr\[8\]\[15\] RF.reg_arr\[9\]\[15\] RF.reg_arr\[10\]\[15\] RF.reg_arr\[11\]\[15\]
+ _1187_ _1189_ VGND VGND VPWR VPWR _1543_ sky130_fd_sc_hd__mux4_1
Xclkbuf_leaf_93_CLK clknet_3_4__leaf_CLK VGND VGND VPWR VPWR clknet_leaf_93_CLK sky130_fd_sc_hd__clkbuf_8
XFILLER_0_56_661 VGND VGND VPWR VPWR sky130_fd_sc_hd__fill_1
X_7473_ _3100_ net747 _3689_ VGND VGND VPWR VPWR _3690_ sky130_fd_sc_hd__mux2_1
X_4685_ _1470_ _1473_ _1284_ VGND VGND VPWR VPWR _1474_ sky130_fd_sc_hd__mux2_1
XFILLER_0_70_141 VGND VGND VPWR VPWR sky130_fd_sc_hd__fill_1
X_9212_ clknet_leaf_22_CLK _0445_ VGND VGND VPWR VPWR RF.reg_arr\[24\]\[30\] sky130_fd_sc_hd__dfxtp_1
XFILLER_0_43_377 VGND VGND VPWR VPWR sky130_fd_sc_hd__decap_6
X_6424_ _3114_ VGND VGND VPWR VPWR _0825_ sky130_fd_sc_hd__clkbuf_1
XFILLER_0_113_243 VGND VGND VPWR VPWR sky130_fd_sc_hd__decap_4
XFILLER_0_113_276 VGND VGND VPWR VPWR sky130_fd_sc_hd__decap_4
X_9143_ clknet_leaf_31_CLK _0376_ VGND VGND VPWR VPWR RF.reg_arr\[30\]\[25\] sky130_fd_sc_hd__dfxtp_1
X_6355_ _3067_ net683 _3059_ VGND VGND VPWR VPWR _3068_ sky130_fd_sc_hd__mux2_1
X_9074_ clknet_leaf_15_CLK _0307_ VGND VGND VPWR VPWR RF.reg_arr\[28\]\[20\] sky130_fd_sc_hd__dfxtp_1
X_6286_ net17 VGND VGND VPWR VPWR _3023_ sky130_fd_sc_hd__buf_2
X_5306_ RF.reg_arr\[0\]\[8\] RF.reg_arr\[1\]\[8\] RF.reg_arr\[2\]\[8\] RF.reg_arr\[3\]\[8\]
+ _1847_ _1850_ VGND VGND VPWR VPWR _2095_ sky130_fd_sc_hd__mux4_1
X_5237_ _2025_ VGND VGND VPWR VPWR _2026_ sky130_fd_sc_hd__buf_2
X_8025_ _3983_ VGND VGND VPWR VPWR _0533_ sky130_fd_sc_hd__clkbuf_1
XTAP_TAPCELL_ROW_110_1574 VGND VPWR sky130_fd_sc_hd__tapvpwrvgnd_1
X_5168_ RF.reg_arr\[12\]\[19\] RF.reg_arr\[13\]\[19\] RF.reg_arr\[14\]\[19\] RF.reg_arr\[15\]\[19\]
+ _1848_ _1851_ VGND VGND VPWR VPWR _1957_ sky130_fd_sc_hd__mux4_1
X_5099_ RF.reg_arr\[12\]\[23\] RF.reg_arr\[13\]\[23\] RF.reg_arr\[14\]\[23\] RF.reg_arr\[15\]\[23\]
+ _1884_ _1886_ VGND VGND VPWR VPWR _1888_ sky130_fd_sc_hd__mux4_1
X_8927_ clknet_leaf_56_CLK _0160_ VGND VGND VPWR VPWR RF.reg_arr\[29\]\[1\] sky130_fd_sc_hd__dfxtp_1
XTAP_TAPCELL_ROW_65_1031 VGND VPWR sky130_fd_sc_hd__tapvpwrvgnd_1
X_8858_ clknet_leaf_31_CLK _0091_ VGND VGND VPWR VPWR RF.reg_arr\[19\]\[28\] sky130_fd_sc_hd__dfxtp_1
XFILLER_0_66_436 VGND VGND VPWR VPWR sky130_fd_sc_hd__decap_6
XFILLER_0_66_414 VGND VGND VPWR VPWR sky130_fd_sc_hd__decap_6
XFILLER_0_38_105 VGND VGND VPWR VPWR sky130_fd_sc_hd__decap_8
XFILLER_0_39_628 VGND VGND VPWR VPWR sky130_fd_sc_hd__decap_6
XFILLER_0_109_516 VGND VGND VPWR VPWR sky130_fd_sc_hd__decap_6
X_8789_ clknet_leaf_42_CLK _0022_ VGND VGND VPWR VPWR RF.reg_arr\[5\]\[23\] sky130_fd_sc_hd__dfxtp_1
X_7809_ _3868_ VGND VGND VPWR VPWR _0432_ sky130_fd_sc_hd__clkbuf_1
Xclkbuf_leaf_84_CLK clknet_3_4__leaf_CLK VGND VGND VPWR VPWR clknet_leaf_84_CLK sky130_fd_sc_hd__clkbuf_8
XTAP_TAPCELL_ROW_76_1160 VGND VPWR sky130_fd_sc_hd__tapvpwrvgnd_1
XFILLER_0_100_471 VGND VGND VPWR VPWR sky130_fd_sc_hd__decap_4
XFILLER_0_89_539 VGND VGND VPWR VPWR sky130_fd_sc_hd__decap_4
XFILLER_0_97_561 VGND VGND VPWR VPWR sky130_fd_sc_hd__decap_6
XFILLER_0_97_583 VGND VGND VPWR VPWR sky130_fd_sc_hd__decap_8
XTAP_TAPCELL_ROW_41_740 VGND VPWR sky130_fd_sc_hd__tapvpwrvgnd_1
XFILLER_0_108_560 VGND VGND VPWR VPWR sky130_fd_sc_hd__decap_8
Xclkbuf_leaf_75_CLK clknet_3_5__leaf_CLK VGND VGND VPWR VPWR clknet_leaf_75_CLK sky130_fd_sc_hd__clkbuf_8
XFILLER_0_20_32 VGND VGND VPWR VPWR sky130_fd_sc_hd__fill_2
XFILLER_0_20_43 VGND VGND VPWR VPWR sky130_fd_sc_hd__fill_1
XFILLER_0_25_355 VGND VGND VPWR VPWR sky130_fd_sc_hd__fill_1
XFILLER_0_52_141 VGND VGND VPWR VPWR sky130_fd_sc_hd__fill_1
Xhold418 RF.reg_arr\[2\]\[2\] VGND VGND VPWR VPWR net500 sky130_fd_sc_hd__dlygate4sd3_1
Xhold407 RF.reg_arr\[19\]\[6\] VGND VGND VPWR VPWR net489 sky130_fd_sc_hd__dlygate4sd3_1
XFILLER_0_20_65 VGND VGND VPWR VPWR sky130_fd_sc_hd__fill_1
XFILLER_0_25_388 VGND VGND VPWR VPWR sky130_fd_sc_hd__decap_4
X_4470_ RF.reg_arr\[24\]\[11\] RF.reg_arr\[25\]\[11\] RF.reg_arr\[26\]\[11\] RF.reg_arr\[27\]\[11\]
+ _1068_ _1069_ VGND VGND VPWR VPWR _1259_ sky130_fd_sc_hd__mux4_2
Xhold429 RF.reg_arr\[29\]\[24\] VGND VGND VPWR VPWR net511 sky130_fd_sc_hd__dlygate4sd3_1
XFILLER_0_20_98 VGND VGND VPWR VPWR sky130_fd_sc_hd__fill_2
XFILLER_0_110_257 VGND VGND VPWR VPWR sky130_fd_sc_hd__fill_1
X_6140_ _2900_ _2901_ VGND VGND VPWR VPWR _2902_ sky130_fd_sc_hd__nor2_1
X_6071_ _2833_ _2835_ _2443_ VGND VGND VPWR VPWR _2837_ sky130_fd_sc_hd__a21o_1
X_5022_ _1791_ _1810_ VGND VGND VPWR VPWR _1811_ sky130_fd_sc_hd__nand2_1
XTAP_TAPCELL_ROW_49_840 VGND VPWR sky130_fd_sc_hd__tapvpwrvgnd_1
XFILLER_0_95_509 VGND VGND VPWR VPWR sky130_fd_sc_hd__fill_1
X_6973_ _3419_ VGND VGND VPWR VPWR _0045_ sky130_fd_sc_hd__clkbuf_1
X_5924_ _1517_ _1533_ net85 _2547_ VGND VGND VPWR VPWR _2698_ sky130_fd_sc_hd__o31a_1
X_8712_ clknet_leaf_12_CLK _0969_ VGND VGND VPWR VPWR RF.reg_arr\[14\]\[10\] sky130_fd_sc_hd__dfxtp_1
X_5855_ _2560_ _2632_ _1830_ VGND VGND VPWR VPWR _2633_ sky130_fd_sc_hd__mux2_1
XFILLER_0_0_53 VGND VGND VPWR VPWR sky130_fd_sc_hd__decap_3
X_8643_ clknet_leaf_79_CLK _0900_ VGND VGND VPWR VPWR RF.reg_arr\[8\]\[5\] sky130_fd_sc_hd__dfxtp_1
XFILLER_0_29_650 VGND VGND VPWR VPWR sky130_fd_sc_hd__fill_1
XFILLER_0_61_94 VGND VGND VPWR VPWR sky130_fd_sc_hd__fill_2
XFILLER_0_0_97 VPWR VGND VPWR VGND sky130_ef_sc_hd__decap_12
X_4806_ _1594_ VGND VGND VPWR VPWR _1595_ sky130_fd_sc_hd__buf_4
X_5786_ _2340_ _2556_ _2567_ VGND VGND VPWR VPWR net78 sky130_fd_sc_hd__a21o_1
Xclkbuf_leaf_66_CLK clknet_3_5__leaf_CLK VGND VGND VPWR VPWR clknet_leaf_66_CLK sky130_fd_sc_hd__clkbuf_8
X_8574_ clknet_leaf_67_CLK _0831_ VGND VGND VPWR VPWR RF.reg_arr\[0\]\[0\] sky130_fd_sc_hd__dfxtp_1
XFILLER_0_9_51 VGND VGND VPWR VPWR sky130_fd_sc_hd__decap_4
X_4737_ RF.reg_arr\[8\]\[14\] RF.reg_arr\[9\]\[14\] RF.reg_arr\[10\]\[14\] RF.reg_arr\[11\]\[14\]
+ _1129_ _1130_ VGND VGND VPWR VPWR _1526_ sky130_fd_sc_hd__mux4_1
XFILLER_0_44_675 VGND VGND VPWR VPWR sky130_fd_sc_hd__decap_6
X_7525_ _3718_ VGND VGND VPWR VPWR _0298_ sky130_fd_sc_hd__clkbuf_1
XFILLER_0_114_563 VPWR VGND VPWR VGND sky130_ef_sc_hd__decap_12
X_4668_ _1455_ _1456_ _1281_ VGND VGND VPWR VPWR _1457_ sky130_fd_sc_hd__mux2_1
X_7456_ _3084_ net1115 _3678_ VGND VGND VPWR VPWR _3681_ sky130_fd_sc_hd__mux2_1
XFILLER_0_16_388 VGND VGND VPWR VPWR sky130_fd_sc_hd__fill_2
X_6407_ net27 VGND VGND VPWR VPWR _3103_ sky130_fd_sc_hd__clkbuf_2
Xhold930 RF.reg_arr\[14\]\[16\] VGND VGND VPWR VPWR net1012 sky130_fd_sc_hd__dlygate4sd3_1
XFILLER_0_12_550 VGND VGND VPWR VPWR sky130_fd_sc_hd__decap_4
X_4599_ _1386_ _1387_ _1059_ VGND VGND VPWR VPWR _1388_ sky130_fd_sc_hd__mux2_1
X_9126_ clknet_leaf_82_CLK _0359_ VGND VGND VPWR VPWR RF.reg_arr\[30\]\[8\] sky130_fd_sc_hd__dfxtp_1
Xhold941 RF.reg_arr\[26\]\[6\] VGND VGND VPWR VPWR net1023 sky130_fd_sc_hd__dlygate4sd3_1
X_7387_ _3084_ net1077 _3641_ VGND VGND VPWR VPWR _3644_ sky130_fd_sc_hd__mux2_1
Xhold963 RF.reg_arr\[24\]\[7\] VGND VGND VPWR VPWR net1045 sky130_fd_sc_hd__dlygate4sd3_1
Xhold952 RF.reg_arr\[25\]\[0\] VGND VGND VPWR VPWR net1034 sky130_fd_sc_hd__dlygate4sd3_1
X_6338_ _3055_ VGND VGND VPWR VPWR _0798_ sky130_fd_sc_hd__clkbuf_1
Xhold974 RF.reg_arr\[24\]\[6\] VGND VGND VPWR VPWR net1056 sky130_fd_sc_hd__dlygate4sd3_1
Xhold996 RF.reg_arr\[2\]\[12\] VGND VGND VPWR VPWR net1078 sky130_fd_sc_hd__dlygate4sd3_1
Xhold985 RF.reg_arr\[27\]\[19\] VGND VGND VPWR VPWR net1067 sky130_fd_sc_hd__dlygate4sd3_1
X_6269_ _3011_ VGND VGND VPWR VPWR _0773_ sky130_fd_sc_hd__clkbuf_1
X_9057_ clknet_leaf_69_CLK _0290_ VGND VGND VPWR VPWR RF.reg_arr\[28\]\[3\] sky130_fd_sc_hd__dfxtp_1
X_8008_ _3974_ VGND VGND VPWR VPWR _0525_ sky130_fd_sc_hd__clkbuf_1
XFILLER_0_94_520 VGND VGND VPWR VPWR sky130_fd_sc_hd__fill_2
XTAP_TAPCELL_ROW_27_578 VGND VPWR sky130_fd_sc_hd__tapvpwrvgnd_1
XFILLER_0_39_458 VGND VGND VPWR VPWR sky130_fd_sc_hd__decap_3
XFILLER_0_81_225 VGND VGND VPWR VPWR sky130_fd_sc_hd__decap_4
Xclkbuf_leaf_57_CLK clknet_3_7__leaf_CLK VGND VGND VPWR VPWR clknet_leaf_57_CLK sky130_fd_sc_hd__clkbuf_8
XFILLER_0_34_141 VGND VGND VPWR VPWR sky130_fd_sc_hd__fill_1
XFILLER_0_105_552 VGND VGND VPWR VPWR sky130_fd_sc_hd__decap_8
XFILLER_0_30_380 VGND VGND VPWR VPWR sky130_fd_sc_hd__fill_1
XPHY_EDGE_ROW_13_Right_13 VGND VGND VPWR VPWR sky130_fd_sc_hd__decap_3
XFILLER_0_82_27 VGND VGND VPWR VPWR sky130_fd_sc_hd__fill_1
XFILLER_0_106_45 VGND VGND VPWR VPWR sky130_fd_sc_hd__fill_1
XFILLER_0_85_520 VPWR VGND VPWR VGND sky130_ef_sc_hd__decap_12
XFILLER_0_97_391 VGND VGND VPWR VPWR sky130_fd_sc_hd__fill_1
XFILLER_0_85_586 VGND VGND VPWR VPWR sky130_fd_sc_hd__fill_2
XFILLER_0_85_564 VGND VGND VPWR VPWR sky130_fd_sc_hd__decap_3
XFILLER_0_17_108 VGND VGND VPWR VPWR sky130_fd_sc_hd__decap_4
Xclkbuf_leaf_48_CLK clknet_3_6__leaf_CLK VGND VGND VPWR VPWR clknet_leaf_48_CLK sky130_fd_sc_hd__clkbuf_8
X_5640_ _1792_ _2121_ VGND VGND VPWR VPWR _2427_ sky130_fd_sc_hd__nand2_1
XFILLER_0_26_642 VGND VGND VPWR VPWR sky130_fd_sc_hd__fill_2
X_5571_ _2356_ _2358_ _1737_ VGND VGND VPWR VPWR _2359_ sky130_fd_sc_hd__mux2_1
XPHY_EDGE_ROW_22_Right_22 VGND VGND VPWR VPWR sky130_fd_sc_hd__decap_3
X_4522_ RF.reg_arr\[4\]\[29\] RF.reg_arr\[5\]\[29\] RF.reg_arr\[6\]\[29\] RF.reg_arr\[7\]\[29\]
+ _1303_ _1305_ VGND VGND VPWR VPWR _1311_ sky130_fd_sc_hd__mux4_1
X_7310_ _3075_ net1025 _3594_ VGND VGND VPWR VPWR _3603_ sky130_fd_sc_hd__mux2_1
XFILLER_0_25_163 VGND VGND VPWR VPWR sky130_fd_sc_hd__decap_4
XFILLER_0_41_634 VGND VGND VPWR VPWR sky130_fd_sc_hd__fill_1
X_8290_ _4123_ VGND VGND VPWR VPWR _0658_ sky130_fd_sc_hd__clkbuf_1
XFILLER_0_111_511 VGND VGND VPWR VPWR sky130_fd_sc_hd__decap_4
Xhold204 RF.reg_arr\[21\]\[30\] VGND VGND VPWR VPWR net286 sky130_fd_sc_hd__dlygate4sd3_1
Xhold226 RF.reg_arr\[13\]\[20\] VGND VGND VPWR VPWR net308 sky130_fd_sc_hd__dlygate4sd3_1
Xhold215 RF.reg_arr\[10\]\[2\] VGND VGND VPWR VPWR net297 sky130_fd_sc_hd__dlygate4sd3_1
X_7241_ _3566_ VGND VGND VPWR VPWR _0166_ sky130_fd_sc_hd__clkbuf_1
XFILLER_0_25_196 VGND VGND VPWR VPWR sky130_fd_sc_hd__decap_4
X_4453_ _1240_ _1241_ _1033_ VGND VGND VPWR VPWR _1242_ sky130_fd_sc_hd__mux2_1
XTAP_TAPCELL_ROW_96_1399 VGND VPWR sky130_fd_sc_hd__tapvpwrvgnd_1
Xhold248 RF.reg_arr\[11\]\[14\] VGND VGND VPWR VPWR net330 sky130_fd_sc_hd__dlygate4sd3_1
Xhold259 RF.reg_arr\[13\]\[16\] VGND VGND VPWR VPWR net341 sky130_fd_sc_hd__dlygate4sd3_1
Xhold237 RF.reg_arr\[3\]\[19\] VGND VGND VPWR VPWR net319 sky130_fd_sc_hd__dlygate4sd3_1
XFILLER_0_111_566 VPWR VGND VPWR VGND sky130_ef_sc_hd__decap_12
X_4384_ _1062_ VGND VGND VPWR VPWR _1173_ sky130_fd_sc_hd__buf_4
X_7172_ _3529_ VGND VGND VPWR VPWR _0134_ sky130_fd_sc_hd__clkbuf_1
X_6123_ _2485_ _2756_ _2885_ _2521_ VGND VGND VPWR VPWR _2886_ sky130_fd_sc_hd__a211oi_1
X_6054_ _2783_ _2820_ _2434_ VGND VGND VPWR VPWR _2821_ sky130_fd_sc_hd__mux2_1
XPHY_EDGE_ROW_31_Right_31 VGND VGND VPWR VPWR sky130_fd_sc_hd__decap_3
X_5005_ RF.reg_arr\[16\]\[25\] RF.reg_arr\[17\]\[25\] RF.reg_arr\[18\]\[25\] RF.reg_arr\[19\]\[25\]
+ _1677_ _1683_ VGND VGND VPWR VPWR _1794_ sky130_fd_sc_hd__mux4_1
XFILLER_0_22_3 VGND VGND VPWR VPWR sky130_fd_sc_hd__fill_2
X_6956_ net1019 _3407_ _3389_ VGND VGND VPWR VPWR _3408_ sky130_fd_sc_hd__mux2_1
X_5907_ _2026_ _2680_ _2681_ _2682_ VGND VGND VPWR VPWR _2683_ sky130_fd_sc_hd__o211a_1
XFILLER_0_76_531 VGND VGND VPWR VPWR sky130_fd_sc_hd__fill_1
XTAP_TAPCELL_ROW_62_1001 VGND VPWR sky130_fd_sc_hd__tapvpwrvgnd_1
XTAP_TAPCELL_ROW_24_537 VGND VPWR sky130_fd_sc_hd__tapvpwrvgnd_1
X_6887_ net604 _3033_ _3355_ VGND VGND VPWR VPWR _3363_ sky130_fd_sc_hd__mux2_1
X_5838_ _2594_ _2616_ _2366_ VGND VGND VPWR VPWR _2617_ sky130_fd_sc_hd__mux2_1
Xclkbuf_leaf_39_CLK clknet_3_3__leaf_CLK VGND VGND VPWR VPWR clknet_leaf_39_CLK sky130_fd_sc_hd__clkbuf_8
X_8626_ clknet_leaf_14_CLK _0883_ VGND VGND VPWR VPWR RF.reg_arr\[16\]\[20\] sky130_fd_sc_hd__dfxtp_1
XPHY_EDGE_ROW_40_Right_40 VGND VGND VPWR VPWR sky130_fd_sc_hd__decap_3
XTAP_TAPCELL_ROW_52_879 VGND VPWR sky130_fd_sc_hd__tapvpwrvgnd_1
X_5769_ _2253_ _2549_ VGND VGND VPWR VPWR _2551_ sky130_fd_sc_hd__nor2_1
X_8557_ clknet_leaf_104_CLK _0814_ VGND VGND VPWR VPWR RF.reg_arr\[23\]\[15\] sky130_fd_sc_hd__dfxtp_1
X_7508_ _3709_ VGND VGND VPWR VPWR _0290_ sky130_fd_sc_hd__clkbuf_1
X_8488_ net1024 net22 _4222_ VGND VGND VPWR VPWR _4228_ sky130_fd_sc_hd__mux2_1
X_7439_ _3067_ net804 _3667_ VGND VGND VPWR VPWR _3672_ sky130_fd_sc_hd__mux2_1
XFILLER_0_31_155 VGND VGND VPWR VPWR sky130_fd_sc_hd__fill_2
XTAP_TAPCELL_ROW_73_1130 VGND VPWR sky130_fd_sc_hd__tapvpwrvgnd_1
Xhold760 RF.reg_arr\[12\]\[22\] VGND VGND VPWR VPWR net842 sky130_fd_sc_hd__dlygate4sd3_1
XFILLER_0_12_391 VGND VGND VPWR VPWR sky130_fd_sc_hd__decap_4
Xhold782 RF.reg_arr\[21\]\[5\] VGND VGND VPWR VPWR net864 sky130_fd_sc_hd__dlygate4sd3_1
Xhold771 RF.reg_arr\[12\]\[13\] VGND VGND VPWR VPWR net853 sky130_fd_sc_hd__dlygate4sd3_1
X_9109_ clknet_leaf_41_CLK _0342_ VGND VGND VPWR VPWR RF.reg_arr\[2\]\[23\] sky130_fd_sc_hd__dfxtp_1
Xhold793 RF.reg_arr\[10\]\[16\] VGND VGND VPWR VPWR net875 sky130_fd_sc_hd__dlygate4sd3_1
XFILLER_0_98_100 VGND VGND VPWR VPWR sky130_fd_sc_hd__fill_1
XFILLER_0_59_509 VGND VGND VPWR VPWR sky130_fd_sc_hd__fill_1
XTAP_TAPCELL_ROW_4_295 VGND VPWR sky130_fd_sc_hd__tapvpwrvgnd_1
XFILLER_0_79_391 VGND VGND VPWR VPWR sky130_fd_sc_hd__fill_1
XFILLER_0_39_244 VGND VGND VPWR VPWR sky130_fd_sc_hd__fill_1
XFILLER_0_2_539 VGND VGND VPWR VPWR sky130_fd_sc_hd__fill_1
XFILLER_0_22_188 VGND VGND VPWR VPWR sky130_fd_sc_hd__decap_8
XFILLER_0_93_15 VGND VGND VPWR VPWR sky130_fd_sc_hd__fill_1
X_6810_ net681 _3025_ _3318_ VGND VGND VPWR VPWR _3322_ sky130_fd_sc_hd__mux2_1
XFILLER_0_58_553 VGND VGND VPWR VPWR sky130_fd_sc_hd__fill_2
X_7790_ _3858_ VGND VGND VPWR VPWR _0423_ sky130_fd_sc_hd__clkbuf_1
XFILLER_0_85_372 VGND VGND VPWR VPWR sky130_fd_sc_hd__fill_1
X_6741_ _3086_ net998 _3281_ VGND VGND VPWR VPWR _3285_ sky130_fd_sc_hd__mux2_1
X_9460_ clknet_leaf_45_CLK _0693_ VGND VGND VPWR VPWR RF.reg_arr\[12\]\[22\] sky130_fd_sc_hd__dfxtp_1
XTAP_TAPCELL_ROW_21_507 VGND VPWR sky130_fd_sc_hd__tapvpwrvgnd_1
X_6672_ _3247_ VGND VGND VPWR VPWR _0940_ sky130_fd_sc_hd__clkbuf_1
XFILLER_0_45_214 VGND VGND VPWR VPWR sky130_fd_sc_hd__fill_2
XTAP_TAPCELL_ROW_98_1428 VGND VPWR sky130_fd_sc_hd__tapvpwrvgnd_1
X_5623_ _1114_ _2293_ VGND VGND VPWR VPWR _2411_ sky130_fd_sc_hd__nand2_1
X_9391_ clknet_leaf_104_CLK _0624_ VGND VGND VPWR VPWR RF.reg_arr\[13\]\[17\] sky130_fd_sc_hd__dfxtp_1
XFILLER_0_5_311 VGND VGND VPWR VPWR sky130_fd_sc_hd__decap_4
X_8411_ net609 _3414_ _4185_ VGND VGND VPWR VPWR _4188_ sky130_fd_sc_hd__mux2_1
XFILLER_0_45_247 VGND VGND VPWR VPWR sky130_fd_sc_hd__fill_1
XFILLER_0_116_669 VGND VGND VPWR VPWR sky130_fd_sc_hd__decap_3
X_8342_ _4151_ VGND VGND VPWR VPWR _0682_ sky130_fd_sc_hd__clkbuf_1
X_5554_ _1092_ _2023_ _2342_ VGND VGND VPWR VPWR net49 sky130_fd_sc_hd__o21ai_1
X_4505_ RF.reg_arr\[20\]\[29\] RF.reg_arr\[21\]\[29\] RF.reg_arr\[22\]\[29\] RF.reg_arr\[23\]\[29\]
+ _1273_ _1275_ VGND VGND VPWR VPWR _1294_ sky130_fd_sc_hd__mux4_1
X_5485_ _2255_ _2273_ VGND VGND VPWR VPWR _2274_ sky130_fd_sc_hd__nand2_1
X_8273_ net706 _3412_ _4113_ VGND VGND VPWR VPWR _4115_ sky130_fd_sc_hd__mux2_1
X_4436_ RF.reg_arr\[16\]\[9\] RF.reg_arr\[17\]\[9\] RF.reg_arr\[18\]\[9\] RF.reg_arr\[19\]\[9\]
+ _1105_ _1106_ VGND VGND VPWR VPWR _1225_ sky130_fd_sc_hd__mux4_1
X_7224_ _2974_ _2996_ _3556_ VGND VGND VPWR VPWR _3557_ sky130_fd_sc_hd__nand3_4
X_7155_ _3447_ _3305_ VGND VGND VPWR VPWR _3520_ sky130_fd_sc_hd__nor2_4
X_4367_ RF.reg_arr\[0\]\[17\] RF.reg_arr\[1\]\[17\] RF.reg_arr\[2\]\[17\] RF.reg_arr\[3\]\[17\]
+ _1134_ _1135_ VGND VGND VPWR VPWR _1156_ sky130_fd_sc_hd__mux4_1
X_6106_ _2869_ _2859_ _2759_ VGND VGND VPWR VPWR _2870_ sky130_fd_sc_hd__a21oi_1
XFILLER_0_6_85 VGND VGND VPWR VPWR sky130_fd_sc_hd__fill_2
X_7086_ _3483_ VGND VGND VPWR VPWR _0094_ sky130_fd_sc_hd__clkbuf_1
X_4298_ RF.reg_arr\[0\]\[4\] RF.reg_arr\[1\]\[4\] RF.reg_arr\[2\]\[4\] RF.reg_arr\[3\]\[4\]
+ _1044_ _1046_ VGND VGND VPWR VPWR _1087_ sky130_fd_sc_hd__mux4_1
X_6037_ _2340_ _2803_ _2804_ VGND VGND VPWR VPWR _2805_ sky130_fd_sc_hd__and3_1
XTAP_TAPCELL_ROW_57_938 VGND VPWR sky130_fd_sc_hd__tapvpwrvgnd_1
XTAP_TAPCELL_ROW_107_1535 VGND VPWR sky130_fd_sc_hd__tapvpwrvgnd_1
XTAP_TAPCELL_ROW_1_265 VGND VPWR sky130_fd_sc_hd__tapvpwrvgnd_1
X_7988_ _3008_ net909 _3958_ VGND VGND VPWR VPWR _3964_ sky130_fd_sc_hd__mux2_1
XFILLER_0_95_169 VGND VGND VPWR VPWR sky130_fd_sc_hd__decap_4
XTAP_TAPCELL_ROW_37_695 VGND VPWR sky130_fd_sc_hd__tapvpwrvgnd_1
X_6939_ _3396_ VGND VGND VPWR VPWR _0034_ sky130_fd_sc_hd__clkbuf_1
X_8609_ clknet_leaf_70_CLK _0866_ VGND VGND VPWR VPWR RF.reg_arr\[16\]\[3\] sky130_fd_sc_hd__dfxtp_1
XFILLER_0_51_239 VGND VGND VPWR VPWR sky130_fd_sc_hd__fill_1
XFILLER_0_115_691 VGND VGND VPWR VPWR sky130_fd_sc_hd__fill_1
XFILLER_0_32_475 VGND VGND VPWR VPWR sky130_fd_sc_hd__fill_1
Xhold590 RF.reg_arr\[22\]\[12\] VGND VGND VPWR VPWR net672 sky130_fd_sc_hd__dlygate4sd3_1
XTAP_TAPCELL_ROW_9_365 VGND VPWR sky130_fd_sc_hd__tapvpwrvgnd_1
XTAP_TAPCELL_ROW_9_354 VGND VPWR sky130_fd_sc_hd__tapvpwrvgnd_1
XFILLER_0_95_670 VGND VGND VPWR VPWR sky130_fd_sc_hd__fill_2
XFILLER_0_27_236 VGND VGND VPWR VPWR sky130_fd_sc_hd__decap_3
XFILLER_0_82_331 VGND VGND VPWR VPWR sky130_fd_sc_hd__decap_8
XFILLER_0_55_567 VGND VGND VPWR VPWR sky130_fd_sc_hd__decap_4
XFILLER_0_55_589 VGND VGND VPWR VPWR sky130_fd_sc_hd__decap_4
XFILLER_0_2_303 VGND VGND VPWR VPWR sky130_fd_sc_hd__fill_2
XFILLER_0_112_138 VGND VGND VPWR VPWR sky130_fd_sc_hd__fill_2
XFILLER_0_106_691 VGND VGND VPWR VPWR sky130_fd_sc_hd__fill_1
X_5270_ RF.reg_arr\[8\]\[10\] RF.reg_arr\[9\]\[10\] RF.reg_arr\[10\]\[10\] RF.reg_arr\[11\]\[10\]
+ _1676_ _1682_ VGND VGND VPWR VPWR _2059_ sky130_fd_sc_hd__mux4_1
XTAP_TAPCELL_ROW_93_1369 VGND VPWR sky130_fd_sc_hd__tapvpwrvgnd_1
X_8960_ clknet_leaf_68_CLK _0193_ VGND VGND VPWR VPWR RF.reg_arr\[31\]\[2\] sky130_fd_sc_hd__dfxtp_1
X_7911_ _3923_ VGND VGND VPWR VPWR _0479_ sky130_fd_sc_hd__clkbuf_1
X_8891_ clknet_leaf_26_CLK _0124_ VGND VGND VPWR VPWR RF.reg_arr\[3\]\[29\] sky130_fd_sc_hd__dfxtp_1
X_7842_ _3056_ net1048 _3886_ VGND VGND VPWR VPWR _3887_ sky130_fd_sc_hd__mux2_1
X_4985_ _1756_ _1773_ VGND VGND VPWR VPWR _1774_ sky130_fd_sc_hd__nand2_1
XFILLER_0_93_629 VGND VGND VPWR VPWR sky130_fd_sc_hd__decap_6
XFILLER_0_86_670 VGND VGND VPWR VPWR sky130_fd_sc_hd__fill_1
X_7773_ _3056_ net1070 _3849_ VGND VGND VPWR VPWR _3850_ sky130_fd_sc_hd__mux2_1
X_6724_ _3069_ net952 _3270_ VGND VGND VPWR VPWR _3276_ sky130_fd_sc_hd__mux2_1
XTAP_TAPCELL_ROW_34_654 VGND VPWR sky130_fd_sc_hd__tapvpwrvgnd_1
XTAP_TAPCELL_ROW_34_665 VGND VPWR sky130_fd_sc_hd__tapvpwrvgnd_1
X_9512_ clknet_leaf_12_CLK _0745_ VGND VGND VPWR VPWR RF.reg_arr\[10\]\[10\] sky130_fd_sc_hd__dfxtp_1
XTAP_TAPCELL_ROW_102_1476 VGND VPWR sky130_fd_sc_hd__tapvpwrvgnd_1
XTAP_TAPCELL_ROW_62_996 VGND VPWR sky130_fd_sc_hd__tapvpwrvgnd_1
X_9443_ clknet_leaf_79_CLK _0676_ VGND VGND VPWR VPWR RF.reg_arr\[12\]\[5\] sky130_fd_sc_hd__dfxtp_1
X_6655_ _3238_ VGND VGND VPWR VPWR _0932_ sky130_fd_sc_hd__clkbuf_1
XFILLER_0_6_653 VGND VGND VPWR VPWR sky130_fd_sc_hd__fill_1
XFILLER_0_6_642 VGND VGND VPWR VPWR sky130_fd_sc_hd__fill_2
XFILLER_0_104_606 VGND VGND VPWR VPWR sky130_fd_sc_hd__decap_8
X_5606_ _1833_ _2157_ _1114_ VGND VGND VPWR VPWR _2394_ sky130_fd_sc_hd__o21ai_1
X_6586_ net644 _3008_ _3196_ VGND VGND VPWR VPWR _3202_ sky130_fd_sc_hd__mux2_1
XFILLER_0_26_291 VGND VGND VPWR VPWR sky130_fd_sc_hd__fill_1
X_9374_ clknet_leaf_70_CLK _0607_ VGND VGND VPWR VPWR RF.reg_arr\[13\]\[0\] sky130_fd_sc_hd__dfxtp_1
XFILLER_0_103_127 VGND VGND VPWR VPWR sky130_fd_sc_hd__fill_1
X_5537_ RF.reg_arr\[4\]\[1\] RF.reg_arr\[5\]\[1\] RF.reg_arr\[6\]\[1\] RF.reg_arr\[7\]\[1\]
+ _1621_ _1594_ VGND VGND VPWR VPWR _2326_ sky130_fd_sc_hd__mux4_1
X_8325_ _4142_ VGND VGND VPWR VPWR _0674_ sky130_fd_sc_hd__clkbuf_1
XFILLER_0_14_486 VGND VGND VPWR VPWR sky130_fd_sc_hd__decap_3
X_8256_ net553 _3395_ _4102_ VGND VGND VPWR VPWR _4106_ sky130_fd_sc_hd__mux2_1
XFILLER_0_112_683 VGND VGND VPWR VPWR sky130_fd_sc_hd__decap_8
X_7207_ net150 _3371_ _3543_ VGND VGND VPWR VPWR _3548_ sky130_fd_sc_hd__mux2_1
X_5468_ RF.reg_arr\[28\]\[6\] RF.reg_arr\[29\]\[6\] RF.reg_arr\[30\]\[6\] RF.reg_arr\[31\]\[6\]
+ _1675_ _1681_ VGND VGND VPWR VPWR _2257_ sky130_fd_sc_hd__mux4_1
X_4419_ RF.reg_arr\[16\]\[8\] RF.reg_arr\[17\]\[8\] RF.reg_arr\[18\]\[8\] RF.reg_arr\[19\]\[8\]
+ _1050_ _1052_ VGND VGND VPWR VPWR _1208_ sky130_fd_sc_hd__mux4_1
XTAP_TAPCELL_ROW_6_324 VGND VPWR sky130_fd_sc_hd__tapvpwrvgnd_1
X_5399_ RF.reg_arr\[4\]\[13\] RF.reg_arr\[5\]\[13\] RF.reg_arr\[6\]\[13\] RF.reg_arr\[7\]\[13\]
+ _1846_ _1849_ VGND VGND VPWR VPWR _2188_ sky130_fd_sc_hd__mux4_1
X_8187_ _4069_ VGND VGND VPWR VPWR _0609_ sky130_fd_sc_hd__clkbuf_1
X_7138_ _3511_ VGND VGND VPWR VPWR _0118_ sky130_fd_sc_hd__clkbuf_1
X_7069_ net215 _3437_ _3471_ VGND VGND VPWR VPWR _3475_ sky130_fd_sc_hd__mux2_1
XFILLER_0_96_401 VGND VGND VPWR VPWR sky130_fd_sc_hd__fill_1
XFILLER_0_69_626 VGND VGND VPWR VPWR sky130_fd_sc_hd__decap_4
XFILLER_0_69_615 VGND VGND VPWR VPWR sky130_fd_sc_hd__fill_1
XTAP_TAPCELL_ROW_68_1073 VGND VPWR sky130_fd_sc_hd__tapvpwrvgnd_1
XTAP_TAPCELL_ROW_68_1062 VGND VPWR sky130_fd_sc_hd__tapvpwrvgnd_1
XFILLER_0_56_309 VGND VGND VPWR VPWR sky130_fd_sc_hd__fill_1
XFILLER_0_77_681 VGND VGND VPWR VPWR sky130_fd_sc_hd__fill_2
XFILLER_0_107_400 VGND VGND VPWR VPWR sky130_fd_sc_hd__decap_3
Xinput19 WD3[14] VGND VGND VPWR VPWR net19 sky130_fd_sc_hd__buf_1
XFILLER_0_32_250 VGND VGND VPWR VPWR sky130_fd_sc_hd__fill_2
XFILLER_0_103_661 VGND VGND VPWR VPWR sky130_fd_sc_hd__decap_3
XFILLER_0_58_29 VGND VGND VPWR VPWR sky130_fd_sc_hd__fill_1
XFILLER_0_32_261 VGND VGND VPWR VPWR sky130_fd_sc_hd__decap_8
XFILLER_0_90_27 VGND VGND VPWR VPWR sky130_fd_sc_hd__fill_1
X_4770_ _1284_ _1558_ VGND VGND VPWR VPWR _1559_ sky130_fd_sc_hd__or2_1
XTAP_TAPCELL_ROW_31_624 VGND VPWR sky130_fd_sc_hd__tapvpwrvgnd_1
XFILLER_0_83_673 VGND VGND VPWR VPWR sky130_fd_sc_hd__decap_6
XFILLER_0_3_601 VPWR VGND VPWR VGND sky130_ef_sc_hd__decap_12
X_6440_ net112 VGND VGND VPWR VPWR _3125_ sky130_fd_sc_hd__clkbuf_1
XFILLER_0_113_447 VGND VGND VPWR VPWR sky130_fd_sc_hd__fill_1
XTAP_TAPCELL_ROW_11_381 VGND VPWR sky130_fd_sc_hd__tapvpwrvgnd_1
X_6371_ _3078_ VGND VGND VPWR VPWR _0808_ sky130_fd_sc_hd__clkbuf_1
X_8110_ _2992_ net1072 _3993_ VGND VGND VPWR VPWR _4028_ sky130_fd_sc_hd__mux2_1
X_5322_ _2107_ _2110_ _1844_ VGND VGND VPWR VPWR _2111_ sky130_fd_sc_hd__mux2_1
XFILLER_0_100_108 VGND VGND VPWR VPWR sky130_fd_sc_hd__decap_6
X_9090_ clknet_leaf_66_CLK _0323_ VGND VGND VPWR VPWR RF.reg_arr\[2\]\[4\] sky130_fd_sc_hd__dfxtp_1
X_8041_ _3991_ VGND VGND VPWR VPWR _0541_ sky130_fd_sc_hd__clkbuf_1
X_5253_ _2040_ _2041_ _1609_ VGND VGND VPWR VPWR _2042_ sky130_fd_sc_hd__mux2_1
X_5184_ RF.reg_arr\[12\]\[16\] RF.reg_arr\[13\]\[16\] RF.reg_arr\[14\]\[16\] RF.reg_arr\[15\]\[16\]
+ _1848_ _1851_ VGND VGND VPWR VPWR _1973_ sky130_fd_sc_hd__mux4_1
XFILLER_0_48_95 VGND VGND VPWR VPWR sky130_fd_sc_hd__fill_1
XTAP_TAPCELL_ROW_39_724 VGND VPWR sky130_fd_sc_hd__tapvpwrvgnd_1
X_8943_ clknet_leaf_106_CLK _0176_ VGND VGND VPWR VPWR RF.reg_arr\[29\]\[17\] sky130_fd_sc_hd__dfxtp_1
XTAP_TAPCELL_ROW_104_1505 VGND VPWR sky130_fd_sc_hd__tapvpwrvgnd_1
X_8874_ clknet_leaf_96_CLK _0107_ VGND VGND VPWR VPWR RF.reg_arr\[3\]\[12\] sky130_fd_sc_hd__dfxtp_1
X_7825_ _3111_ net505 _3871_ VGND VGND VPWR VPWR _3877_ sky130_fd_sc_hd__mux2_1
XTAP_TAPCELL_ROW_19_481 VGND VPWR sky130_fd_sc_hd__tapvpwrvgnd_1
X_7756_ _3840_ VGND VGND VPWR VPWR _0407_ sky130_fd_sc_hd__clkbuf_1
X_4968_ RF.reg_arr\[20\]\[27\] RF.reg_arr\[21\]\[27\] RF.reg_arr\[22\]\[27\] RF.reg_arr\[23\]\[27\]
+ _1592_ _1599_ VGND VGND VPWR VPWR _1757_ sky130_fd_sc_hd__mux4_1
X_7687_ _3109_ net455 _3799_ VGND VGND VPWR VPWR _3804_ sky130_fd_sc_hd__mux2_1
X_4899_ RF.reg_arr\[8\]\[29\] RF.reg_arr\[9\]\[29\] RF.reg_arr\[10\]\[29\] RF.reg_arr\[11\]\[29\]
+ _1627_ _1629_ VGND VGND VPWR VPWR _1688_ sky130_fd_sc_hd__mux4_1
X_6707_ _3265_ VGND VGND VPWR VPWR _0957_ sky130_fd_sc_hd__clkbuf_1
XFILLER_0_34_526 VGND VGND VPWR VPWR sky130_fd_sc_hd__decap_6
X_6638_ net695 _2990_ _3195_ VGND VGND VPWR VPWR _3229_ sky130_fd_sc_hd__mux2_1
XFILLER_0_61_345 VGND VGND VPWR VPWR sky130_fd_sc_hd__decap_3
X_9426_ clknet_leaf_14_CLK _0659_ VGND VGND VPWR VPWR RF.reg_arr\[17\]\[20\] sky130_fd_sc_hd__dfxtp_1
X_9357_ clknet_leaf_104_CLK _0590_ VGND VGND VPWR VPWR RF.reg_arr\[18\]\[15\] sky130_fd_sc_hd__dfxtp_1
XFILLER_0_6_483 VPWR VGND VPWR VGND sky130_ef_sc_hd__decap_12
XTAP_TAPCELL_ROW_115_1634 VGND VPWR sky130_fd_sc_hd__tapvpwrvgnd_1
X_6569_ _3192_ VGND VGND VPWR VPWR _0892_ sky130_fd_sc_hd__clkbuf_1
X_8308_ net169 _3379_ _4124_ VGND VGND VPWR VPWR _4133_ sky130_fd_sc_hd__mux2_1
XFILLER_0_42_570 VGND VGND VPWR VPWR sky130_fd_sc_hd__fill_1
X_9288_ clknet_leaf_10_CLK _0521_ VGND VGND VPWR VPWR RF.reg_arr\[25\]\[10\] sky130_fd_sc_hd__dfxtp_1
XFILLER_0_112_480 VPWR VGND VPWR VGND sky130_ef_sc_hd__decap_12
X_8239_ _4096_ VGND VGND VPWR VPWR _0634_ sky130_fd_sc_hd__clkbuf_1
XFILLER_0_84_415 VGND VGND VPWR VPWR sky130_fd_sc_hd__decap_4
XPHY_EDGE_ROW_69_Right_69 VGND VGND VPWR VPWR sky130_fd_sc_hd__decap_3
XFILLER_0_80_643 VGND VGND VPWR VPWR sky130_fd_sc_hd__fill_1
XFILLER_0_64_172 VGND VGND VPWR VPWR sky130_fd_sc_hd__decap_3
XFILLER_0_80_665 VGND VGND VPWR VPWR sky130_fd_sc_hd__decap_8
XPHY_EDGE_ROW_78_Right_78 VGND VGND VPWR VPWR sky130_fd_sc_hd__decap_3
XTAP_TAPCELL_ROW_90_1328 VGND VPWR sky130_fd_sc_hd__tapvpwrvgnd_1
XFILLER_0_20_253 VGND VGND VPWR VPWR sky130_fd_sc_hd__decap_6
X_5940_ net47 _2024_ _1090_ VGND VGND VPWR VPWR _2713_ sky130_fd_sc_hd__or3_1
XPHY_EDGE_ROW_87_Right_87 VGND VGND VPWR VPWR sky130_fd_sc_hd__decap_3
X_5871_ _2646_ _2647_ VGND VGND VPWR VPWR _2648_ sky130_fd_sc_hd__nor2_1
X_7610_ _3740_ VGND VGND VPWR VPWR _3763_ sky130_fd_sc_hd__clkbuf_8
XTAP_TAPCELL_ROW_16_440 VGND VPWR sky130_fd_sc_hd__tapvpwrvgnd_1
XFILLER_0_34_97 VGND VGND VPWR VPWR sky130_fd_sc_hd__fill_2
XTAP_TAPCELL_ROW_44_782 VGND VPWR sky130_fd_sc_hd__tapvpwrvgnd_1
X_8590_ clknet_leaf_12_CLK _0847_ VGND VGND VPWR VPWR RF.reg_arr\[0\]\[16\] sky130_fd_sc_hd__dfxtp_1
X_4822_ _1610_ VGND VGND VPWR VPWR _1611_ sky130_fd_sc_hd__clkbuf_8
XFILLER_0_90_407 VGND VGND VPWR VPWR sky130_fd_sc_hd__fill_1
X_4753_ _1128_ _1541_ VGND VGND VPWR VPWR _1542_ sky130_fd_sc_hd__or2_1
X_7541_ _3726_ VGND VGND VPWR VPWR _0306_ sky130_fd_sc_hd__clkbuf_1
X_7472_ _3666_ VGND VGND VPWR VPWR _3689_ sky130_fd_sc_hd__clkbuf_8
XFILLER_0_50_85 VGND VGND VPWR VPWR sky130_fd_sc_hd__fill_2
X_6423_ _3113_ net1036 _3101_ VGND VGND VPWR VPWR _3114_ sky130_fd_sc_hd__mux2_1
X_9211_ clknet_leaf_29_CLK _0444_ VGND VGND VPWR VPWR RF.reg_arr\[24\]\[29\] sky130_fd_sc_hd__dfxtp_1
X_4684_ _1471_ _1472_ _1281_ VGND VGND VPWR VPWR _1473_ sky130_fd_sc_hd__mux2_1
XFILLER_0_43_367 VGND VGND VPWR VPWR sky130_fd_sc_hd__fill_1
XPHY_EDGE_ROW_96_Right_96 VGND VGND VPWR VPWR sky130_fd_sc_hd__decap_3
XFILLER_0_70_197 VGND VGND VPWR VPWR sky130_fd_sc_hd__decap_8
X_9142_ clknet_leaf_51_CLK _0375_ VGND VGND VPWR VPWR RF.reg_arr\[30\]\[24\] sky130_fd_sc_hd__dfxtp_1
X_6354_ net40 VGND VGND VPWR VPWR _3067_ sky130_fd_sc_hd__clkbuf_2
X_5305_ _2090_ _2093_ _1842_ VGND VGND VPWR VPWR _2094_ sky130_fd_sc_hd__mux2_1
X_9073_ clknet_leaf_4_CLK _0306_ VGND VGND VPWR VPWR RF.reg_arr\[28\]\[19\] sky130_fd_sc_hd__dfxtp_1
X_6285_ _3022_ VGND VGND VPWR VPWR _0778_ sky130_fd_sc_hd__clkbuf_1
X_5236_ net47 _2024_ _1090_ VGND VGND VPWR VPWR _2025_ sky130_fd_sc_hd__or3b_2
X_8024_ _3044_ net777 _3980_ VGND VGND VPWR VPWR _3983_ sky130_fd_sc_hd__mux2_1
XTAP_TAPCELL_ROW_110_1575 VGND VPWR sky130_fd_sc_hd__tapvpwrvgnd_1
XPHY_EDGE_ROW_3_Left_120 VGND VGND VPWR VPWR sky130_fd_sc_hd__decap_3
X_5167_ RF.reg_arr\[8\]\[19\] RF.reg_arr\[9\]\[19\] RF.reg_arr\[10\]\[19\] RF.reg_arr\[11\]\[19\]
+ _1676_ _1682_ VGND VGND VPWR VPWR _1956_ sky130_fd_sc_hd__mux4_1
X_5098_ RF.reg_arr\[8\]\[23\] RF.reg_arr\[9\]\[23\] RF.reg_arr\[10\]\[23\] RF.reg_arr\[11\]\[23\]
+ _1884_ _1886_ VGND VGND VPWR VPWR _1887_ sky130_fd_sc_hd__mux4_1
X_8926_ clknet_leaf_71_CLK _0159_ VGND VGND VPWR VPWR RF.reg_arr\[29\]\[0\] sky130_fd_sc_hd__dfxtp_1
XFILLER_0_78_253 VGND VGND VPWR VPWR sky130_fd_sc_hd__fill_1
XFILLER_0_66_404 VGND VGND VPWR VPWR sky130_fd_sc_hd__fill_2
X_8857_ clknet_leaf_39_CLK _0090_ VGND VGND VPWR VPWR RF.reg_arr\[19\]\[27\] sky130_fd_sc_hd__dfxtp_1
XTAP_TAPCELL_ROW_65_1032 VGND VPWR sky130_fd_sc_hd__tapvpwrvgnd_1
X_8788_ clknet_leaf_45_CLK _0021_ VGND VGND VPWR VPWR RF.reg_arr\[5\]\[22\] sky130_fd_sc_hd__dfxtp_1
X_7808_ _3094_ net916 _3860_ VGND VGND VPWR VPWR _3868_ sky130_fd_sc_hd__mux2_1
X_7739_ _3831_ VGND VGND VPWR VPWR _0399_ sky130_fd_sc_hd__clkbuf_1
XFILLER_0_74_481 VGND VGND VPWR VPWR sky130_fd_sc_hd__fill_1
XFILLER_0_62_643 VGND VGND VPWR VPWR sky130_fd_sc_hd__fill_1
XPHY_EDGE_ROW_49_Left_166 VGND VGND VPWR VPWR sky130_fd_sc_hd__decap_3
X_9409_ clknet_leaf_70_CLK _0642_ VGND VGND VPWR VPWR RF.reg_arr\[17\]\[3\] sky130_fd_sc_hd__dfxtp_1
XFILLER_0_61_164 VGND VGND VPWR VPWR sky130_fd_sc_hd__fill_1
XFILLER_0_34_389 VGND VGND VPWR VPWR sky130_fd_sc_hd__decap_4
XTAP_TAPCELL_ROW_76_1161 VGND VPWR sky130_fd_sc_hd__tapvpwrvgnd_1
XPHY_EDGE_ROW_58_Left_175 VGND VGND VPWR VPWR sky130_fd_sc_hd__decap_3
XFILLER_0_69_242 VGND VGND VPWR VPWR sky130_fd_sc_hd__decap_8
XTAP_TAPCELL_ROW_87_1290 VGND VPWR sky130_fd_sc_hd__tapvpwrvgnd_1
XPHY_EDGE_ROW_67_Left_184 VGND VGND VPWR VPWR sky130_fd_sc_hd__decap_3
XTAP_TAPCELL_ROW_13_410 VGND VPWR sky130_fd_sc_hd__tapvpwrvgnd_1
XFILLER_0_37_150 VPWR VGND VPWR VGND sky130_ef_sc_hd__decap_12
XTAP_TAPCELL_ROW_41_741 VGND VPWR sky130_fd_sc_hd__tapvpwrvgnd_1
XFILLER_0_4_206 VGND VGND VPWR VPWR sky130_fd_sc_hd__decap_4
Xhold408 RF.reg_arr\[22\]\[21\] VGND VGND VPWR VPWR net490 sky130_fd_sc_hd__dlygate4sd3_1
XFILLER_0_80_484 VGND VGND VPWR VPWR sky130_fd_sc_hd__fill_1
XFILLER_0_40_326 VGND VGND VPWR VPWR sky130_fd_sc_hd__decap_3
Xhold419 RF.reg_arr\[4\]\[8\] VGND VGND VPWR VPWR net501 sky130_fd_sc_hd__dlygate4sd3_1
XFILLER_0_52_197 VGND VGND VPWR VPWR sky130_fd_sc_hd__fill_2
X_6070_ _2833_ _2835_ VGND VGND VPWR VPWR _2836_ sky130_fd_sc_hd__nor2_1
XPHY_EDGE_ROW_76_Left_193 VGND VGND VPWR VPWR sky130_fd_sc_hd__decap_3
X_5021_ _1792_ _1809_ VGND VGND VPWR VPWR _1810_ sky130_fd_sc_hd__nand2_1
XTAP_TAPCELL_ROW_49_841 VGND VPWR sky130_fd_sc_hd__tapvpwrvgnd_1
X_6972_ net259 _3418_ _3410_ VGND VGND VPWR VPWR _3419_ sky130_fd_sc_hd__mux2_1
X_8711_ clknet_leaf_64_CLK _0968_ VGND VGND VPWR VPWR RF.reg_arr\[14\]\[9\] sky130_fd_sc_hd__dfxtp_1
X_5923_ _2685_ _2690_ _2697_ _2446_ VGND VGND VPWR VPWR net54 sky130_fd_sc_hd__o22a_1
X_5854_ _2599_ _2631_ _1737_ VGND VGND VPWR VPWR _2632_ sky130_fd_sc_hd__mux2_1
XFILLER_0_8_501 VGND VGND VPWR VPWR sky130_fd_sc_hd__fill_1
X_8642_ clknet_leaf_72_CLK _0899_ VGND VGND VPWR VPWR RF.reg_arr\[8\]\[4\] sky130_fd_sc_hd__dfxtp_1
X_8573_ clknet_leaf_18_CLK _0830_ VGND VGND VPWR VPWR RF.reg_arr\[23\]\[31\] sky130_fd_sc_hd__dfxtp_1
X_4805_ net2 VGND VGND VPWR VPWR _1594_ sky130_fd_sc_hd__clkbuf_4
XFILLER_0_29_673 VPWR VGND VPWR VGND sky130_ef_sc_hd__decap_12
X_5785_ _2505_ _2558_ _2562_ _2563_ _2566_ VGND VGND VPWR VPWR _2567_ sky130_fd_sc_hd__a221o_1
XFILLER_0_16_312 VGND VGND VPWR VPWR sky130_fd_sc_hd__fill_2
XFILLER_0_56_481 VGND VGND VPWR VPWR sky130_fd_sc_hd__fill_1
X_7524_ net140 _3412_ _3716_ VGND VGND VPWR VPWR _3718_ sky130_fd_sc_hd__mux2_1
X_4736_ RF.reg_arr\[12\]\[14\] RF.reg_arr\[13\]\[14\] RF.reg_arr\[14\]\[14\] RF.reg_arr\[15\]\[14\]
+ _1164_ _1165_ VGND VGND VPWR VPWR _1525_ sky130_fd_sc_hd__mux4_1
X_4667_ RF.reg_arr\[24\]\[31\] RF.reg_arr\[25\]\[31\] RF.reg_arr\[26\]\[31\] RF.reg_arr\[27\]\[31\]
+ _1450_ _1451_ VGND VGND VPWR VPWR _1456_ sky130_fd_sc_hd__mux4_1
X_7455_ _3680_ VGND VGND VPWR VPWR _0266_ sky130_fd_sc_hd__clkbuf_1
XFILLER_0_114_575 VPWR VGND VPWR VGND sky130_ef_sc_hd__decap_12
X_6406_ _3102_ VGND VGND VPWR VPWR _0819_ sky130_fd_sc_hd__clkbuf_1
Xhold920 RF.reg_arr\[20\]\[14\] VGND VGND VPWR VPWR net1002 sky130_fd_sc_hd__dlygate4sd3_1
Xhold931 RF.reg_arr\[25\]\[19\] VGND VGND VPWR VPWR net1013 sky130_fd_sc_hd__dlygate4sd3_1
X_7386_ _3643_ VGND VGND VPWR VPWR _0234_ sky130_fd_sc_hd__clkbuf_1
X_6337_ net201 _2992_ _2997_ VGND VGND VPWR VPWR _3055_ sky130_fd_sc_hd__mux2_1
Xhold964 RF.reg_arr\[24\]\[31\] VGND VGND VPWR VPWR net1046 sky130_fd_sc_hd__dlygate4sd3_1
X_4598_ RF.reg_arr\[28\]\[6\] RF.reg_arr\[29\]\[6\] RF.reg_arr\[30\]\[6\] RF.reg_arr\[31\]\[6\]
+ net98 _1094_ VGND VGND VPWR VPWR _1387_ sky130_fd_sc_hd__mux4_1
X_9125_ clknet_leaf_99_CLK _0358_ VGND VGND VPWR VPWR RF.reg_arr\[30\]\[7\] sky130_fd_sc_hd__dfxtp_1
Xhold942 RF.reg_arr\[10\]\[17\] VGND VGND VPWR VPWR net1024 sky130_fd_sc_hd__dlygate4sd3_1
Xhold953 RF.reg_arr\[21\]\[3\] VGND VGND VPWR VPWR net1035 sky130_fd_sc_hd__dlygate4sd3_1
Xhold997 RF.reg_arr\[28\]\[15\] VGND VGND VPWR VPWR net1079 sky130_fd_sc_hd__dlygate4sd3_1
Xhold975 RF.reg_arr\[30\]\[15\] VGND VGND VPWR VPWR net1057 sky130_fd_sc_hd__dlygate4sd3_1
Xhold986 RF.reg_arr\[15\]\[13\] VGND VGND VPWR VPWR net1068 sky130_fd_sc_hd__dlygate4sd3_1
XFILLER_0_86_70 VGND VGND VPWR VPWR sky130_fd_sc_hd__fill_1
X_9056_ clknet_leaf_56_CLK _0289_ VGND VGND VPWR VPWR RF.reg_arr\[28\]\[2\] sky130_fd_sc_hd__dfxtp_1
X_6268_ net314 _3010_ _2998_ VGND VGND VPWR VPWR _3011_ sky130_fd_sc_hd__mux2_1
X_6199_ _2955_ _2957_ VGND VGND VPWR VPWR _2958_ sky130_fd_sc_hd__xnor2_1
X_8007_ _3027_ net756 _3969_ VGND VGND VPWR VPWR _3974_ sky130_fd_sc_hd__mux2_1
X_5219_ _1061_ _2007_ VGND VGND VPWR VPWR _2008_ sky130_fd_sc_hd__nand2_1
XFILLER_0_79_584 VGND VGND VPWR VPWR sky130_fd_sc_hd__decap_3
XFILLER_0_66_212 VGND VGND VPWR VPWR sky130_fd_sc_hd__fill_1
X_8909_ clknet_leaf_2_CLK _0142_ VGND VGND VPWR VPWR RF.reg_arr\[7\]\[15\] sky130_fd_sc_hd__dfxtp_1
XFILLER_0_66_234 VGND VGND VPWR VPWR sky130_fd_sc_hd__fill_2
XTAP_TAPCELL_ROW_27_579 VGND VPWR sky130_fd_sc_hd__tapvpwrvgnd_1
XFILLER_0_94_587 VGND VGND VPWR VPWR sky130_fd_sc_hd__fill_1
XFILLER_0_81_204 VGND VGND VPWR VPWR sky130_fd_sc_hd__decap_4
XFILLER_0_19_150 VGND VGND VPWR VPWR sky130_fd_sc_hd__fill_2
XFILLER_0_105_531 VPWR VGND VPWR VGND sky130_ef_sc_hd__decap_12
XFILLER_0_34_186 VGND VGND VPWR VPWR sky130_fd_sc_hd__decap_8
XTAP_TAPCELL_ROW_46_800 VGND VPWR sky130_fd_sc_hd__tapvpwrvgnd_1
XFILLER_0_106_79 VGND VGND VPWR VPWR sky130_fd_sc_hd__decap_4
XFILLER_0_106_57 VGND VGND VPWR VPWR sky130_fd_sc_hd__fill_1
XFILLER_0_15_66 VGND VGND VPWR VPWR sky130_fd_sc_hd__decap_4
XFILLER_0_85_532 VGND VGND VPWR VPWR sky130_fd_sc_hd__fill_2
XFILLER_0_15_99 VGND VGND VPWR VPWR sky130_fd_sc_hd__fill_2
XFILLER_0_31_43 VPWR VGND VPWR VGND sky130_ef_sc_hd__decap_12
X_5570_ _1756_ _1809_ _2357_ VGND VGND VPWR VPWR _2358_ sky130_fd_sc_hd__o21bai_1
XFILLER_0_110_3 VPWR VGND VPWR VGND sky130_ef_sc_hd__decap_12
XFILLER_0_25_142 VPWR VGND VPWR VGND sky130_ef_sc_hd__decap_12
XFILLER_0_31_65 VGND VGND VPWR VPWR sky130_fd_sc_hd__fill_2
X_4521_ _1284_ _1309_ VGND VGND VPWR VPWR _1310_ sky130_fd_sc_hd__nor2_1
XFILLER_0_26_676 VGND VGND VPWR VPWR sky130_fd_sc_hd__decap_3
Xhold216 RF.reg_arr\[30\]\[26\] VGND VGND VPWR VPWR net298 sky130_fd_sc_hd__dlygate4sd3_1
Xhold205 RF.reg_arr\[18\]\[30\] VGND VGND VPWR VPWR net287 sky130_fd_sc_hd__dlygate4sd3_1
XFILLER_0_13_337 VGND VGND VPWR VPWR sky130_fd_sc_hd__fill_1
X_7240_ _3073_ net1039 _3558_ VGND VGND VPWR VPWR _3566_ sky130_fd_sc_hd__mux2_1
X_4452_ RF.reg_arr\[16\]\[10\] RF.reg_arr\[17\]\[10\] RF.reg_arr\[18\]\[10\] RF.reg_arr\[19\]\[10\]
+ net88 _1028_ VGND VGND VPWR VPWR _1241_ sky130_fd_sc_hd__mux4_1
XPHY_EDGE_ROW_84_Left_201 VGND VGND VPWR VPWR sky130_fd_sc_hd__decap_3
Xhold227 RF.reg_arr\[13\]\[30\] VGND VGND VPWR VPWR net309 sky130_fd_sc_hd__dlygate4sd3_1
Xhold249 RF.reg_arr\[19\]\[14\] VGND VGND VPWR VPWR net331 sky130_fd_sc_hd__dlygate4sd3_1
Xhold238 RF.reg_arr\[4\]\[7\] VGND VGND VPWR VPWR net320 sky130_fd_sc_hd__dlygate4sd3_1
XFILLER_0_111_578 VPWR VGND VPWR VGND sky130_ef_sc_hd__decap_12
XFILLER_0_0_253 VGND VGND VPWR VPWR sky130_fd_sc_hd__decap_4
XFILLER_0_21_381 VGND VGND VPWR VPWR sky130_fd_sc_hd__decap_8
X_7171_ net580 _3403_ _3521_ VGND VGND VPWR VPWR _3529_ sky130_fd_sc_hd__mux2_1
X_4383_ _1170_ _1171_ _1168_ VGND VGND VPWR VPWR _1172_ sky130_fd_sc_hd__mux2_1
X_6122_ _2430_ _2821_ _2884_ _2421_ VGND VGND VPWR VPWR _2885_ sky130_fd_sc_hd__a22o_1
X_6053_ _1870_ _1928_ VGND VGND VPWR VPWR _2820_ sky130_fd_sc_hd__nand2_1
X_5004_ RF.reg_arr\[20\]\[25\] RF.reg_arr\[21\]\[25\] RF.reg_arr\[22\]\[25\] RF.reg_arr\[23\]\[25\]
+ _1677_ _1683_ VGND VGND VPWR VPWR _1793_ sky130_fd_sc_hd__mux4_1
XFILLER_0_56_51 VGND VGND VPWR VPWR sky130_fd_sc_hd__fill_1
XFILLER_0_15_3 VPWR VGND VPWR VGND sky130_ef_sc_hd__decap_12
XPHY_EDGE_ROW_93_Left_210 VGND VGND VPWR VPWR sky130_fd_sc_hd__decap_3
X_6955_ net45 VGND VGND VPWR VPWR _3407_ sky130_fd_sc_hd__clkbuf_4
X_5906_ _2511_ _2588_ _2662_ _2353_ _1024_ VGND VGND VPWR VPWR _2682_ sky130_fd_sc_hd__o221a_1
XFILLER_0_91_513 VGND VGND VPWR VPWR sky130_fd_sc_hd__decap_6
XFILLER_0_8_320 VGND VGND VPWR VPWR sky130_fd_sc_hd__fill_1
XTAP_TAPCELL_ROW_24_538 VGND VPWR sky130_fd_sc_hd__tapvpwrvgnd_1
X_6886_ _3362_ VGND VGND VPWR VPWR _0015_ sky130_fd_sc_hd__clkbuf_1
X_8625_ clknet_leaf_5_CLK _0882_ VGND VGND VPWR VPWR RF.reg_arr\[16\]\[19\] sky130_fd_sc_hd__dfxtp_1
XFILLER_0_48_278 VGND VGND VPWR VPWR sky130_fd_sc_hd__fill_1
XFILLER_0_91_535 VPWR VGND VPWR VGND sky130_ef_sc_hd__decap_12
X_5837_ _2069_ _2427_ VGND VGND VPWR VPWR _2616_ sky130_fd_sc_hd__nand2_1
X_5768_ _2253_ _2549_ VGND VGND VPWR VPWR _2550_ sky130_fd_sc_hd__nand2_1
X_8556_ clknet_leaf_101_CLK _0813_ VGND VGND VPWR VPWR RF.reg_arr\[23\]\[14\] sky130_fd_sc_hd__dfxtp_1
X_4719_ RF.reg_arr\[8\]\[13\] RF.reg_arr\[9\]\[13\] RF.reg_arr\[10\]\[13\] RF.reg_arr\[11\]\[13\]
+ _1357_ _1358_ VGND VGND VPWR VPWR _1508_ sky130_fd_sc_hd__mux4_1
X_8487_ _4227_ VGND VGND VPWR VPWR _0751_ sky130_fd_sc_hd__clkbuf_1
X_7507_ net400 _3395_ _3705_ VGND VGND VPWR VPWR _3709_ sky130_fd_sc_hd__mux2_1
X_5699_ _2340_ _2460_ _2484_ VGND VGND VPWR VPWR net74 sky130_fd_sc_hd__a21oi_1
XFILLER_0_31_134 VGND VGND VPWR VPWR sky130_fd_sc_hd__fill_1
XFILLER_0_32_657 VGND VGND VPWR VPWR sky130_fd_sc_hd__fill_1
X_7438_ _3671_ VGND VGND VPWR VPWR _0258_ sky130_fd_sc_hd__clkbuf_1
XFILLER_0_31_167 VGND VGND VPWR VPWR sky130_fd_sc_hd__fill_1
Xhold750 RF.reg_arr\[14\]\[30\] VGND VGND VPWR VPWR net832 sky130_fd_sc_hd__dlygate4sd3_1
XTAP_TAPCELL_ROW_73_1131 VGND VPWR sky130_fd_sc_hd__tapvpwrvgnd_1
Xhold761 RF.reg_arr\[29\]\[15\] VGND VGND VPWR VPWR net843 sky130_fd_sc_hd__dlygate4sd3_1
Xhold772 RF.reg_arr\[11\]\[13\] VGND VGND VPWR VPWR net854 sky130_fd_sc_hd__dlygate4sd3_1
X_7369_ _3634_ VGND VGND VPWR VPWR _0226_ sky130_fd_sc_hd__clkbuf_1
Xhold783 RF.reg_arr\[12\]\[21\] VGND VGND VPWR VPWR net865 sky130_fd_sc_hd__dlygate4sd3_1
X_9108_ clknet_leaf_44_CLK _0341_ VGND VGND VPWR VPWR RF.reg_arr\[2\]\[22\] sky130_fd_sc_hd__dfxtp_1
Xhold794 RF.reg_arr\[16\]\[0\] VGND VGND VPWR VPWR net876 sky130_fd_sc_hd__dlygate4sd3_1
X_9039_ clknet_leaf_106_CLK _0272_ VGND VGND VPWR VPWR RF.reg_arr\[26\]\[17\] sky130_fd_sc_hd__dfxtp_1
XFILLER_0_99_668 VGND VGND VPWR VPWR sky130_fd_sc_hd__decap_4
XTAP_TAPCELL_ROW_4_296 VGND VPWR sky130_fd_sc_hd__tapvpwrvgnd_1
XPHY_EDGE_ROW_105_Right_105 VGND VGND VPWR VPWR sky130_fd_sc_hd__decap_3
XTAP_TAPCELL_ROW_84_1260 VGND VPWR sky130_fd_sc_hd__tapvpwrvgnd_1
XFILLER_0_39_223 VGND VGND VPWR VPWR sky130_fd_sc_hd__fill_1
XFILLER_0_39_234 VGND VGND VPWR VPWR sky130_fd_sc_hd__fill_1
XFILLER_0_109_122 VGND VGND VPWR VPWR sky130_fd_sc_hd__fill_1
XFILLER_0_94_384 VGND VGND VPWR VPWR sky130_fd_sc_hd__fill_2
XFILLER_0_82_524 VGND VGND VPWR VPWR sky130_fd_sc_hd__decap_8
XFILLER_0_54_237 VGND VGND VPWR VPWR sky130_fd_sc_hd__decap_3
XFILLER_0_35_462 VGND VGND VPWR VPWR sky130_fd_sc_hd__fill_1
XFILLER_0_50_421 VGND VGND VPWR VPWR sky130_fd_sc_hd__fill_2
XFILLER_0_22_156 VGND VGND VPWR VPWR sky130_fd_sc_hd__fill_1
X_6740_ _3284_ VGND VGND VPWR VPWR _0971_ sky130_fd_sc_hd__clkbuf_1
XFILLER_0_9_117 VGND VGND VPWR VPWR sky130_fd_sc_hd__fill_1
XFILLER_0_18_418 VGND VGND VPWR VPWR sky130_fd_sc_hd__fill_2
XTAP_TAPCELL_ROW_21_508 VGND VPWR sky130_fd_sc_hd__tapvpwrvgnd_1
X_6671_ _3086_ net1068 _3243_ VGND VGND VPWR VPWR _3247_ sky130_fd_sc_hd__mux2_1
XFILLER_0_116_615 VGND VGND VPWR VPWR sky130_fd_sc_hd__fill_1
X_5622_ _1700_ _2217_ VGND VGND VPWR VPWR _2410_ sky130_fd_sc_hd__nand2_1
X_9390_ clknet_leaf_3_CLK _0623_ VGND VGND VPWR VPWR RF.reg_arr\[13\]\[16\] sky130_fd_sc_hd__dfxtp_1
X_8410_ _4187_ VGND VGND VPWR VPWR _0714_ sky130_fd_sc_hd__clkbuf_1
XTAP_TAPCELL_ROW_98_1429 VGND VPWR sky130_fd_sc_hd__tapvpwrvgnd_1
X_5553_ _2026_ _2027_ _2048_ _2336_ _2341_ VGND VGND VPWR VPWR _2342_ sky130_fd_sc_hd__o311a_1
X_8341_ _3021_ net1082 _4149_ VGND VGND VPWR VPWR _4151_ sky130_fd_sc_hd__mux2_1
X_4504_ _1272_ _1283_ _1288_ _1292_ VGND VGND VPWR VPWR _1293_ sky130_fd_sc_hd__o2bb2a_4
XFILLER_0_84_6 VGND VGND VPWR VPWR sky130_fd_sc_hd__decap_4
X_5484_ _1667_ _2272_ VGND VGND VPWR VPWR _2273_ sky130_fd_sc_hd__nand2_1
X_8272_ _4114_ VGND VGND VPWR VPWR _0649_ sky130_fd_sc_hd__clkbuf_1
X_7223_ net13 net12 net11 VGND VGND VPWR VPWR _3556_ sky130_fd_sc_hd__and3_2
XFILLER_0_13_178 VGND VGND VPWR VPWR sky130_fd_sc_hd__fill_1
X_4435_ RF.reg_arr\[20\]\[9\] RF.reg_arr\[21\]\[9\] RF.reg_arr\[22\]\[9\] RF.reg_arr\[23\]\[9\]
+ _1105_ _1106_ VGND VGND VPWR VPWR _1224_ sky130_fd_sc_hd__mux4_1
X_7154_ _3519_ VGND VGND VPWR VPWR _0126_ sky130_fd_sc_hd__clkbuf_1
X_4366_ RF.reg_arr\[4\]\[17\] RF.reg_arr\[5\]\[17\] RF.reg_arr\[6\]\[17\] RF.reg_arr\[7\]\[17\]
+ _1134_ _1135_ VGND VGND VPWR VPWR _1155_ sky130_fd_sc_hd__mux4_1
X_6105_ _1580_ VGND VGND VPWR VPWR _2869_ sky130_fd_sc_hd__inv_2
X_7085_ net847 _3385_ _3448_ VGND VGND VPWR VPWR _3483_ sky130_fd_sc_hd__mux2_1
X_4297_ _1042_ _1085_ VGND VGND VPWR VPWR _1086_ sky130_fd_sc_hd__or2_1
X_6036_ _2797_ _2798_ _2802_ VGND VGND VPWR VPWR _2804_ sky130_fd_sc_hd__o21ai_1
Xrebuffer20 net1128 VGND VGND VPWR VPWR net1129 sky130_fd_sc_hd__dlygate4sd1_1
XTAP_TAPCELL_ROW_57_939 VGND VPWR sky130_fd_sc_hd__tapvpwrvgnd_1
XTAP_TAPCELL_ROW_107_1536 VGND VPWR sky130_fd_sc_hd__tapvpwrvgnd_1
XFILLER_0_68_307 VGND VGND VPWR VPWR sky130_fd_sc_hd__fill_1
XTAP_TAPCELL_ROW_1_266 VGND VPWR sky130_fd_sc_hd__tapvpwrvgnd_1
X_7987_ _3963_ VGND VGND VPWR VPWR _0515_ sky130_fd_sc_hd__clkbuf_1
XTAP_TAPCELL_ROW_37_696 VGND VPWR sky130_fd_sc_hd__tapvpwrvgnd_1
XFILLER_0_49_554 VGND VGND VPWR VPWR sky130_fd_sc_hd__decap_3
X_6938_ net822 _3395_ _3389_ VGND VGND VPWR VPWR _3396_ sky130_fd_sc_hd__mux2_1
X_6869_ _3353_ VGND VGND VPWR VPWR _0007_ sky130_fd_sc_hd__clkbuf_1
X_8608_ clknet_leaf_55_CLK _0865_ VGND VGND VPWR VPWR RF.reg_arr\[16\]\[2\] sky130_fd_sc_hd__dfxtp_1
XFILLER_0_9_673 VGND VGND VPWR VPWR sky130_fd_sc_hd__decap_4
X_8539_ clknet_leaf_26_CLK _0796_ VGND VGND VPWR VPWR RF.reg_arr\[1\]\[29\] sky130_fd_sc_hd__dfxtp_1
XFILLER_0_91_387 VGND VGND VPWR VPWR sky130_fd_sc_hd__decap_4
XFILLER_0_44_270 VGND VGND VPWR VPWR sky130_fd_sc_hd__fill_1
XFILLER_0_20_627 VGND VGND VPWR VPWR sky130_fd_sc_hd__decap_4
XTAP_TAPCELL_ROW_9_355 VGND VPWR sky130_fd_sc_hd__tapvpwrvgnd_1
XFILLER_0_4_3 VPWR VGND VPWR VGND sky130_ef_sc_hd__decap_12
Xhold580 RF.reg_arr\[21\]\[18\] VGND VGND VPWR VPWR net662 sky130_fd_sc_hd__dlygate4sd3_1
Xhold591 RF.reg_arr\[27\]\[3\] VGND VGND VPWR VPWR net673 sky130_fd_sc_hd__dlygate4sd3_1
XFILLER_0_99_476 VGND VGND VPWR VPWR sky130_fd_sc_hd__fill_1
XFILLER_0_55_502 VGND VGND VPWR VPWR sky130_fd_sc_hd__fill_2
XFILLER_0_82_365 VGND VGND VPWR VPWR sky130_fd_sc_hd__decap_4
XFILLER_0_12_56 VGND VGND VPWR VPWR sky130_fd_sc_hd__fill_1
XFILLER_0_35_281 VGND VGND VPWR VPWR sky130_fd_sc_hd__decap_4
XFILLER_0_112_128 VGND VGND VPWR VPWR sky130_fd_sc_hd__fill_1
X_8890_ clknet_leaf_28_CLK _0123_ VGND VGND VPWR VPWR RF.reg_arr\[3\]\[28\] sky130_fd_sc_hd__dfxtp_1
X_7910_ _2994_ net1066 _3922_ VGND VGND VPWR VPWR _3923_ sky130_fd_sc_hd__mux2_1
X_7841_ _3885_ VGND VGND VPWR VPWR _3886_ sky130_fd_sc_hd__clkbuf_8
X_4984_ _1583_ _1772_ VGND VGND VPWR VPWR _1773_ sky130_fd_sc_hd__or2_1
X_7772_ _3848_ VGND VGND VPWR VPWR _3849_ sky130_fd_sc_hd__clkbuf_8
XFILLER_0_58_362 VGND VGND VPWR VPWR sky130_fd_sc_hd__fill_2
X_6723_ _3275_ VGND VGND VPWR VPWR _0963_ sky130_fd_sc_hd__clkbuf_1
XTAP_TAPCELL_ROW_34_655 VGND VPWR sky130_fd_sc_hd__tapvpwrvgnd_1
X_9511_ clknet_leaf_63_CLK _0744_ VGND VGND VPWR VPWR RF.reg_arr\[10\]\[9\] sky130_fd_sc_hd__dfxtp_1
XTAP_TAPCELL_ROW_102_1477 VGND VPWR sky130_fd_sc_hd__tapvpwrvgnd_1
XTAP_TAPCELL_ROW_62_997 VGND VPWR sky130_fd_sc_hd__tapvpwrvgnd_1
X_6654_ _3069_ net967 _3232_ VGND VGND VPWR VPWR _3238_ sky130_fd_sc_hd__mux2_1
XFILLER_0_18_248 VGND VGND VPWR VPWR sky130_fd_sc_hd__decap_4
X_9442_ clknet_leaf_71_CLK _0675_ VGND VGND VPWR VPWR RF.reg_arr\[12\]\[4\] sky130_fd_sc_hd__dfxtp_1
X_5605_ _2389_ _2392_ _1737_ VGND VGND VPWR VPWR _2393_ sky130_fd_sc_hd__mux2_1
XPHY_EDGE_ROW_12_Left_129 VGND VGND VPWR VPWR sky130_fd_sc_hd__decap_3
XFILLER_0_104_629 VGND VGND VPWR VPWR sky130_fd_sc_hd__fill_1
XFILLER_0_82_3 VGND VGND VPWR VPWR sky130_fd_sc_hd__fill_1
X_9373_ clknet_leaf_19_CLK _0606_ VGND VGND VPWR VPWR RF.reg_arr\[18\]\[31\] sky130_fd_sc_hd__dfxtp_1
X_6585_ _3201_ VGND VGND VPWR VPWR _0899_ sky130_fd_sc_hd__clkbuf_1
XFILLER_0_103_117 VGND VGND VPWR VPWR sky130_fd_sc_hd__fill_1
X_5536_ _1634_ _2324_ VGND VGND VPWR VPWR _2325_ sky130_fd_sc_hd__nand2_1
X_8324_ _3004_ net582 _4138_ VGND VGND VPWR VPWR _4142_ sky130_fd_sc_hd__mux2_1
X_8255_ _4105_ VGND VGND VPWR VPWR _0641_ sky130_fd_sc_hd__clkbuf_1
X_5467_ RF.reg_arr\[24\]\[6\] RF.reg_arr\[25\]\[6\] RF.reg_arr\[26\]\[6\] RF.reg_arr\[27\]\[6\]
+ _1675_ _1681_ VGND VGND VPWR VPWR _2256_ sky130_fd_sc_hd__mux4_1
X_7206_ _3547_ VGND VGND VPWR VPWR _0150_ sky130_fd_sc_hd__clkbuf_1
X_4418_ RF.reg_arr\[20\]\[8\] RF.reg_arr\[21\]\[8\] RF.reg_arr\[22\]\[8\] RF.reg_arr\[23\]\[8\]
+ _1050_ _1052_ VGND VGND VPWR VPWR _1207_ sky130_fd_sc_hd__mux4_1
XTAP_TAPCELL_ROW_6_325 VGND VPWR sky130_fd_sc_hd__tapvpwrvgnd_1
X_5398_ net3 _2186_ _1634_ VGND VGND VPWR VPWR _2187_ sky130_fd_sc_hd__o21a_1
X_8186_ _3002_ net375 _4066_ VGND VGND VPWR VPWR _4069_ sky130_fd_sc_hd__mux2_1
X_7137_ net238 _3437_ _3507_ VGND VGND VPWR VPWR _3511_ sky130_fd_sc_hd__mux2_1
X_4349_ RF.reg_arr\[8\]\[16\] RF.reg_arr\[9\]\[16\] RF.reg_arr\[10\]\[16\] RF.reg_arr\[11\]\[16\]
+ _1129_ _1130_ VGND VGND VPWR VPWR _1138_ sky130_fd_sc_hd__mux4_1
XFILLER_0_94_70 VGND VGND VPWR VPWR sky130_fd_sc_hd__decap_3
X_7068_ _3474_ VGND VGND VPWR VPWR _0085_ sky130_fd_sc_hd__clkbuf_1
XPHY_EDGE_ROW_21_Left_138 VGND VGND VPWR VPWR sky130_fd_sc_hd__decap_3
X_6019_ _1349_ _2770_ VGND VGND VPWR VPWR _2788_ sky130_fd_sc_hd__xnor2_1
XTAP_TAPCELL_ROW_68_1063 VGND VPWR sky130_fd_sc_hd__tapvpwrvgnd_1
XFILLER_0_107_412 VGND VGND VPWR VPWR sky130_fd_sc_hd__fill_2
XPHY_EDGE_ROW_30_Left_147 VGND VGND VPWR VPWR sky130_fd_sc_hd__decap_3
XFILLER_0_92_674 VGND VGND VPWR VPWR sky130_fd_sc_hd__fill_1
XFILLER_0_17_270 VGND VGND VPWR VPWR sky130_fd_sc_hd__decap_6
XFILLER_0_103_673 VGND VGND VPWR VPWR sky130_fd_sc_hd__decap_4
XFILLER_0_99_240 VGND VGND VPWR VPWR sky130_fd_sc_hd__decap_4
XFILLER_0_87_402 VGND VGND VPWR VPWR sky130_fd_sc_hd__fill_1
XFILLER_0_23_11 VGND VGND VPWR VPWR sky130_fd_sc_hd__fill_2
XFILLER_0_23_55 VGND VGND VPWR VPWR sky130_fd_sc_hd__fill_1
XFILLER_0_95_490 VGND VGND VPWR VPWR sky130_fd_sc_hd__fill_1
XTAP_TAPCELL_ROW_31_625 VGND VPWR sky130_fd_sc_hd__tapvpwrvgnd_1
XFILLER_0_55_321 VGND VGND VPWR VPWR sky130_fd_sc_hd__decap_6
XFILLER_0_99_15 VGND VGND VPWR VPWR sky130_fd_sc_hd__decap_3
XFILLER_0_43_505 VGND VGND VPWR VPWR sky130_fd_sc_hd__decap_3
XFILLER_0_55_387 VGND VGND VPWR VPWR sky130_fd_sc_hd__decap_4
XFILLER_0_82_195 VGND VGND VPWR VPWR sky130_fd_sc_hd__fill_1
X_6370_ _3077_ net766 _3059_ VGND VGND VPWR VPWR _3078_ sky130_fd_sc_hd__mux2_1
XTAP_TAPCELL_ROW_11_382 VGND VPWR sky130_fd_sc_hd__tapvpwrvgnd_1
XFILLER_0_3_613 VGND VGND VPWR VPWR sky130_fd_sc_hd__decap_3
X_5321_ _2108_ _2109_ _1864_ VGND VGND VPWR VPWR _2110_ sky130_fd_sc_hd__mux2_1
XFILLER_0_2_134 VGND VGND VPWR VPWR sky130_fd_sc_hd__fill_1
XFILLER_0_23_251 VGND VGND VPWR VPWR sky130_fd_sc_hd__decap_4
X_8040_ _2990_ net799 _3957_ VGND VGND VPWR VPWR _3991_ sky130_fd_sc_hd__mux2_1
X_5252_ RF.reg_arr\[8\]\[0\] RF.reg_arr\[9\]\[0\] RF.reg_arr\[10\]\[0\] RF.reg_arr\[11\]\[0\]
+ _1588_ _1679_ VGND VGND VPWR VPWR _2041_ sky130_fd_sc_hd__mux4_1
X_5183_ RF.reg_arr\[8\]\[16\] RF.reg_arr\[9\]\[16\] RF.reg_arr\[10\]\[16\] RF.reg_arr\[11\]\[16\]
+ _1848_ _1851_ VGND VGND VPWR VPWR _1972_ sky130_fd_sc_hd__mux4_1
XFILLER_0_48_85 VGND VGND VPWR VPWR sky130_fd_sc_hd__fill_1
XFILLER_0_3_54 VGND VGND VPWR VPWR sky130_fd_sc_hd__fill_2
XTAP_TAPCELL_ROW_39_714 VGND VPWR sky130_fd_sc_hd__tapvpwrvgnd_1
XTAP_TAPCELL_ROW_39_725 VGND VPWR sky130_fd_sc_hd__tapvpwrvgnd_1
X_8942_ clknet_leaf_6_CLK _0175_ VGND VGND VPWR VPWR RF.reg_arr\[29\]\[16\] sky130_fd_sc_hd__dfxtp_1
XFILLER_0_78_435 VGND VGND VPWR VPWR sky130_fd_sc_hd__fill_1
X_8873_ clknet_leaf_13_CLK _0106_ VGND VGND VPWR VPWR RF.reg_arr\[3\]\[11\] sky130_fd_sc_hd__dfxtp_1
X_7824_ _3876_ VGND VGND VPWR VPWR _0439_ sky130_fd_sc_hd__clkbuf_1
XTAP_TAPCELL_ROW_19_482 VGND VPWR sky130_fd_sc_hd__tapvpwrvgnd_1
X_4967_ _1700_ VGND VGND VPWR VPWR _1756_ sky130_fd_sc_hd__buf_2
X_7755_ net188 _3371_ _3835_ VGND VGND VPWR VPWR _3840_ sky130_fd_sc_hd__mux2_1
X_4898_ _1672_ _1686_ _1637_ VGND VGND VPWR VPWR _1687_ sky130_fd_sc_hd__mux2_1
X_6706_ _3121_ net715 _3231_ VGND VGND VPWR VPWR _3265_ sky130_fd_sc_hd__mux2_1
XFILLER_0_80_94 VGND VGND VPWR VPWR sky130_fd_sc_hd__decap_6
X_7686_ _3803_ VGND VGND VPWR VPWR _0374_ sky130_fd_sc_hd__clkbuf_1
XFILLER_0_46_365 VGND VGND VPWR VPWR sky130_fd_sc_hd__decap_3
X_6637_ _3228_ VGND VGND VPWR VPWR _0924_ sky130_fd_sc_hd__clkbuf_1
X_9425_ clknet_leaf_4_CLK _0658_ VGND VGND VPWR VPWR RF.reg_arr\[17\]\[19\] sky130_fd_sc_hd__dfxtp_1
X_6568_ net626 _2988_ _3182_ VGND VGND VPWR VPWR _3192_ sky130_fd_sc_hd__mux2_1
X_9356_ clknet_leaf_101_CLK _0589_ VGND VGND VPWR VPWR RF.reg_arr\[18\]\[14\] sky130_fd_sc_hd__dfxtp_1
XTAP_TAPCELL_ROW_115_1635 VGND VPWR sky130_fd_sc_hd__tapvpwrvgnd_1
X_8307_ _4132_ VGND VGND VPWR VPWR _0666_ sky130_fd_sc_hd__clkbuf_1
X_5519_ _1844_ _2307_ _1641_ VGND VGND VPWR VPWR _2308_ sky130_fd_sc_hd__o21ai_1
X_6499_ _3154_ VGND VGND VPWR VPWR _0860_ sky130_fd_sc_hd__clkbuf_1
XFILLER_0_14_295 VGND VGND VPWR VPWR sky130_fd_sc_hd__fill_1
X_9287_ clknet_leaf_77_CLK _0520_ VGND VGND VPWR VPWR RF.reg_arr\[25\]\[9\] sky130_fd_sc_hd__dfxtp_1
X_8238_ _2984_ net488 _4088_ VGND VGND VPWR VPWR _4096_ sky130_fd_sc_hd__mux2_1
X_8169_ _4059_ VGND VGND VPWR VPWR _0601_ sky130_fd_sc_hd__clkbuf_1
XFILLER_0_100_687 VGND VGND VPWR VPWR sky130_fd_sc_hd__decap_4
XFILLER_0_49_181 VGND VGND VPWR VPWR sky130_fd_sc_hd__fill_1
XFILLER_0_92_471 VGND VGND VPWR VPWR sky130_fd_sc_hd__decap_4
XFILLER_0_25_505 VGND VGND VPWR VPWR sky130_fd_sc_hd__decap_3
XFILLER_0_80_633 VGND VGND VPWR VPWR sky130_fd_sc_hd__decap_6
XFILLER_0_100_15 VGND VGND VPWR VPWR sky130_fd_sc_hd__decap_8
XTAP_TAPCELL_ROW_90_1329 VGND VPWR sky130_fd_sc_hd__tapvpwrvgnd_1
X_5870_ _2175_ _2644_ _2645_ VGND VGND VPWR VPWR _2647_ sky130_fd_sc_hd__and3_1
XTAP_TAPCELL_ROW_16_441 VGND VPWR sky130_fd_sc_hd__tapvpwrvgnd_1
X_4821_ _1609_ VGND VGND VPWR VPWR _1610_ sky130_fd_sc_hd__buf_4
XTAP_TAPCELL_ROW_44_783 VGND VPWR sky130_fd_sc_hd__tapvpwrvgnd_1
XFILLER_0_90_419 VGND VGND VPWR VPWR sky130_fd_sc_hd__fill_1
XFILLER_0_7_237 VGND VGND VPWR VPWR sky130_fd_sc_hd__fill_1
X_4752_ RF.reg_arr\[12\]\[15\] RF.reg_arr\[13\]\[15\] RF.reg_arr\[14\]\[15\] RF.reg_arr\[15\]\[15\]
+ _1187_ _1189_ VGND VGND VPWR VPWR _1541_ sky130_fd_sc_hd__mux4_1
X_7540_ net434 _3428_ _3716_ VGND VGND VPWR VPWR _3726_ sky130_fd_sc_hd__mux2_1
X_4683_ RF.reg_arr\[16\]\[30\] RF.reg_arr\[17\]\[30\] RF.reg_arr\[18\]\[30\] RF.reg_arr\[19\]\[30\]
+ _1450_ _1451_ VGND VGND VPWR VPWR _1472_ sky130_fd_sc_hd__mux4_1
XFILLER_0_28_398 VGND VGND VPWR VPWR sky130_fd_sc_hd__fill_1
X_7471_ _3688_ VGND VGND VPWR VPWR _0274_ sky130_fd_sc_hd__clkbuf_1
X_6422_ net32 VGND VGND VPWR VPWR _3113_ sky130_fd_sc_hd__clkbuf_2
X_9210_ clknet_leaf_29_CLK _0443_ VGND VGND VPWR VPWR RF.reg_arr\[24\]\[28\] sky130_fd_sc_hd__dfxtp_1
XFILLER_0_31_508 VGND VGND VPWR VPWR sky130_fd_sc_hd__decap_3
XFILLER_0_113_223 VGND VGND VPWR VPWR sky130_fd_sc_hd__fill_1
X_9141_ clknet_leaf_17_CLK _0374_ VGND VGND VPWR VPWR RF.reg_arr\[30\]\[23\] sky130_fd_sc_hd__dfxtp_1
XFILLER_0_70_176 VGND VGND VPWR VPWR sky130_fd_sc_hd__fill_2
X_6353_ _3066_ VGND VGND VPWR VPWR _0802_ sky130_fd_sc_hd__clkbuf_1
X_5304_ _2091_ _2092_ _1864_ VGND VGND VPWR VPWR _2093_ sky130_fd_sc_hd__mux2_1
X_9072_ clknet_leaf_0_CLK _0305_ VGND VGND VPWR VPWR RF.reg_arr\[28\]\[18\] sky130_fd_sc_hd__dfxtp_1
X_6284_ net229 _3021_ _3019_ VGND VGND VPWR VPWR _3022_ sky130_fd_sc_hd__mux2_1
X_5235_ _1024_ _1065_ VGND VGND VPWR VPWR _2024_ sky130_fd_sc_hd__nand2_1
X_8023_ _3982_ VGND VGND VPWR VPWR _0532_ sky130_fd_sc_hd__clkbuf_1
XFILLER_0_11_287 VGND VGND VPWR VPWR sky130_fd_sc_hd__fill_1
XTAP_TAPCELL_ROW_110_1576 VGND VPWR sky130_fd_sc_hd__tapvpwrvgnd_1
XFILLER_0_75_72 VGND VGND VPWR VPWR sky130_fd_sc_hd__fill_2
X_5166_ _1951_ _1954_ _1635_ VGND VGND VPWR VPWR _1955_ sky130_fd_sc_hd__mux2_1
X_5097_ _1885_ VGND VGND VPWR VPWR _1886_ sky130_fd_sc_hd__buf_4
X_8925_ clknet_leaf_23_CLK _0158_ VGND VGND VPWR VPWR RF.reg_arr\[7\]\[31\] sky130_fd_sc_hd__dfxtp_1
X_8856_ clknet_leaf_35_CLK _0089_ VGND VGND VPWR VPWR RF.reg_arr\[19\]\[26\] sky130_fd_sc_hd__dfxtp_1
XTAP_TAPCELL_ROW_65_1033 VGND VPWR sky130_fd_sc_hd__tapvpwrvgnd_1
X_5999_ _2752_ _2753_ _2758_ _2769_ _2568_ VGND VGND VPWR VPWR net58 sky130_fd_sc_hd__o32a_1
X_8787_ clknet_leaf_46_CLK _0020_ VGND VGND VPWR VPWR RF.reg_arr\[5\]\[21\] sky130_fd_sc_hd__dfxtp_1
XFILLER_0_19_332 VGND VGND VPWR VPWR sky130_fd_sc_hd__decap_4
X_7807_ _3867_ VGND VGND VPWR VPWR _0431_ sky130_fd_sc_hd__clkbuf_1
XFILLER_0_62_600 VGND VGND VPWR VPWR sky130_fd_sc_hd__fill_1
X_7738_ net378 _3422_ _3824_ VGND VGND VPWR VPWR _3831_ sky130_fd_sc_hd__mux2_1
XPHY_EDGE_ROW_104_Left_221 VGND VGND VPWR VPWR sky130_fd_sc_hd__decap_3
X_9408_ clknet_leaf_55_CLK _0641_ VGND VGND VPWR VPWR RF.reg_arr\[17\]\[2\] sky130_fd_sc_hd__dfxtp_1
XFILLER_0_6_270 VGND VGND VPWR VPWR sky130_fd_sc_hd__decap_4
X_7669_ _3794_ VGND VGND VPWR VPWR _0366_ sky130_fd_sc_hd__clkbuf_1
X_9339_ clknet_leaf_34_CLK _0572_ VGND VGND VPWR VPWR RF.reg_arr\[20\]\[29\] sky130_fd_sc_hd__dfxtp_1
XTAP_TAPCELL_ROW_76_1162 VGND VPWR sky130_fd_sc_hd__tapvpwrvgnd_1
XFILLER_0_30_585 VGND VGND VPWR VPWR sky130_fd_sc_hd__decap_3
XPHY_EDGE_ROW_113_Left_230 VGND VGND VPWR VPWR sky130_fd_sc_hd__decap_3
XFILLER_0_97_574 VGND VGND VPWR VPWR sky130_fd_sc_hd__decap_4
XTAP_TAPCELL_ROW_87_1291 VGND VPWR sky130_fd_sc_hd__tapvpwrvgnd_1
XFILLER_0_57_427 VGND VGND VPWR VPWR sky130_fd_sc_hd__fill_2
XTAP_TAPCELL_ROW_13_411 VGND VPWR sky130_fd_sc_hd__tapvpwrvgnd_1
XTAP_TAPCELL_ROW_41_742 VGND VPWR sky130_fd_sc_hd__tapvpwrvgnd_1
XFILLER_0_38_685 VGND VGND VPWR VPWR sky130_fd_sc_hd__fill_1
XFILLER_0_108_573 VPWR VGND VPWR VGND sky130_ef_sc_hd__decap_12
XFILLER_0_25_335 VGND VGND VPWR VPWR sky130_fd_sc_hd__fill_1
Xhold409 RF.reg_arr\[31\]\[11\] VGND VGND VPWR VPWR net491 sky130_fd_sc_hd__dlygate4sd3_1
XFILLER_0_33_390 VGND VGND VPWR VPWR sky130_fd_sc_hd__fill_2
XFILLER_0_96_38 VGND VGND VPWR VPWR sky130_fd_sc_hd__decap_6
XFILLER_0_21_552 VGND VGND VPWR VPWR sky130_fd_sc_hd__fill_2
X_5020_ _1584_ _1808_ VGND VGND VPWR VPWR _1809_ sky130_fd_sc_hd__or2_1
XTAP_TAPCELL_ROW_49_842 VGND VPWR sky130_fd_sc_hd__tapvpwrvgnd_1
X_8710_ clknet_leaf_81_CLK _0967_ VGND VGND VPWR VPWR RF.reg_arr\[14\]\[8\] sky130_fd_sc_hd__dfxtp_1
X_6971_ net19 VGND VGND VPWR VPWR _3418_ sky130_fd_sc_hd__buf_2
XFILLER_0_88_574 VGND VGND VPWR VPWR sky130_fd_sc_hd__decap_4
X_5922_ _2693_ _2696_ VGND VGND VPWR VPWR _2697_ sky130_fd_sc_hd__xnor2_1
X_5853_ _2387_ _2391_ VGND VGND VPWR VPWR _2631_ sky130_fd_sc_hd__nand2_1
XFILLER_0_61_52 VGND VGND VPWR VPWR sky130_fd_sc_hd__decap_4
X_8641_ clknet_leaf_65_CLK _0898_ VGND VGND VPWR VPWR RF.reg_arr\[8\]\[3\] sky130_fd_sc_hd__dfxtp_1
X_5784_ _2485_ _2564_ _2565_ _2418_ VGND VGND VPWR VPWR _2566_ sky130_fd_sc_hd__a211oi_1
X_4804_ _1592_ VGND VGND VPWR VPWR _1593_ sky130_fd_sc_hd__buf_4
XFILLER_0_75_279 VGND VGND VPWR VPWR sky130_fd_sc_hd__fill_1
X_8572_ clknet_leaf_22_CLK _0829_ VGND VGND VPWR VPWR RF.reg_arr\[23\]\[30\] sky130_fd_sc_hd__dfxtp_1
X_4735_ _1520_ _1523_ _1126_ VGND VGND VPWR VPWR _1524_ sky130_fd_sc_hd__mux2_1
XFILLER_0_8_579 VGND VGND VPWR VPWR sky130_fd_sc_hd__fill_1
XFILLER_0_29_685 VGND VGND VPWR VPWR sky130_fd_sc_hd__fill_1
XFILLER_0_43_110 VGND VGND VPWR VPWR sky130_fd_sc_hd__fill_2
X_7523_ _3717_ VGND VGND VPWR VPWR _0297_ sky130_fd_sc_hd__clkbuf_1
XFILLER_0_28_195 VGND VGND VPWR VPWR sky130_fd_sc_hd__fill_1
X_4666_ RF.reg_arr\[28\]\[31\] RF.reg_arr\[29\]\[31\] RF.reg_arr\[30\]\[31\] RF.reg_arr\[31\]\[31\]
+ _1450_ _1451_ VGND VGND VPWR VPWR _1455_ sky130_fd_sc_hd__mux4_1
X_7454_ _3082_ net979 _3678_ VGND VGND VPWR VPWR _3680_ sky130_fd_sc_hd__mux2_1
XFILLER_0_114_587 VGND VGND VPWR VPWR sky130_fd_sc_hd__fill_1
Xhold910 RF.reg_arr\[27\]\[29\] VGND VGND VPWR VPWR net992 sky130_fd_sc_hd__dlygate4sd3_1
X_6405_ _3100_ net871 _3101_ VGND VGND VPWR VPWR _3102_ sky130_fd_sc_hd__mux2_1
X_4597_ RF.reg_arr\[24\]\[6\] RF.reg_arr\[25\]\[6\] RF.reg_arr\[26\]\[6\] RF.reg_arr\[27\]\[6\]
+ net98 _1106_ VGND VGND VPWR VPWR _1386_ sky130_fd_sc_hd__mux4_1
Xhold921 RF.reg_arr\[15\]\[14\] VGND VGND VPWR VPWR net1003 sky130_fd_sc_hd__dlygate4sd3_1
X_7385_ _3082_ net772 _3641_ VGND VGND VPWR VPWR _3643_ sky130_fd_sc_hd__mux2_1
Xhold954 RF.reg_arr\[23\]\[26\] VGND VGND VPWR VPWR net1036 sky130_fd_sc_hd__dlygate4sd3_1
X_6336_ _3054_ VGND VGND VPWR VPWR _0797_ sky130_fd_sc_hd__clkbuf_1
Xhold932 RF.reg_arr\[27\]\[1\] VGND VGND VPWR VPWR net1014 sky130_fd_sc_hd__dlygate4sd3_1
X_9124_ clknet_leaf_83_CLK _0357_ VGND VGND VPWR VPWR RF.reg_arr\[30\]\[6\] sky130_fd_sc_hd__dfxtp_1
Xhold943 RF.reg_arr\[31\]\[8\] VGND VGND VPWR VPWR net1025 sky130_fd_sc_hd__dlygate4sd3_1
Xhold998 RF.reg_arr\[25\]\[26\] VGND VGND VPWR VPWR net1080 sky130_fd_sc_hd__dlygate4sd3_1
Xhold987 RF.reg_arr\[21\]\[20\] VGND VGND VPWR VPWR net1069 sky130_fd_sc_hd__dlygate4sd3_1
X_9055_ clknet_leaf_56_CLK _0288_ VGND VGND VPWR VPWR RF.reg_arr\[28\]\[1\] sky130_fd_sc_hd__dfxtp_1
XFILLER_0_12_596 VPWR VGND VPWR VGND sky130_ef_sc_hd__decap_12
Xhold965 RF.reg_arr\[30\]\[17\] VGND VGND VPWR VPWR net1047 sky130_fd_sc_hd__dlygate4sd3_1
Xhold976 RF.reg_arr\[21\]\[19\] VGND VGND VPWR VPWR net1058 sky130_fd_sc_hd__dlygate4sd3_1
X_6267_ net42 VGND VGND VPWR VPWR _3010_ sky130_fd_sc_hd__buf_2
X_6198_ _2916_ _2926_ _2937_ _2956_ VGND VGND VPWR VPWR _2957_ sky130_fd_sc_hd__o31a_1
X_8006_ _3973_ VGND VGND VPWR VPWR _0524_ sky130_fd_sc_hd__clkbuf_1
X_5218_ _2005_ _2006_ net6 VGND VGND VPWR VPWR _2007_ sky130_fd_sc_hd__mux2_1
X_5149_ RF.reg_arr\[12\]\[18\] RF.reg_arr\[13\]\[18\] RF.reg_arr\[14\]\[18\] RF.reg_arr\[15\]\[18\]
+ _1857_ _1860_ VGND VGND VPWR VPWR _1938_ sky130_fd_sc_hd__mux4_1
X_8908_ clknet_leaf_95_CLK _0141_ VGND VGND VPWR VPWR RF.reg_arr\[7\]\[14\] sky130_fd_sc_hd__dfxtp_1
XFILLER_0_39_416 VGND VGND VPWR VPWR sky130_fd_sc_hd__decap_4
XFILLER_0_94_555 VGND VGND VPWR VPWR sky130_fd_sc_hd__decap_4
XFILLER_0_94_533 VGND VGND VPWR VPWR sky130_fd_sc_hd__decap_8
X_8839_ clknet_leaf_78_CLK _0072_ VGND VGND VPWR VPWR RF.reg_arr\[19\]\[9\] sky130_fd_sc_hd__dfxtp_1
XFILLER_0_109_337 VGND VGND VPWR VPWR sky130_fd_sc_hd__decap_4
XFILLER_0_109_326 VGND VGND VPWR VPWR sky130_fd_sc_hd__fill_1
XFILLER_0_19_195 VGND VGND VPWR VPWR sky130_fd_sc_hd__fill_1
XFILLER_0_105_543 VGND VGND VPWR VPWR sky130_fd_sc_hd__fill_1
XFILLER_0_50_669 VGND VGND VPWR VPWR sky130_fd_sc_hd__decap_6
XFILLER_0_105_598 VGND VGND VPWR VPWR sky130_fd_sc_hd__fill_1
XFILLER_0_66_19 VGND VGND VPWR VPWR sky130_fd_sc_hd__fill_1
XTAP_TAPCELL_ROW_89_1320 VGND VPWR sky130_fd_sc_hd__tapvpwrvgnd_1
XFILLER_0_82_29 VGND VGND VPWR VPWR sky130_fd_sc_hd__fill_2
XTAP_TAPCELL_ROW_46_801 VGND VPWR sky130_fd_sc_hd__tapvpwrvgnd_1
XFILLER_0_57_279 VGND VGND VPWR VPWR sky130_fd_sc_hd__fill_1
XFILLER_0_38_471 VGND VGND VPWR VPWR sky130_fd_sc_hd__fill_2
XFILLER_0_65_290 VGND VGND VPWR VPWR sky130_fd_sc_hd__fill_1
XFILLER_0_31_55 VGND VGND VPWR VPWR sky130_fd_sc_hd__fill_1
X_4520_ _1306_ _1307_ _1308_ VGND VGND VPWR VPWR _1309_ sky130_fd_sc_hd__mux2_1
XFILLER_0_5_549 VGND VGND VPWR VPWR sky130_fd_sc_hd__fill_2
XFILLER_0_25_154 VGND VGND VPWR VPWR sky130_fd_sc_hd__decap_6
XFILLER_0_26_688 VGND VGND VPWR VPWR sky130_fd_sc_hd__decap_4
Xhold217 RF.reg_arr\[10\]\[26\] VGND VGND VPWR VPWR net299 sky130_fd_sc_hd__dlygate4sd3_1
XFILLER_0_103_3 VPWR VGND VPWR VGND sky130_ef_sc_hd__decap_12
Xhold206 RF.reg_arr\[11\]\[6\] VGND VGND VPWR VPWR net288 sky130_fd_sc_hd__dlygate4sd3_1
X_4451_ RF.reg_arr\[20\]\[10\] RF.reg_arr\[21\]\[10\] RF.reg_arr\[22\]\[10\] RF.reg_arr\[23\]\[10\]
+ net88 _1028_ VGND VGND VPWR VPWR _1240_ sky130_fd_sc_hd__mux4_1
XFILLER_0_111_524 VGND VGND VPWR VPWR sky130_fd_sc_hd__fill_1
Xhold239 RF.reg_arr\[31\]\[21\] VGND VGND VPWR VPWR net321 sky130_fd_sc_hd__dlygate4sd3_1
X_7170_ _3528_ VGND VGND VPWR VPWR _0133_ sky130_fd_sc_hd__clkbuf_1
Xhold228 RF.reg_arr\[6\]\[7\] VGND VGND VPWR VPWR net310 sky130_fd_sc_hd__dlygate4sd3_1
X_6121_ _2844_ _2883_ _2276_ VGND VGND VPWR VPWR _2884_ sky130_fd_sc_hd__mux2_1
XFILLER_0_21_371 VGND VGND VPWR VPWR sky130_fd_sc_hd__decap_6
X_4382_ RF.reg_arr\[24\]\[19\] RF.reg_arr\[25\]\[19\] RF.reg_arr\[26\]\[19\] RF.reg_arr\[27\]\[19\]
+ _1164_ _1165_ VGND VGND VPWR VPWR _1171_ sky130_fd_sc_hd__mux4_1
X_6052_ _2814_ _2818_ VGND VGND VPWR VPWR _2819_ sky130_fd_sc_hd__xor2_1
XPHY_EDGE_ROW_7_Right_7 VGND VGND VPWR VPWR sky130_fd_sc_hd__decap_3
X_5003_ _1700_ VGND VGND VPWR VPWR _1792_ sky130_fd_sc_hd__buf_2
XFILLER_0_88_360 VGND VGND VPWR VPWR sky130_fd_sc_hd__fill_1
X_6954_ _3406_ VGND VGND VPWR VPWR _0039_ sky130_fd_sc_hd__clkbuf_1
X_5905_ _2586_ _2506_ VGND VGND VPWR VPWR _2681_ sky130_fd_sc_hd__or2b_1
XFILLER_0_88_382 VGND VGND VPWR VPWR sky130_fd_sc_hd__decap_3
XFILLER_0_76_533 VGND VGND VPWR VPWR sky130_fd_sc_hd__decap_4
XFILLER_0_76_555 VPWR VGND VPWR VGND sky130_ef_sc_hd__decap_12
XTAP_TAPCELL_ROW_24_539 VGND VPWR sky130_fd_sc_hd__tapvpwrvgnd_1
X_8624_ clknet_leaf_3_CLK _0881_ VGND VGND VPWR VPWR RF.reg_arr\[16\]\[18\] sky130_fd_sc_hd__dfxtp_1
XFILLER_0_36_419 VGND VGND VPWR VPWR sky130_fd_sc_hd__fill_1
X_6885_ net480 _3031_ _3355_ VGND VGND VPWR VPWR _3362_ sky130_fd_sc_hd__mux2_1
X_5836_ _2418_ _2614_ VGND VGND VPWR VPWR _2615_ sky130_fd_sc_hd__or2_1
XFILLER_0_91_547 VPWR VGND VPWR VGND sky130_ef_sc_hd__decap_12
XFILLER_0_8_343 VGND VGND VPWR VPWR sky130_fd_sc_hd__fill_1
XFILLER_0_106_307 VGND VGND VPWR VPWR sky130_fd_sc_hd__fill_1
XFILLER_0_91_569 VGND VGND VPWR VPWR sky130_fd_sc_hd__decap_8
X_5767_ _1415_ _2548_ VGND VGND VPWR VPWR _2549_ sky130_fd_sc_hd__xnor2_1
XFILLER_0_29_493 VGND VGND VPWR VPWR sky130_fd_sc_hd__decap_8
X_8555_ clknet_leaf_94_CLK _0812_ VGND VGND VPWR VPWR RF.reg_arr\[23\]\[13\] sky130_fd_sc_hd__dfxtp_1
X_5698_ _1092_ _2471_ _2483_ VGND VGND VPWR VPWR _2484_ sky130_fd_sc_hd__o21a_1
X_7506_ _3708_ VGND VGND VPWR VPWR _0289_ sky130_fd_sc_hd__clkbuf_1
XFILLER_0_16_165 VGND VGND VPWR VPWR sky130_fd_sc_hd__fill_2
X_4718_ _1062_ _1502_ _1504_ _1506_ VGND VGND VPWR VPWR _1507_ sky130_fd_sc_hd__o2bb2a_1
X_8486_ net875 net21 _4222_ VGND VGND VPWR VPWR _4227_ sky130_fd_sc_hd__mux2_1
X_4649_ RF.reg_arr\[4\]\[26\] RF.reg_arr\[5\]\[26\] RF.reg_arr\[6\]\[26\] RF.reg_arr\[7\]\[26\]
+ _1327_ _1328_ VGND VGND VPWR VPWR _1438_ sky130_fd_sc_hd__mux4_1
X_7437_ _3065_ net504 _3667_ VGND VGND VPWR VPWR _3671_ sky130_fd_sc_hd__mux2_1
XFILLER_0_102_513 VGND VGND VPWR VPWR sky130_fd_sc_hd__fill_1
XFILLER_0_102_546 VGND VGND VPWR VPWR sky130_fd_sc_hd__decap_6
Xhold751 RF.reg_arr\[15\]\[29\] VGND VGND VPWR VPWR net833 sky130_fd_sc_hd__dlygate4sd3_1
XTAP_TAPCELL_ROW_73_1132 VGND VPWR sky130_fd_sc_hd__tapvpwrvgnd_1
Xhold773 RF.reg_arr\[18\]\[11\] VGND VGND VPWR VPWR net855 sky130_fd_sc_hd__dlygate4sd3_1
Xhold762 RF.reg_arr\[13\]\[6\] VGND VGND VPWR VPWR net844 sky130_fd_sc_hd__dlygate4sd3_1
X_7368_ _3065_ net673 _3630_ VGND VGND VPWR VPWR _3634_ sky130_fd_sc_hd__mux2_1
Xhold740 RF.reg_arr\[4\]\[3\] VGND VGND VPWR VPWR net822 sky130_fd_sc_hd__dlygate4sd3_1
X_9107_ clknet_leaf_47_CLK _0340_ VGND VGND VPWR VPWR RF.reg_arr\[2\]\[21\] sky130_fd_sc_hd__dfxtp_1
X_6319_ _3045_ VGND VGND VPWR VPWR _0789_ sky130_fd_sc_hd__clkbuf_1
Xhold784 RF.reg_arr\[12\]\[15\] VGND VGND VPWR VPWR net866 sky130_fd_sc_hd__dlygate4sd3_1
Xhold795 RF.reg_arr\[20\]\[18\] VGND VGND VPWR VPWR net877 sky130_fd_sc_hd__dlygate4sd3_1
X_7299_ _3597_ VGND VGND VPWR VPWR _0193_ sky130_fd_sc_hd__clkbuf_1
X_9038_ clknet_leaf_5_CLK _0271_ VGND VGND VPWR VPWR RF.reg_arr\[26\]\[16\] sky130_fd_sc_hd__dfxtp_1
XTAP_TAPCELL_ROW_4_297 VGND VPWR sky130_fd_sc_hd__tapvpwrvgnd_1
XTAP_TAPCELL_ROW_84_1261 VGND VPWR sky130_fd_sc_hd__tapvpwrvgnd_1
XFILLER_0_82_536 VPWR VGND VPWR VGND sky130_ef_sc_hd__decap_12
XFILLER_0_39_279 VGND VGND VPWR VPWR sky130_fd_sc_hd__fill_1
XFILLER_0_109_167 VGND VGND VPWR VPWR sky130_fd_sc_hd__fill_1
XFILLER_0_105_340 VPWR VGND VPWR VGND sky130_ef_sc_hd__decap_12
XFILLER_0_77_18 VGND VGND VPWR VPWR sky130_fd_sc_hd__decap_3
XTAP_TAPCELL_ROW_95_1390 VGND VPWR sky130_fd_sc_hd__tapvpwrvgnd_1
XFILLER_0_77_29 VGND VGND VPWR VPWR sky130_fd_sc_hd__decap_4
XFILLER_0_89_113 VGND VGND VPWR VPWR sky130_fd_sc_hd__decap_3
XFILLER_0_98_691 VGND VGND VPWR VPWR sky130_fd_sc_hd__fill_1
XFILLER_0_58_533 VGND VGND VPWR VPWR sky130_fd_sc_hd__decap_3
XFILLER_0_73_503 VGND VGND VPWR VPWR sky130_fd_sc_hd__fill_1
XFILLER_0_73_525 VPWR VGND VPWR VGND sky130_ef_sc_hd__decap_12
X_6670_ _3246_ VGND VGND VPWR VPWR _0939_ sky130_fd_sc_hd__clkbuf_1
XTAP_TAPCELL_ROW_21_509 VGND VPWR sky130_fd_sc_hd__tapvpwrvgnd_1
X_5621_ _1114_ _2310_ VGND VGND VPWR VPWR _2409_ sky130_fd_sc_hd__or2_1
X_5552_ _2337_ _2338_ _2340_ VGND VGND VPWR VPWR _2341_ sky130_fd_sc_hd__o21ai_1
XFILLER_0_14_603 VGND VGND VPWR VPWR sky130_fd_sc_hd__decap_4
X_8340_ _4150_ VGND VGND VPWR VPWR _0681_ sky130_fd_sc_hd__clkbuf_1
X_4503_ _1282_ _1291_ _1163_ VGND VGND VPWR VPWR _1292_ sky130_fd_sc_hd__o21ai_1
X_8271_ net438 _3409_ _4113_ VGND VGND VPWR VPWR _4114_ sky130_fd_sc_hd__mux2_1
X_5483_ _1584_ _2271_ VGND VGND VPWR VPWR _2272_ sky130_fd_sc_hd__or2_1
XFILLER_0_77_6 VGND VGND VPWR VPWR sky130_fd_sc_hd__fill_1
X_7222_ _3555_ VGND VGND VPWR VPWR _0158_ sky130_fd_sc_hd__clkbuf_1
X_4434_ _1063_ _1210_ _1214_ _1218_ _1222_ VGND VGND VPWR VPWR _1223_ sky130_fd_sc_hd__a32oi_4
X_7153_ net252 _3385_ _3484_ VGND VGND VPWR VPWR _3519_ sky130_fd_sc_hd__mux2_1
X_4365_ _1133_ _1153_ _1062_ VGND VGND VPWR VPWR _1154_ sky130_fd_sc_hd__o21a_1
X_6104_ _1808_ VGND VGND VPWR VPWR _2868_ sky130_fd_sc_hd__inv_2
X_7084_ _3482_ VGND VGND VPWR VPWR _0093_ sky130_fd_sc_hd__clkbuf_1
X_6035_ _2797_ _2798_ _2802_ VGND VGND VPWR VPWR _2803_ sky130_fd_sc_hd__or3_1
X_4296_ RF.reg_arr\[4\]\[4\] RF.reg_arr\[5\]\[4\] RF.reg_arr\[6\]\[4\] RF.reg_arr\[7\]\[4\]
+ _1082_ _1084_ VGND VGND VPWR VPWR _1085_ sky130_fd_sc_hd__mux4_1
Xrebuffer10 _2533_ VGND VGND VPWR VPWR net92 sky130_fd_sc_hd__dlymetal6s2s_1
XTAP_TAPCELL_ROW_107_1537 VGND VPWR sky130_fd_sc_hd__tapvpwrvgnd_1
XFILLER_0_96_628 VGND VGND VPWR VPWR sky130_fd_sc_hd__decap_4
XTAP_TAPCELL_ROW_1_267 VGND VPWR sky130_fd_sc_hd__tapvpwrvgnd_1
X_7986_ _3006_ net634 _3958_ VGND VGND VPWR VPWR _3963_ sky130_fd_sc_hd__mux2_1
XTAP_TAPCELL_ROW_37_697 VGND VPWR sky130_fd_sc_hd__tapvpwrvgnd_1
X_6937_ net39 VGND VGND VPWR VPWR _3395_ sky130_fd_sc_hd__buf_2
XFILLER_0_76_363 VGND VGND VPWR VPWR sky130_fd_sc_hd__fill_1
X_6868_ net704 _3014_ _3344_ VGND VGND VPWR VPWR _3353_ sky130_fd_sc_hd__mux2_1
XFILLER_0_107_605 VGND VGND VPWR VPWR sky130_fd_sc_hd__decap_8
X_5819_ _2390_ _2402_ VGND VGND VPWR VPWR _2599_ sky130_fd_sc_hd__nand2_1
X_8607_ clknet_leaf_55_CLK _0864_ VGND VGND VPWR VPWR RF.reg_arr\[16\]\[1\] sky130_fd_sc_hd__dfxtp_1
XFILLER_0_64_558 VGND VGND VPWR VPWR sky130_fd_sc_hd__fill_1
XFILLER_0_17_441 VGND VGND VPWR VPWR sky130_fd_sc_hd__fill_1
XFILLER_0_36_249 VGND VGND VPWR VPWR sky130_fd_sc_hd__decap_3
X_8538_ clknet_leaf_28_CLK _0795_ VGND VGND VPWR VPWR RF.reg_arr\[1\]\[28\] sky130_fd_sc_hd__dfxtp_1
X_6799_ net250 _3014_ _3307_ VGND VGND VPWR VPWR _3316_ sky130_fd_sc_hd__mux2_1
XFILLER_0_115_671 VGND VGND VPWR VPWR sky130_fd_sc_hd__fill_1
X_8469_ net440 net44 _4211_ VGND VGND VPWR VPWR _4218_ sky130_fd_sc_hd__mux2_1
XFILLER_0_20_617 VGND VGND VPWR VPWR sky130_fd_sc_hd__fill_1
XFILLER_0_32_477 VGND VGND VPWR VPWR sky130_fd_sc_hd__fill_2
XFILLER_0_32_488 VGND VGND VPWR VPWR sky130_fd_sc_hd__fill_2
XFILLER_0_32_499 VGND VGND VPWR VPWR sky130_fd_sc_hd__decap_6
XFILLER_0_102_365 VGND VGND VPWR VPWR sky130_fd_sc_hd__decap_6
Xhold581 RF.reg_arr\[20\]\[23\] VGND VGND VPWR VPWR net663 sky130_fd_sc_hd__dlygate4sd3_1
XTAP_TAPCELL_ROW_9_356 VGND VPWR sky130_fd_sc_hd__tapvpwrvgnd_1
Xhold570 RF.reg_arr\[29\]\[18\] VGND VGND VPWR VPWR net652 sky130_fd_sc_hd__dlygate4sd3_1
Xhold592 RF.reg_arr\[13\]\[3\] VGND VGND VPWR VPWR net674 sky130_fd_sc_hd__dlygate4sd3_1
XFILLER_0_87_617 VGND VGND VPWR VPWR sky130_fd_sc_hd__decap_3
XFILLER_0_103_15 VPWR VGND VPWR VGND sky130_ef_sc_hd__decap_12
XFILLER_0_12_79 VGND VGND VPWR VPWR sky130_fd_sc_hd__decap_4
XFILLER_0_23_499 VGND VGND VPWR VPWR sky130_fd_sc_hd__fill_1
X_7840_ _3267_ _3884_ VGND VGND VPWR VPWR _3885_ sky130_fd_sc_hd__nand2_4
XFILLER_0_78_639 VGND VGND VPWR VPWR sky130_fd_sc_hd__decap_4
XFILLER_0_77_116 VGND VGND VPWR VPWR sky130_fd_sc_hd__decap_4
XFILLER_0_53_53 VGND VGND VPWR VPWR sky130_fd_sc_hd__decap_3
X_4983_ _1587_ _1763_ _1767_ _1771_ VGND VGND VPWR VPWR _1772_ sky130_fd_sc_hd__o2bb2a_2
XFILLER_0_93_609 VGND VGND VPWR VPWR sky130_fd_sc_hd__decap_6
X_7771_ _3702_ _3665_ VGND VGND VPWR VPWR _3848_ sky130_fd_sc_hd__nand2_4
X_9510_ clknet_leaf_86_CLK _0743_ VGND VGND VPWR VPWR RF.reg_arr\[10\]\[8\] sky130_fd_sc_hd__dfxtp_1
X_6722_ _3067_ net773 _3270_ VGND VGND VPWR VPWR _3275_ sky130_fd_sc_hd__mux2_1
XTAP_TAPCELL_ROW_34_656 VGND VPWR sky130_fd_sc_hd__tapvpwrvgnd_1
XFILLER_0_116_402 VGND VGND VPWR VPWR sky130_fd_sc_hd__fill_1
XTAP_TAPCELL_ROW_102_1478 VGND VPWR sky130_fd_sc_hd__tapvpwrvgnd_1
XTAP_TAPCELL_ROW_62_998 VGND VPWR sky130_fd_sc_hd__tapvpwrvgnd_1
X_6653_ _3237_ VGND VGND VPWR VPWR _0931_ sky130_fd_sc_hd__clkbuf_1
X_9441_ clknet_leaf_67_CLK _0674_ VGND VGND VPWR VPWR RF.reg_arr\[12\]\[3\] sky130_fd_sc_hd__dfxtp_1
X_5604_ _2390_ _2391_ VGND VGND VPWR VPWR _2392_ sky130_fd_sc_hd__nand2_1
X_9372_ clknet_leaf_20_CLK _0605_ VGND VGND VPWR VPWR RF.reg_arr\[18\]\[30\] sky130_fd_sc_hd__dfxtp_1
X_6584_ net484 _3006_ _3196_ VGND VGND VPWR VPWR _3201_ sky130_fd_sc_hd__mux2_1
X_5535_ _2322_ _2323_ net3 VGND VGND VPWR VPWR _2324_ sky130_fd_sc_hd__mux2_1
X_8323_ _4141_ VGND VGND VPWR VPWR _0673_ sky130_fd_sc_hd__clkbuf_1
X_5466_ _1792_ _2254_ VGND VGND VPWR VPWR _2255_ sky130_fd_sc_hd__nand2_1
X_8254_ net753 _3393_ _4102_ VGND VGND VPWR VPWR _4105_ sky130_fd_sc_hd__mux2_1
X_4417_ _1162_ _1185_ _1205_ VGND VGND VPWR VPWR _1206_ sky130_fd_sc_hd__nand3_1
X_7205_ net578 _3437_ _3543_ VGND VGND VPWR VPWR _3547_ sky130_fd_sc_hd__mux2_1
XFILLER_0_78_83 VGND VGND VPWR VPWR sky130_fd_sc_hd__fill_1
XTAP_TAPCELL_ROW_6_326 VGND VPWR sky130_fd_sc_hd__tapvpwrvgnd_1
X_5397_ RF.reg_arr\[8\]\[13\] RF.reg_arr\[9\]\[13\] RF.reg_arr\[10\]\[13\] RF.reg_arr\[11\]\[13\]
+ _1846_ _1849_ VGND VGND VPWR VPWR _2186_ sky130_fd_sc_hd__mux4_1
X_8185_ _4068_ VGND VGND VPWR VPWR _0608_ sky130_fd_sc_hd__clkbuf_1
X_7136_ _3510_ VGND VGND VPWR VPWR _0117_ sky130_fd_sc_hd__clkbuf_1
X_4348_ _1133_ _1136_ _1110_ VGND VGND VPWR VPWR _1137_ sky130_fd_sc_hd__o21a_1
X_7067_ net180 _3435_ _3471_ VGND VGND VPWR VPWR _3474_ sky130_fd_sc_hd__mux2_1
X_4279_ net88 VGND VGND VPWR VPWR _1068_ sky130_fd_sc_hd__buf_12
X_6018_ _2495_ _2715_ _2786_ _2443_ VGND VGND VPWR VPWR _2787_ sky130_fd_sc_hd__o211a_1
XTAP_TAPCELL_ROW_68_1064 VGND VPWR sky130_fd_sc_hd__tapvpwrvgnd_1
X_7969_ _3953_ VGND VGND VPWR VPWR _0507_ sky130_fd_sc_hd__clkbuf_1
XFILLER_0_96_469 VGND VGND VPWR VPWR sky130_fd_sc_hd__decap_6
XFILLER_0_83_108 VGND VGND VPWR VPWR sky130_fd_sc_hd__decap_4
XTAP_TAPCELL_ROW_81_1220 VGND VPWR sky130_fd_sc_hd__tapvpwrvgnd_1
XFILLER_0_91_130 VGND VGND VPWR VPWR sky130_fd_sc_hd__fill_2
XFILLER_0_76_193 VGND VGND VPWR VPWR sky130_fd_sc_hd__decap_3
XFILLER_0_91_141 VGND VGND VPWR VPWR sky130_fd_sc_hd__fill_1
XFILLER_0_24_219 VGND VGND VPWR VPWR sky130_fd_sc_hd__fill_1
XFILLER_0_103_641 VPWR VGND VPWR VGND sky130_ef_sc_hd__decap_12
XFILLER_0_60_572 VGND VGND VPWR VPWR sky130_fd_sc_hd__decap_8
XTAP_TAPCELL_ROW_92_1360 VGND VPWR sky130_fd_sc_hd__tapvpwrvgnd_1
XFILLER_0_99_252 VGND VGND VPWR VPWR sky130_fd_sc_hd__decap_6
XFILLER_0_90_29 VGND VGND VPWR VPWR sky130_fd_sc_hd__fill_2
XFILLER_0_87_447 VGND VGND VPWR VPWR sky130_fd_sc_hd__fill_1
XTAP_TAPCELL_ROW_31_626 VGND VPWR sky130_fd_sc_hd__tapvpwrvgnd_1
XFILLER_0_70_325 VGND VGND VPWR VPWR sky130_fd_sc_hd__fill_2
XFILLER_0_43_528 VGND VGND VPWR VPWR sky130_fd_sc_hd__decap_3
Xrebuffer1 _1549_ VGND VGND VPWR VPWR net83 sky130_fd_sc_hd__dlymetal6s2s_1
XTAP_TAPCELL_ROW_11_383 VGND VPWR sky130_fd_sc_hd__tapvpwrvgnd_1
XFILLER_0_11_403 VGND VGND VPWR VPWR sky130_fd_sc_hd__decap_3
X_5320_ RF.reg_arr\[24\]\[9\] RF.reg_arr\[25\]\[9\] RF.reg_arr\[26\]\[9\] RF.reg_arr\[27\]\[9\]
+ _1623_ _1596_ VGND VGND VPWR VPWR _2109_ sky130_fd_sc_hd__mux4_1
XFILLER_0_11_436 VGND VGND VPWR VPWR sky130_fd_sc_hd__decap_3
X_5251_ RF.reg_arr\[12\]\[0\] RF.reg_arr\[13\]\[0\] RF.reg_arr\[14\]\[0\] RF.reg_arr\[15\]\[0\]
+ _1588_ _1679_ VGND VGND VPWR VPWR _2040_ sky130_fd_sc_hd__mux4_1
XFILLER_0_11_469 VGND VGND VPWR VPWR sky130_fd_sc_hd__decap_3
X_5182_ _1967_ _1968_ _1969_ _1970_ _1865_ _1635_ VGND VGND VPWR VPWR _1971_ sky130_fd_sc_hd__mux4_1
X_8941_ clknet_leaf_105_CLK _0174_ VGND VGND VPWR VPWR RF.reg_arr\[29\]\[15\] sky130_fd_sc_hd__dfxtp_1
XTAP_TAPCELL_ROW_39_715 VGND VPWR sky130_fd_sc_hd__tapvpwrvgnd_1
XFILLER_0_64_96 VGND VGND VPWR VPWR sky130_fd_sc_hd__fill_2
XFILLER_0_64_85 VGND VGND VPWR VPWR sky130_fd_sc_hd__fill_2
X_8872_ clknet_leaf_90_CLK _0105_ VGND VGND VPWR VPWR RF.reg_arr\[3\]\[10\] sky130_fd_sc_hd__dfxtp_1
X_7823_ _3109_ net463 _3871_ VGND VGND VPWR VPWR _3876_ sky130_fd_sc_hd__mux2_1
XTAP_TAPCELL_ROW_19_483 VGND VPWR sky130_fd_sc_hd__tapvpwrvgnd_1
XFILLER_0_93_439 VGND VGND VPWR VPWR sky130_fd_sc_hd__decap_3
X_7754_ _3839_ VGND VGND VPWR VPWR _0406_ sky130_fd_sc_hd__clkbuf_1
XFILLER_0_19_503 VGND VGND VPWR VPWR sky130_fd_sc_hd__fill_1
Xclkbuf_leaf_96_CLK clknet_3_4__leaf_CLK VGND VGND VPWR VPWR clknet_leaf_96_CLK sky130_fd_sc_hd__clkbuf_8
X_4966_ _1648_ _1754_ VGND VGND VPWR VPWR _1755_ sky130_fd_sc_hd__nand2_1
X_6705_ _3264_ VGND VGND VPWR VPWR _0956_ sky130_fd_sc_hd__clkbuf_1
X_4897_ _1673_ _1685_ _1614_ VGND VGND VPWR VPWR _1686_ sky130_fd_sc_hd__mux2_1
X_7685_ _3107_ net514 _3799_ VGND VGND VPWR VPWR _3803_ sky130_fd_sc_hd__mux2_1
XFILLER_0_74_664 VGND VGND VPWR VPWR sky130_fd_sc_hd__decap_6
XFILLER_0_116_243 VGND VGND VPWR VPWR sky130_fd_sc_hd__fill_1
X_6636_ net166 _2988_ _3218_ VGND VGND VPWR VPWR _3228_ sky130_fd_sc_hd__mux2_1
XFILLER_0_73_163 VGND VGND VPWR VPWR sky130_fd_sc_hd__decap_4
X_9424_ clknet_leaf_4_CLK _0657_ VGND VGND VPWR VPWR RF.reg_arr\[17\]\[18\] sky130_fd_sc_hd__dfxtp_1
XFILLER_0_116_276 VGND VGND VPWR VPWR sky130_fd_sc_hd__decap_4
X_6567_ _3191_ VGND VGND VPWR VPWR _0891_ sky130_fd_sc_hd__clkbuf_1
XFILLER_0_14_241 VGND VGND VPWR VPWR sky130_fd_sc_hd__decap_8
X_9355_ clknet_leaf_93_CLK _0588_ VGND VGND VPWR VPWR RF.reg_arr\[18\]\[13\] sky130_fd_sc_hd__dfxtp_1
XTAP_TAPCELL_ROW_115_1636 VGND VPWR sky130_fd_sc_hd__tapvpwrvgnd_1
X_8306_ net316 _3377_ _4124_ VGND VGND VPWR VPWR _4132_ sky130_fd_sc_hd__mux2_1
X_5518_ _2305_ _2306_ _1863_ VGND VGND VPWR VPWR _2307_ sky130_fd_sc_hd__mux2_1
X_6498_ net111 VGND VGND VPWR VPWR _3154_ sky130_fd_sc_hd__clkbuf_1
X_9286_ clknet_leaf_82_CLK _0519_ VGND VGND VPWR VPWR RF.reg_arr\[25\]\[8\] sky130_fd_sc_hd__dfxtp_1
X_8237_ _4095_ VGND VGND VPWR VPWR _0633_ sky130_fd_sc_hd__clkbuf_1
X_5449_ RF.reg_arr\[20\]\[7\] RF.reg_arr\[21\]\[7\] RF.reg_arr\[22\]\[7\] RF.reg_arr\[23\]\[7\]
+ _1883_ _1885_ VGND VGND VPWR VPWR _2238_ sky130_fd_sc_hd__mux4_1
X_8168_ net355 _3375_ _4052_ VGND VGND VPWR VPWR _4059_ sky130_fd_sc_hd__mux2_1
Xclkbuf_leaf_20_CLK clknet_3_0__leaf_CLK VGND VGND VPWR VPWR clknet_leaf_20_CLK sky130_fd_sc_hd__clkbuf_8
X_7119_ _3501_ VGND VGND VPWR VPWR _0109_ sky130_fd_sc_hd__clkbuf_1
X_8099_ _4022_ VGND VGND VPWR VPWR _0568_ sky130_fd_sc_hd__clkbuf_1
Xclkbuf_leaf_87_CLK clknet_3_5__leaf_CLK VGND VGND VPWR VPWR clknet_leaf_87_CLK sky130_fd_sc_hd__clkbuf_8
XFILLER_0_80_601 VGND VGND VPWR VPWR sky130_fd_sc_hd__fill_2
XFILLER_0_64_141 VGND VGND VPWR VPWR sky130_fd_sc_hd__fill_1
XFILLER_0_37_366 VGND VGND VPWR VPWR sky130_fd_sc_hd__decap_4
XFILLER_0_80_645 VPWR VGND VPWR VGND sky130_ef_sc_hd__decap_12
XFILLER_0_100_38 VGND VGND VPWR VPWR sky130_fd_sc_hd__fill_1
XFILLER_0_100_27 VGND VGND VPWR VPWR sky130_fd_sc_hd__fill_1
XFILLER_0_0_617 VPWR VGND VPWR VGND sky130_ef_sc_hd__decap_12
Xclkbuf_leaf_11_CLK clknet_3_1__leaf_CLK VGND VGND VPWR VPWR clknet_leaf_11_CLK sky130_fd_sc_hd__clkbuf_8
XFILLER_0_18_89 VGND VGND VPWR VPWR sky130_fd_sc_hd__fill_2
XFILLER_0_87_222 VGND VGND VPWR VPWR sky130_fd_sc_hd__fill_2
XTAP_TAPCELL_ROW_16_442 VGND VPWR sky130_fd_sc_hd__tapvpwrvgnd_1
X_4820_ net3 VGND VGND VPWR VPWR _1609_ sky130_fd_sc_hd__inv_2
Xclkbuf_leaf_78_CLK clknet_3_5__leaf_CLK VGND VGND VPWR VPWR clknet_leaf_78_CLK sky130_fd_sc_hd__clkbuf_8
XTAP_TAPCELL_ROW_44_784 VGND VPWR sky130_fd_sc_hd__tapvpwrvgnd_1
X_4751_ _1536_ _1539_ _1126_ VGND VGND VPWR VPWR _1540_ sky130_fd_sc_hd__mux2_1
X_4682_ RF.reg_arr\[20\]\[30\] RF.reg_arr\[21\]\[30\] RF.reg_arr\[22\]\[30\] RF.reg_arr\[23\]\[30\]
+ _1450_ _1451_ VGND VGND VPWR VPWR _1471_ sky130_fd_sc_hd__mux4_1
XFILLER_0_71_623 VGND VGND VPWR VPWR sky130_fd_sc_hd__fill_1
X_7470_ _3098_ net1094 _3678_ VGND VGND VPWR VPWR _3688_ sky130_fd_sc_hd__mux2_1
XFILLER_0_43_314 VGND VGND VPWR VPWR sky130_fd_sc_hd__fill_1
X_6421_ _3112_ VGND VGND VPWR VPWR _0824_ sky130_fd_sc_hd__clkbuf_1
XFILLER_0_70_133 VGND VGND VPWR VPWR sky130_fd_sc_hd__fill_1
X_9140_ clknet_leaf_63_CLK _0373_ VGND VGND VPWR VPWR RF.reg_arr\[30\]\[22\] sky130_fd_sc_hd__dfxtp_1
XFILLER_0_11_211 VGND VGND VPWR VPWR sky130_fd_sc_hd__decap_4
X_6352_ _3065_ net407 _3059_ VGND VGND VPWR VPWR _3066_ sky130_fd_sc_hd__mux2_1
X_5303_ RF.reg_arr\[16\]\[8\] RF.reg_arr\[17\]\[8\] RF.reg_arr\[18\]\[8\] RF.reg_arr\[19\]\[8\]
+ _1623_ _1596_ VGND VGND VPWR VPWR _2092_ sky130_fd_sc_hd__mux4_1
X_9071_ clknet_leaf_106_CLK _0304_ VGND VGND VPWR VPWR RF.reg_arr\[28\]\[17\] sky130_fd_sc_hd__dfxtp_1
X_6283_ net16 VGND VGND VPWR VPWR _3021_ sky130_fd_sc_hd__buf_2
X_5234_ _1832_ _2004_ _2022_ VGND VGND VPWR VPWR _2023_ sky130_fd_sc_hd__mux2_1
X_8022_ _3042_ net749 _3980_ VGND VGND VPWR VPWR _3982_ sky130_fd_sc_hd__mux2_1
XTAP_TAPCELL_ROW_110_1566 VGND VPWR sky130_fd_sc_hd__tapvpwrvgnd_1
X_5165_ _1952_ _1953_ _1942_ VGND VGND VPWR VPWR _1954_ sky130_fd_sc_hd__mux2_1
XTAP_TAPCELL_ROW_110_1577 VGND VPWR sky130_fd_sc_hd__tapvpwrvgnd_1
X_5096_ _1680_ VGND VGND VPWR VPWR _1885_ sky130_fd_sc_hd__buf_4
X_8924_ clknet_leaf_23_CLK _0157_ VGND VGND VPWR VPWR RF.reg_arr\[7\]\[30\] sky130_fd_sc_hd__dfxtp_1
Xclone6 A2[0] VGND VGND VPWR VPWR net88 sky130_fd_sc_hd__clkbuf_16
X_8855_ clknet_leaf_39_CLK _0088_ VGND VGND VPWR VPWR RF.reg_arr\[19\]\[25\] sky130_fd_sc_hd__dfxtp_1
XFILLER_0_78_277 VGND VGND VPWR VPWR sky130_fd_sc_hd__fill_1
XTAP_TAPCELL_ROW_65_1034 VGND VPWR sky130_fd_sc_hd__tapvpwrvgnd_1
X_7806_ _3092_ net646 _3860_ VGND VGND VPWR VPWR _3867_ sky130_fd_sc_hd__mux2_1
X_5998_ _2767_ _2768_ VGND VGND VPWR VPWR _2769_ sky130_fd_sc_hd__and2b_1
X_8786_ clknet_leaf_43_CLK _0019_ VGND VGND VPWR VPWR RF.reg_arr\[5\]\[20\] sky130_fd_sc_hd__dfxtp_1
XFILLER_0_47_620 VGND VGND VPWR VPWR sky130_fd_sc_hd__fill_2
Xclkbuf_leaf_69_CLK clknet_3_7__leaf_CLK VGND VGND VPWR VPWR clknet_leaf_69_CLK sky130_fd_sc_hd__clkbuf_8
X_4949_ _1737_ VGND VGND VPWR VPWR _1738_ sky130_fd_sc_hd__buf_4
XFILLER_0_93_258 VGND VGND VPWR VPWR sky130_fd_sc_hd__fill_1
XFILLER_0_74_461 VPWR VGND VPWR VGND sky130_ef_sc_hd__decap_12
X_7737_ _3830_ VGND VGND VPWR VPWR _0398_ sky130_fd_sc_hd__clkbuf_1
X_7668_ _3090_ net1057 _3788_ VGND VGND VPWR VPWR _3794_ sky130_fd_sc_hd__mux2_1
X_9407_ clknet_leaf_55_CLK _0640_ VGND VGND VPWR VPWR RF.reg_arr\[17\]\[1\] sky130_fd_sc_hd__dfxtp_1
XFILLER_0_62_645 VGND VGND VPWR VPWR sky130_fd_sc_hd__fill_1
X_6619_ _3219_ VGND VGND VPWR VPWR _0915_ sky130_fd_sc_hd__clkbuf_1
X_7599_ _3757_ VGND VGND VPWR VPWR _0333_ sky130_fd_sc_hd__clkbuf_1
X_9338_ clknet_leaf_33_CLK _0571_ VGND VGND VPWR VPWR RF.reg_arr\[20\]\[28\] sky130_fd_sc_hd__dfxtp_1
XFILLER_0_30_531 VGND VGND VPWR VPWR sky130_fd_sc_hd__fill_1
XFILLER_0_42_380 VGND VGND VPWR VPWR sky130_fd_sc_hd__fill_2
X_9269_ clknet_leaf_16_CLK _0502_ VGND VGND VPWR VPWR RF.reg_arr\[21\]\[23\] sky130_fd_sc_hd__dfxtp_1
XTAP_TAPCELL_ROW_76_1163 VGND VPWR sky130_fd_sc_hd__tapvpwrvgnd_1
XFILLER_0_30_564 VGND VGND VPWR VPWR sky130_fd_sc_hd__fill_2
XFILLER_0_97_542 VGND VGND VPWR VPWR sky130_fd_sc_hd__fill_2
XTAP_TAPCELL_ROW_87_1292 VGND VPWR sky130_fd_sc_hd__tapvpwrvgnd_1
XFILLER_0_84_203 VGND VGND VPWR VPWR sky130_fd_sc_hd__fill_1
XFILLER_0_69_266 VGND VGND VPWR VPWR sky130_fd_sc_hd__fill_1
XFILLER_0_69_288 VGND VGND VPWR VPWR sky130_fd_sc_hd__fill_1
XTAP_TAPCELL_ROW_13_412 VGND VPWR sky130_fd_sc_hd__tapvpwrvgnd_1
Xclkbuf_leaf_0_CLK clknet_3_0__leaf_CLK VGND VGND VPWR VPWR clknet_leaf_0_CLK sky130_fd_sc_hd__clkbuf_8
XTAP_TAPCELL_ROW_41_743 VGND VPWR sky130_fd_sc_hd__tapvpwrvgnd_1
XFILLER_0_111_15 VPWR VGND VPWR VGND sky130_ef_sc_hd__decap_12
XFILLER_0_108_585 VGND VGND VPWR VPWR sky130_fd_sc_hd__decap_3
XFILLER_0_80_475 VGND VGND VPWR VPWR sky130_fd_sc_hd__fill_1
XFILLER_0_110_249 VGND VGND VPWR VPWR sky130_fd_sc_hd__decap_3
XFILLER_0_0_458 VGND VGND VPWR VPWR sky130_fd_sc_hd__fill_1
XTAP_TAPCELL_ROW_49_843 VGND VPWR sky130_fd_sc_hd__tapvpwrvgnd_1
X_6970_ _3417_ VGND VGND VPWR VPWR _0044_ sky130_fd_sc_hd__clkbuf_1
XFILLER_0_45_54 VGND VGND VPWR VPWR sky130_fd_sc_hd__fill_2
XFILLER_0_88_531 VGND VGND VPWR VPWR sky130_fd_sc_hd__fill_1
X_5921_ _2694_ _2674_ _2695_ VGND VGND VPWR VPWR _2696_ sky130_fd_sc_hd__o21ai_1
X_5852_ _2628_ _2629_ VGND VGND VPWR VPWR _2630_ sky130_fd_sc_hd__nand2_1
XFILLER_0_75_225 VGND VGND VPWR VPWR sky130_fd_sc_hd__fill_1
X_8640_ clknet_leaf_65_CLK _0897_ VGND VGND VPWR VPWR RF.reg_arr\[8\]\[2\] sky130_fd_sc_hd__dfxtp_1
X_8571_ clknet_leaf_30_CLK _0828_ VGND VGND VPWR VPWR RF.reg_arr\[23\]\[29\] sky130_fd_sc_hd__dfxtp_1
X_5783_ _2430_ _2475_ _2480_ _2421_ VGND VGND VPWR VPWR _2565_ sky130_fd_sc_hd__a22o_1
X_4803_ _1591_ VGND VGND VPWR VPWR _1592_ sky130_fd_sc_hd__buf_4
XFILLER_0_28_141 VGND VGND VPWR VPWR sky130_fd_sc_hd__fill_2
XFILLER_0_8_569 VGND VGND VPWR VPWR sky130_fd_sc_hd__fill_1
X_4734_ _1521_ _1522_ _1121_ VGND VGND VPWR VPWR _1523_ sky130_fd_sc_hd__mux2_1
XFILLER_0_44_612 VGND VGND VPWR VPWR sky130_fd_sc_hd__fill_1
X_7522_ net222 _3409_ _3716_ VGND VGND VPWR VPWR _3717_ sky130_fd_sc_hd__mux2_1
XFILLER_0_44_645 VGND VGND VPWR VPWR sky130_fd_sc_hd__fill_1
XFILLER_0_114_533 VGND VGND VPWR VPWR sky130_fd_sc_hd__fill_1
X_4665_ _1452_ _1453_ _1281_ VGND VGND VPWR VPWR _1454_ sky130_fd_sc_hd__mux2_1
X_7453_ _3679_ VGND VGND VPWR VPWR _0265_ sky130_fd_sc_hd__clkbuf_1
XFILLER_0_43_155 VGND VGND VPWR VPWR sky130_fd_sc_hd__fill_2
XFILLER_0_43_166 VGND VGND VPWR VPWR sky130_fd_sc_hd__fill_2
XFILLER_0_43_177 VGND VGND VPWR VPWR sky130_fd_sc_hd__fill_1
X_4596_ _1333_ _1384_ VGND VGND VPWR VPWR _1385_ sky130_fd_sc_hd__and2_1
Xhold911 RF.reg_arr\[20\]\[25\] VGND VGND VPWR VPWR net993 sky130_fd_sc_hd__dlygate4sd3_1
X_6404_ _3058_ VGND VGND VPWR VPWR _3101_ sky130_fd_sc_hd__clkbuf_8
Xhold922 RF.reg_arr\[22\]\[13\] VGND VGND VPWR VPWR net1004 sky130_fd_sc_hd__dlygate4sd3_1
X_7384_ _3642_ VGND VGND VPWR VPWR _0233_ sky130_fd_sc_hd__clkbuf_1
Xhold900 RF.reg_arr\[23\]\[11\] VGND VGND VPWR VPWR net982 sky130_fd_sc_hd__dlygate4sd3_1
X_6335_ net740 _2990_ _2997_ VGND VGND VPWR VPWR _3054_ sky130_fd_sc_hd__mux2_1
Xhold944 RF.reg_arr\[30\]\[12\] VGND VGND VPWR VPWR net1026 sky130_fd_sc_hd__dlygate4sd3_1
X_9123_ clknet_leaf_76_CLK _0356_ VGND VGND VPWR VPWR RF.reg_arr\[30\]\[5\] sky130_fd_sc_hd__dfxtp_1
Xhold933 RF.reg_arr\[25\]\[18\] VGND VGND VPWR VPWR net1015 sky130_fd_sc_hd__dlygate4sd3_1
Xhold955 RF.reg_arr\[12\]\[9\] VGND VGND VPWR VPWR net1037 sky130_fd_sc_hd__dlygate4sd3_1
Xhold977 RF.reg_arr\[28\]\[30\] VGND VGND VPWR VPWR net1059 sky130_fd_sc_hd__dlygate4sd3_1
XFILLER_0_12_586 VGND VGND VPWR VPWR sky130_fd_sc_hd__fill_2
Xhold988 RF.reg_arr\[24\]\[0\] VGND VGND VPWR VPWR net1070 sky130_fd_sc_hd__dlygate4sd3_1
Xhold966 RF.reg_arr\[22\]\[0\] VGND VGND VPWR VPWR net1048 sky130_fd_sc_hd__dlygate4sd3_1
X_9054_ clknet_leaf_71_CLK _0287_ VGND VGND VPWR VPWR RF.reg_arr\[28\]\[0\] sky130_fd_sc_hd__dfxtp_1
XFILLER_0_86_83 VGND VGND VPWR VPWR sky130_fd_sc_hd__fill_1
X_6266_ _3009_ VGND VGND VPWR VPWR _0772_ sky130_fd_sc_hd__clkbuf_1
Xhold999 RF.reg_arr\[30\]\[13\] VGND VGND VPWR VPWR net1081 sky130_fd_sc_hd__dlygate4sd3_1
X_8005_ _3025_ net257 _3969_ VGND VGND VPWR VPWR _3973_ sky130_fd_sc_hd__mux2_1
X_6197_ _2938_ VGND VGND VPWR VPWR _2956_ sky130_fd_sc_hd__inv_2
X_5217_ RF.reg_arr\[28\]\[3\] RF.reg_arr\[29\]\[3\] RF.reg_arr\[30\]\[3\] RF.reg_arr\[31\]\[3\]
+ net88 _1028_ VGND VGND VPWR VPWR _2006_ sky130_fd_sc_hd__mux4_1
X_5148_ _1854_ _1936_ VGND VGND VPWR VPWR _1937_ sky130_fd_sc_hd__or2_1
X_5079_ _1643_ _1843_ _1856_ _1867_ VGND VGND VPWR VPWR _1868_ sky130_fd_sc_hd__a2bb2o_2
X_8907_ clknet_leaf_89_CLK _0140_ VGND VGND VPWR VPWR RF.reg_arr\[7\]\[13\] sky130_fd_sc_hd__dfxtp_1
XFILLER_0_94_512 VGND VGND VPWR VPWR sky130_fd_sc_hd__fill_2
X_8838_ clknet_leaf_81_CLK _0071_ VGND VGND VPWR VPWR RF.reg_arr\[19\]\[8\] sky130_fd_sc_hd__dfxtp_1
X_8769_ clknet_leaf_65_CLK _0002_ VGND VGND VPWR VPWR RF.reg_arr\[5\]\[3\] sky130_fd_sc_hd__dfxtp_1
XFILLER_0_94_589 VGND VGND VPWR VPWR sky130_fd_sc_hd__fill_1
XFILLER_0_62_442 VGND VGND VPWR VPWR sky130_fd_sc_hd__fill_1
XFILLER_0_62_475 VGND VGND VPWR VPWR sky130_fd_sc_hd__fill_1
XFILLER_0_62_497 VGND VGND VPWR VPWR sky130_fd_sc_hd__fill_2
XTAP_TAPCELL_ROW_89_1321 VGND VPWR sky130_fd_sc_hd__tapvpwrvgnd_1
XFILLER_0_106_15 VGND VGND VPWR VPWR sky130_fd_sc_hd__decap_4
XTAP_TAPCELL_ROW_46_802 VGND VPWR sky130_fd_sc_hd__tapvpwrvgnd_1
XFILLER_0_85_578 VGND VGND VPWR VPWR sky130_fd_sc_hd__decap_8
XFILLER_0_115_319 VGND VGND VPWR VPWR sky130_fd_sc_hd__fill_1
XFILLER_0_25_122 VGND VGND VPWR VPWR sky130_fd_sc_hd__decap_3
XFILLER_0_5_539 VGND VGND VPWR VPWR sky130_fd_sc_hd__fill_1
XFILLER_0_111_503 VGND VGND VPWR VPWR sky130_fd_sc_hd__fill_1
XFILLER_0_80_283 VGND VGND VPWR VPWR sky130_fd_sc_hd__fill_1
X_4450_ _1025_ _1228_ _1238_ VGND VGND VPWR VPWR _1239_ sky130_fd_sc_hd__o21a_1
XFILLER_0_13_328 VGND VGND VPWR VPWR sky130_fd_sc_hd__decap_8
Xhold207 RF.reg_arr\[2\]\[18\] VGND VGND VPWR VPWR net289 sky130_fd_sc_hd__dlygate4sd3_1
Xhold218 RF.reg_arr\[14\]\[26\] VGND VGND VPWR VPWR net300 sky130_fd_sc_hd__dlygate4sd3_1
Xhold229 RF.reg_arr\[6\]\[20\] VGND VGND VPWR VPWR net311 sky130_fd_sc_hd__dlygate4sd3_1
X_4381_ RF.reg_arr\[28\]\[19\] RF.reg_arr\[29\]\[19\] RF.reg_arr\[30\]\[19\] RF.reg_arr\[31\]\[19\]
+ _1164_ _1165_ VGND VGND VPWR VPWR _1170_ sky130_fd_sc_hd__mux4_1
X_6120_ _1755_ _1810_ VGND VGND VPWR VPWR _2883_ sky130_fd_sc_hd__nand2_1
X_6051_ _2798_ _2802_ _2817_ VGND VGND VPWR VPWR _2818_ sky130_fd_sc_hd__a21o_1
X_5002_ _1648_ _1790_ VGND VGND VPWR VPWR _1791_ sky130_fd_sc_hd__nand2_1
X_6953_ net501 _3405_ _3389_ VGND VGND VPWR VPWR _3406_ sky130_fd_sc_hd__mux2_1
X_5904_ _2510_ _2679_ _2021_ VGND VGND VPWR VPWR _2680_ sky130_fd_sc_hd__mux2_1
X_6884_ _3361_ VGND VGND VPWR VPWR _0014_ sky130_fd_sc_hd__clkbuf_1
X_5835_ _2439_ _2425_ _2022_ VGND VGND VPWR VPWR _2614_ sky130_fd_sc_hd__mux2_1
XFILLER_0_76_567 VGND VGND VPWR VPWR sky130_fd_sc_hd__decap_4
X_8623_ clknet_leaf_106_CLK _0880_ VGND VGND VPWR VPWR RF.reg_arr\[16\]\[17\] sky130_fd_sc_hd__dfxtp_1
XFILLER_0_48_247 VGND VGND VPWR VPWR sky130_fd_sc_hd__fill_2
XFILLER_0_76_589 VPWR VGND VPWR VGND sky130_ef_sc_hd__decap_12
XFILLER_0_91_559 VGND VGND VPWR VPWR sky130_fd_sc_hd__fill_1
X_5766_ _2546_ net90 _2534_ _2547_ VGND VGND VPWR VPWR _2548_ sky130_fd_sc_hd__o31a_1
X_8554_ clknet_leaf_102_CLK _0811_ VGND VGND VPWR VPWR RF.reg_arr\[23\]\[12\] sky130_fd_sc_hd__dfxtp_1
X_5697_ _2382_ _2474_ _2482_ _1024_ VGND VGND VPWR VPWR _2483_ sky130_fd_sc_hd__o211a_1
X_7505_ net592 _3393_ _3705_ VGND VGND VPWR VPWR _3708_ sky130_fd_sc_hd__mux2_1
X_8485_ _4226_ VGND VGND VPWR VPWR _0750_ sky130_fd_sc_hd__clkbuf_1
X_4717_ _1049_ _1505_ VGND VGND VPWR VPWR _1506_ sky130_fd_sc_hd__nor2_1
X_4648_ _1433_ _1434_ _1435_ _1436_ _1296_ _1173_ VGND VGND VPWR VPWR _1437_ sky130_fd_sc_hd__mux4_1
XFILLER_0_44_497 VGND VGND VPWR VPWR sky130_fd_sc_hd__fill_1
X_7436_ _3670_ VGND VGND VPWR VPWR _0257_ sky130_fd_sc_hd__clkbuf_1
Xhold730 RF.reg_arr\[15\]\[0\] VGND VGND VPWR VPWR net812 sky130_fd_sc_hd__dlygate4sd3_1
XTAP_TAPCELL_ROW_73_1122 VGND VPWR sky130_fd_sc_hd__tapvpwrvgnd_1
X_4579_ RF.reg_arr\[24\]\[22\] RF.reg_arr\[25\]\[22\] RF.reg_arr\[26\]\[22\] RF.reg_arr\[27\]\[22\]
+ _1082_ _1084_ VGND VGND VPWR VPWR _1368_ sky130_fd_sc_hd__mux4_1
X_9106_ clknet_leaf_13_CLK _0339_ VGND VGND VPWR VPWR RF.reg_arr\[2\]\[20\] sky130_fd_sc_hd__dfxtp_1
Xhold741 RF.reg_arr\[25\]\[8\] VGND VGND VPWR VPWR net823 sky130_fd_sc_hd__dlygate4sd3_1
Xhold752 RF.reg_arr\[29\]\[6\] VGND VGND VPWR VPWR net834 sky130_fd_sc_hd__dlygate4sd3_1
Xhold763 RF.reg_arr\[9\]\[0\] VGND VGND VPWR VPWR net845 sky130_fd_sc_hd__dlygate4sd3_1
X_7367_ _3633_ VGND VGND VPWR VPWR _0225_ sky130_fd_sc_hd__clkbuf_1
Xhold796 RF.reg_arr\[21\]\[23\] VGND VGND VPWR VPWR net878 sky130_fd_sc_hd__dlygate4sd3_1
XTAP_TAPCELL_ROW_73_1133 VGND VPWR sky130_fd_sc_hd__tapvpwrvgnd_1
X_6318_ net141 _3044_ _3040_ VGND VGND VPWR VPWR _3045_ sky130_fd_sc_hd__mux2_1
Xhold785 RF.reg_arr\[28\]\[12\] VGND VGND VPWR VPWR net867 sky130_fd_sc_hd__dlygate4sd3_1
X_7298_ _3063_ net1092 _3594_ VGND VGND VPWR VPWR _3597_ sky130_fd_sc_hd__mux2_1
Xhold774 RF.reg_arr\[21\]\[16\] VGND VGND VPWR VPWR net856 sky130_fd_sc_hd__dlygate4sd3_1
X_6249_ _2997_ VGND VGND VPWR VPWR _2998_ sky130_fd_sc_hd__clkbuf_8
X_9037_ clknet_leaf_105_CLK _0270_ VGND VGND VPWR VPWR RF.reg_arr\[26\]\[15\] sky130_fd_sc_hd__dfxtp_1
XFILLER_0_99_615 VGND VGND VPWR VPWR sky130_fd_sc_hd__fill_1
XTAP_TAPCELL_ROW_4_298 VGND VPWR sky130_fd_sc_hd__tapvpwrvgnd_1
XTAP_TAPCELL_ROW_84_1262 VGND VPWR sky130_fd_sc_hd__tapvpwrvgnd_1
XFILLER_0_39_269 VGND VGND VPWR VPWR sky130_fd_sc_hd__fill_1
XFILLER_0_82_504 VGND VGND VPWR VPWR sky130_fd_sc_hd__decap_3
XFILLER_0_82_548 VGND VGND VPWR VPWR sky130_fd_sc_hd__fill_1
XTAP_TAPCELL_ROW_51_860 VGND VPWR sky130_fd_sc_hd__tapvpwrvgnd_1
XFILLER_0_23_604 VGND VGND VPWR VPWR sky130_fd_sc_hd__decap_3
XFILLER_0_105_352 VGND VGND VPWR VPWR sky130_fd_sc_hd__decap_3
XFILLER_0_62_272 VGND VGND VPWR VPWR sky130_fd_sc_hd__decap_4
XFILLER_0_23_626 VGND VGND VPWR VPWR sky130_fd_sc_hd__decap_4
XFILLER_0_105_363 VGND VGND VPWR VPWR sky130_fd_sc_hd__fill_1
XFILLER_0_22_147 VGND VGND VPWR VPWR sky130_fd_sc_hd__fill_1
XTAP_TAPCELL_ROW_95_1391 VGND VPWR sky130_fd_sc_hd__tapvpwrvgnd_1
XTAP_TAPCELL_ROW_59_960 VGND VPWR sky130_fd_sc_hd__tapvpwrvgnd_1
XFILLER_0_26_45 VGND VGND VPWR VPWR sky130_fd_sc_hd__decap_3
Xhold90 RF.reg_arr\[18\]\[10\] VGND VGND VPWR VPWR net172 sky130_fd_sc_hd__dlygate4sd3_1
XFILLER_0_85_364 VGND VGND VPWR VPWR sky130_fd_sc_hd__decap_8
XFILLER_0_73_537 VGND VGND VPWR VPWR sky130_fd_sc_hd__decap_4
XFILLER_0_58_589 VPWR VGND VPWR VGND sky130_ef_sc_hd__decap_12
XFILLER_0_116_617 VPWR VGND VPWR VGND sky130_ef_sc_hd__decap_12
X_5620_ _2404_ _2407_ _2000_ VGND VGND VPWR VPWR _2408_ sky130_fd_sc_hd__mux2_1
XFILLER_0_109_691 VGND VGND VPWR VPWR sky130_fd_sc_hd__fill_1
X_5551_ _2339_ VGND VGND VPWR VPWR _2340_ sky130_fd_sc_hd__buf_2
XFILLER_0_26_475 VGND VGND VPWR VPWR sky130_fd_sc_hd__fill_1
X_4502_ _1289_ _1290_ _1281_ VGND VGND VPWR VPWR _1291_ sky130_fd_sc_hd__mux2_1
X_8270_ _4101_ VGND VGND VPWR VPWR _4113_ sky130_fd_sc_hd__buf_6
XFILLER_0_13_103 VGND VGND VPWR VPWR sky130_fd_sc_hd__decap_6
XFILLER_0_5_358 VGND VGND VPWR VPWR sky130_fd_sc_hd__decap_3
X_7221_ net620 _3385_ _3520_ VGND VGND VPWR VPWR _3555_ sky130_fd_sc_hd__mux2_1
X_5482_ _1643_ _2262_ _2266_ _2270_ VGND VGND VPWR VPWR _2271_ sky130_fd_sc_hd__a2bb2o_2
XFILLER_0_6_33 VGND VGND VPWR VPWR sky130_fd_sc_hd__fill_1
XFILLER_0_1_553 VGND VGND VPWR VPWR sky130_fd_sc_hd__fill_1
X_4433_ _1077_ _1221_ _1063_ VGND VGND VPWR VPWR _1222_ sky130_fd_sc_hd__a21oi_2
XFILLER_0_111_377 VGND VGND VPWR VPWR sky130_fd_sc_hd__fill_2
XFILLER_0_111_355 VGND VGND VPWR VPWR sky130_fd_sc_hd__fill_1
X_7152_ _3518_ VGND VGND VPWR VPWR _0125_ sky130_fd_sc_hd__clkbuf_1
X_4364_ RF.reg_arr\[8\]\[17\] RF.reg_arr\[9\]\[17\] RF.reg_arr\[10\]\[17\] RF.reg_arr\[11\]\[17\]
+ _1134_ _1135_ VGND VGND VPWR VPWR _1153_ sky130_fd_sc_hd__mux4_1
X_6103_ _2848_ _2849_ _2867_ _2446_ VGND VGND VPWR VPWR net65 sky130_fd_sc_hd__o2bb2a_1
X_7083_ net284 _3383_ _3448_ VGND VGND VPWR VPWR _3482_ sky130_fd_sc_hd__mux2_1
X_4295_ _1083_ VGND VGND VPWR VPWR _1084_ sky130_fd_sc_hd__buf_4
X_6034_ _1926_ _2801_ VGND VGND VPWR VPWR _2802_ sky130_fd_sc_hd__xnor2_1
Xrebuffer11 net1123 VGND VGND VPWR VPWR net1124 sky130_fd_sc_hd__dlygate4sd1_1
XFILLER_0_20_3 VGND VGND VPWR VPWR sky130_fd_sc_hd__decap_3
XTAP_TAPCELL_ROW_107_1538 VGND VPWR sky130_fd_sc_hd__tapvpwrvgnd_1
X_7985_ _3962_ VGND VGND VPWR VPWR _0514_ sky130_fd_sc_hd__clkbuf_1
X_6936_ _3394_ VGND VGND VPWR VPWR _0033_ sky130_fd_sc_hd__clkbuf_1
XTAP_TAPCELL_ROW_1_268 VGND VPWR sky130_fd_sc_hd__tapvpwrvgnd_1
XFILLER_0_49_534 VGND VGND VPWR VPWR sky130_fd_sc_hd__decap_3
XFILLER_0_9_620 VGND VGND VPWR VPWR sky130_fd_sc_hd__decap_4
XTAP_TAPCELL_ROW_37_698 VGND VPWR sky130_fd_sc_hd__tapvpwrvgnd_1
XFILLER_0_49_567 VGND VGND VPWR VPWR sky130_fd_sc_hd__fill_1
X_6867_ _3352_ VGND VGND VPWR VPWR _0006_ sky130_fd_sc_hd__clkbuf_1
XFILLER_0_36_206 VGND VGND VPWR VPWR sky130_fd_sc_hd__fill_2
X_5818_ _2568_ _2582_ _2590_ _2598_ VGND VGND VPWR VPWR net79 sky130_fd_sc_hd__o22a_1
XFILLER_0_91_345 VGND VGND VPWR VPWR sky130_fd_sc_hd__decap_3
XFILLER_0_9_686 VGND VGND VPWR VPWR sky130_fd_sc_hd__decap_6
XFILLER_0_8_152 VGND VGND VPWR VPWR sky130_fd_sc_hd__decap_4
XFILLER_0_8_141 VGND VGND VPWR VPWR sky130_fd_sc_hd__fill_2
XFILLER_0_29_291 VGND VGND VPWR VPWR sky130_fd_sc_hd__fill_1
X_8606_ clknet_leaf_71_CLK _0863_ VGND VGND VPWR VPWR RF.reg_arr\[16\]\[0\] sky130_fd_sc_hd__dfxtp_1
X_6798_ _3315_ VGND VGND VPWR VPWR _0998_ sky130_fd_sc_hd__clkbuf_1
X_5749_ _1092_ _2528_ _2531_ VGND VGND VPWR VPWR _2532_ sky130_fd_sc_hd__o21ai_1
X_8537_ clknet_leaf_48_CLK _0794_ VGND VGND VPWR VPWR RF.reg_arr\[1\]\[27\] sky130_fd_sc_hd__dfxtp_1
XFILLER_0_17_497 VGND VGND VPWR VPWR sky130_fd_sc_hd__decap_4
X_8468_ _4217_ VGND VGND VPWR VPWR _0742_ sky130_fd_sc_hd__clkbuf_1
X_7419_ _3660_ VGND VGND VPWR VPWR _0250_ sky130_fd_sc_hd__clkbuf_1
X_8399_ _4181_ VGND VGND VPWR VPWR _0709_ sky130_fd_sc_hd__clkbuf_1
Xhold560 RF.reg_arr\[12\]\[25\] VGND VGND VPWR VPWR net642 sky130_fd_sc_hd__dlygate4sd3_1
Xhold571 RF.reg_arr\[23\]\[8\] VGND VGND VPWR VPWR net653 sky130_fd_sc_hd__dlygate4sd3_1
XTAP_TAPCELL_ROW_9_357 VGND VPWR sky130_fd_sc_hd__tapvpwrvgnd_1
Xhold593 RF.reg_arr\[4\]\[29\] VGND VGND VPWR VPWR net675 sky130_fd_sc_hd__dlygate4sd3_1
Xhold582 RF.reg_arr\[31\]\[14\] VGND VGND VPWR VPWR net664 sky130_fd_sc_hd__dlygate4sd3_1
XFILLER_0_95_673 VGND VGND VPWR VPWR sky130_fd_sc_hd__decap_4
XFILLER_0_103_27 VGND VGND VPWR VPWR sky130_fd_sc_hd__decap_3
XFILLER_0_82_378 VGND VGND VPWR VPWR sky130_fd_sc_hd__decap_4
XFILLER_0_12_69 VGND VGND VPWR VPWR sky130_fd_sc_hd__fill_1
XFILLER_0_113_609 VGND VGND VPWR VPWR sky130_fd_sc_hd__decap_6
XTAP_TAPCELL_ROW_97_1420 VGND VPWR sky130_fd_sc_hd__tapvpwrvgnd_1
XFILLER_0_106_683 VGND VGND VPWR VPWR sky130_fd_sc_hd__decap_8
XFILLER_0_106_672 VGND VGND VPWR VPWR sky130_fd_sc_hd__fill_2
XFILLER_0_88_29 VGND VGND VPWR VPWR sky130_fd_sc_hd__fill_2
XFILLER_0_23_467 VGND VGND VPWR VPWR sky130_fd_sc_hd__fill_2
Xoutput80 net80 VGND VGND VPWR VPWR result[9] sky130_fd_sc_hd__clkbuf_4
XFILLER_0_37_55 VGND VGND VPWR VPWR sky130_fd_sc_hd__fill_1
XFILLER_0_78_618 VGND VGND VPWR VPWR sky130_fd_sc_hd__fill_2
X_4982_ _1619_ _1770_ _1644_ VGND VGND VPWR VPWR _1771_ sky130_fd_sc_hd__o21ai_1
X_7770_ _3847_ VGND VGND VPWR VPWR _0414_ sky130_fd_sc_hd__clkbuf_1
XTAP_TAPCELL_ROW_34_657 VGND VPWR sky130_fd_sc_hd__tapvpwrvgnd_1
X_6721_ _3274_ VGND VGND VPWR VPWR _0962_ sky130_fd_sc_hd__clkbuf_1
XTAP_TAPCELL_ROW_102_1479 VGND VPWR sky130_fd_sc_hd__tapvpwrvgnd_1
XFILLER_0_73_334 VGND VGND VPWR VPWR sky130_fd_sc_hd__fill_2
XTAP_TAPCELL_ROW_62_999 VGND VPWR sky130_fd_sc_hd__tapvpwrvgnd_1
X_6652_ _3067_ net739 _3232_ VGND VGND VPWR VPWR _3237_ sky130_fd_sc_hd__mux2_1
X_9440_ clknet_leaf_67_CLK _0673_ VGND VGND VPWR VPWR RF.reg_arr\[12\]\[2\] sky130_fd_sc_hd__dfxtp_1
X_9371_ clknet_leaf_34_CLK _0604_ VGND VGND VPWR VPWR RF.reg_arr\[18\]\[29\] sky130_fd_sc_hd__dfxtp_1
X_5603_ _1113_ _2068_ VGND VGND VPWR VPWR _2391_ sky130_fd_sc_hd__or2_1
XFILLER_0_6_623 VGND VGND VPWR VPWR sky130_fd_sc_hd__fill_1
XFILLER_0_116_469 VGND VGND VPWR VPWR sky130_fd_sc_hd__fill_1
XFILLER_0_116_447 VGND VGND VPWR VPWR sky130_fd_sc_hd__fill_1
XFILLER_0_6_678 VPWR VGND VPWR VGND sky130_ef_sc_hd__decap_12
XFILLER_0_26_272 VGND VGND VPWR VPWR sky130_fd_sc_hd__decap_3
X_6583_ _3200_ VGND VGND VPWR VPWR _0898_ sky130_fd_sc_hd__clkbuf_1
X_8322_ _3002_ net971 _4138_ VGND VGND VPWR VPWR _4141_ sky130_fd_sc_hd__mux2_1
XFILLER_0_14_445 VGND VGND VPWR VPWR sky130_fd_sc_hd__decap_4
XFILLER_0_41_231 VGND VGND VPWR VPWR sky130_fd_sc_hd__fill_1
X_5534_ RF.reg_arr\[12\]\[1\] RF.reg_arr\[13\]\[1\] RF.reg_arr\[14\]\[1\] RF.reg_arr\[15\]\[1\]
+ _1621_ _1594_ VGND VGND VPWR VPWR _2323_ sky130_fd_sc_hd__mux4_1
X_5465_ _1584_ _2253_ VGND VGND VPWR VPWR _2254_ sky130_fd_sc_hd__or2_1
X_8253_ _4104_ VGND VGND VPWR VPWR _0640_ sky130_fd_sc_hd__clkbuf_1
X_7204_ _3546_ VGND VGND VPWR VPWR _0149_ sky130_fd_sc_hd__clkbuf_1
X_4416_ _1116_ _1196_ _1204_ VGND VGND VPWR VPWR _1205_ sky130_fd_sc_hd__o21ai_4
X_8184_ _3000_ net697 _4066_ VGND VGND VPWR VPWR _4068_ sky130_fd_sc_hd__mux2_1
X_7135_ net436 _3435_ _3507_ VGND VGND VPWR VPWR _3510_ sky130_fd_sc_hd__mux2_1
X_5396_ _1610_ _2184_ VGND VGND VPWR VPWR _2185_ sky130_fd_sc_hd__or2_1
XTAP_TAPCELL_ROW_6_327 VGND VPWR sky130_fd_sc_hd__tapvpwrvgnd_1
X_4347_ RF.reg_arr\[0\]\[16\] RF.reg_arr\[1\]\[16\] RF.reg_arr\[2\]\[16\] RF.reg_arr\[3\]\[16\]
+ _1134_ _1135_ VGND VGND VPWR VPWR _1136_ sky130_fd_sc_hd__mux4_1
X_4278_ _1066_ VGND VGND VPWR VPWR _1067_ sky130_fd_sc_hd__inv_2
X_7066_ _3473_ VGND VGND VPWR VPWR _0084_ sky130_fd_sc_hd__clkbuf_1
X_6017_ _2660_ _2718_ _2785_ _2381_ VGND VGND VPWR VPWR _2786_ sky130_fd_sc_hd__o22a_1
XFILLER_0_96_437 VGND VGND VPWR VPWR sky130_fd_sc_hd__decap_4
XTAP_TAPCELL_ROW_68_1065 VGND VPWR sky130_fd_sc_hd__tapvpwrvgnd_1
X_7968_ _2986_ net526 _3944_ VGND VGND VPWR VPWR _3953_ sky130_fd_sc_hd__mux2_1
XFILLER_0_77_640 VGND VGND VPWR VPWR sky130_fd_sc_hd__decap_8
X_7899_ _3916_ VGND VGND VPWR VPWR _0474_ sky130_fd_sc_hd__clkbuf_1
X_6919_ _3382_ VGND VGND VPWR VPWR _0028_ sky130_fd_sc_hd__clkbuf_1
XTAP_TAPCELL_ROW_81_1221 VGND VPWR sky130_fd_sc_hd__tapvpwrvgnd_1
XFILLER_0_77_673 VGND VGND VPWR VPWR sky130_fd_sc_hd__decap_8
XFILLER_0_76_172 VGND VGND VPWR VPWR sky130_fd_sc_hd__fill_2
XFILLER_0_37_559 VGND VGND VPWR VPWR sky130_fd_sc_hd__fill_1
XFILLER_0_92_654 VPWR VGND VPWR VGND sky130_ef_sc_hd__decap_12
XFILLER_0_107_458 VGND VGND VPWR VPWR sky130_fd_sc_hd__decap_4
XFILLER_0_107_447 VGND VGND VPWR VPWR sky130_fd_sc_hd__fill_1
XFILLER_0_17_294 VGND VGND VPWR VPWR sky130_fd_sc_hd__decap_3
XTAP_TAPCELL_ROW_79_1194 VGND VPWR sky130_fd_sc_hd__tapvpwrvgnd_1
XFILLER_0_103_653 VGND VGND VPWR VPWR sky130_fd_sc_hd__decap_4
XFILLER_0_102_141 VPWR VGND VPWR VGND sky130_ef_sc_hd__decap_12
XTAP_TAPCELL_ROW_92_1361 VGND VPWR sky130_fd_sc_hd__tapvpwrvgnd_1
XTAP_TAPCELL_ROW_92_1350 VGND VPWR sky130_fd_sc_hd__tapvpwrvgnd_1
XFILLER_0_20_459 VGND VGND VPWR VPWR sky130_fd_sc_hd__decap_6
Xhold390 RF.reg_arr\[5\]\[13\] VGND VGND VPWR VPWR net472 sky130_fd_sc_hd__dlygate4sd3_1
XFILLER_0_114_15 VPWR VGND VPWR VGND sky130_ef_sc_hd__decap_12
XFILLER_0_23_57 VGND VGND VPWR VPWR sky130_fd_sc_hd__fill_1
XTAP_TAPCELL_ROW_31_627 VGND VPWR sky130_fd_sc_hd__tapvpwrvgnd_1
XFILLER_0_83_687 VGND VGND VPWR VPWR sky130_fd_sc_hd__fill_2
Xrebuffer2 net83 VGND VGND VPWR VPWR net84 sky130_fd_sc_hd__dlygate4sd1_1
XFILLER_0_82_197 VGND VGND VPWR VPWR sky130_fd_sc_hd__fill_1
XTAP_TAPCELL_ROW_11_384 VGND VPWR sky130_fd_sc_hd__tapvpwrvgnd_1
X_5250_ _1610_ _2036_ _2038_ _1616_ VGND VGND VPWR VPWR _2039_ sky130_fd_sc_hd__o211a_1
XFILLER_0_48_32 VGND VGND VPWR VPWR sky130_fd_sc_hd__fill_1
X_5181_ RF.reg_arr\[24\]\[16\] RF.reg_arr\[25\]\[16\] RF.reg_arr\[26\]\[16\] RF.reg_arr\[27\]\[16\]
+ _1884_ _1886_ VGND VGND VPWR VPWR _1970_ sky130_fd_sc_hd__mux4_1
X_8940_ clknet_leaf_101_CLK _0173_ VGND VGND VPWR VPWR RF.reg_arr\[29\]\[14\] sky130_fd_sc_hd__dfxtp_1
XTAP_TAPCELL_ROW_39_716 VGND VPWR sky130_fd_sc_hd__tapvpwrvgnd_1
X_8871_ clknet_leaf_64_CLK _0104_ VGND VGND VPWR VPWR RF.reg_arr\[3\]\[9\] sky130_fd_sc_hd__dfxtp_1
X_7822_ _3875_ VGND VGND VPWR VPWR _0438_ sky130_fd_sc_hd__clkbuf_1
X_4965_ _1583_ _1753_ VGND VGND VPWR VPWR _1754_ sky130_fd_sc_hd__or2_1
XFILLER_0_93_429 VGND VGND VPWR VPWR sky130_fd_sc_hd__fill_2
X_7753_ net255 _3437_ _3835_ VGND VGND VPWR VPWR _3839_ sky130_fd_sc_hd__mux2_1
XFILLER_0_59_673 VGND VGND VPWR VPWR sky130_fd_sc_hd__fill_1
XTAP_TAPCELL_ROW_19_484 VGND VPWR sky130_fd_sc_hd__tapvpwrvgnd_1
X_6704_ _3119_ net833 _3254_ VGND VGND VPWR VPWR _3264_ sky130_fd_sc_hd__mux2_1
XFILLER_0_80_52 VGND VGND VPWR VPWR sky130_fd_sc_hd__fill_1
XFILLER_0_74_643 VGND VGND VPWR VPWR sky130_fd_sc_hd__fill_1
X_4896_ RF.reg_arr\[24\]\[29\] RF.reg_arr\[25\]\[29\] RF.reg_arr\[26\]\[29\] RF.reg_arr\[27\]\[29\]
+ _1678_ _1684_ VGND VGND VPWR VPWR _1685_ sky130_fd_sc_hd__mux4_1
XFILLER_0_80_85 VGND VGND VPWR VPWR sky130_fd_sc_hd__decap_6
X_7684_ _3802_ VGND VGND VPWR VPWR _0373_ sky130_fd_sc_hd__clkbuf_1
X_9423_ clknet_leaf_105_CLK _0656_ VGND VGND VPWR VPWR RF.reg_arr\[17\]\[17\] sky130_fd_sc_hd__dfxtp_1
XFILLER_0_116_222 VGND VGND VPWR VPWR sky130_fd_sc_hd__fill_2
X_6635_ _3227_ VGND VGND VPWR VPWR _0923_ sky130_fd_sc_hd__clkbuf_1
X_6566_ net337 _2986_ _3182_ VGND VGND VPWR VPWR _3191_ sky130_fd_sc_hd__mux2_1
X_9354_ clknet_leaf_99_CLK _0587_ VGND VGND VPWR VPWR RF.reg_arr\[18\]\[12\] sky130_fd_sc_hd__dfxtp_1
XTAP_TAPCELL_ROW_115_1626 VGND VPWR sky130_fd_sc_hd__tapvpwrvgnd_1
X_8305_ _4131_ VGND VGND VPWR VPWR _0665_ sky130_fd_sc_hd__clkbuf_1
X_5517_ RF.reg_arr\[0\]\[2\] RF.reg_arr\[1\]\[2\] RF.reg_arr\[2\]\[2\] RF.reg_arr\[3\]\[2\]
+ _1846_ _1849_ VGND VGND VPWR VPWR _2306_ sky130_fd_sc_hd__mux4_1
XFILLER_0_14_253 VGND VGND VPWR VPWR sky130_fd_sc_hd__decap_4
X_9285_ clknet_leaf_83_CLK _0518_ VGND VGND VPWR VPWR RF.reg_arr\[25\]\[7\] sky130_fd_sc_hd__dfxtp_1
XTAP_TAPCELL_ROW_115_1637 VGND VPWR sky130_fd_sc_hd__tapvpwrvgnd_1
X_8236_ _2982_ net622 _4088_ VGND VGND VPWR VPWR _4095_ sky130_fd_sc_hd__mux2_1
X_6497_ _3153_ VGND VGND VPWR VPWR _0859_ sky130_fd_sc_hd__clkbuf_1
X_5448_ _2218_ _2236_ VGND VGND VPWR VPWR _2237_ sky130_fd_sc_hd__nor2_1
XFILLER_0_2_681 VGND VGND VPWR VPWR sky130_fd_sc_hd__decap_8
X_8167_ _4058_ VGND VGND VPWR VPWR _0600_ sky130_fd_sc_hd__clkbuf_1
X_5379_ RF.reg_arr\[12\]\[12\] RF.reg_arr\[13\]\[12\] RF.reg_arr\[14\]\[12\] RF.reg_arr\[15\]\[12\]
+ _1589_ _1834_ VGND VGND VPWR VPWR _2168_ sky130_fd_sc_hd__mux4_1
X_8098_ _2980_ net993 _4016_ VGND VGND VPWR VPWR _4022_ sky130_fd_sc_hd__mux2_1
X_7118_ net175 _3418_ _3496_ VGND VGND VPWR VPWR _3501_ sky130_fd_sc_hd__mux2_1
X_7049_ _3464_ VGND VGND VPWR VPWR _0076_ sky130_fd_sc_hd__clkbuf_1
XPHY_EDGE_ROW_29_Right_29 VGND VGND VPWR VPWR sky130_fd_sc_hd__decap_3
XFILLER_0_77_492 VPWR VGND VPWR VGND sky130_ef_sc_hd__decap_12
XFILLER_0_49_194 VGND VGND VPWR VPWR sky130_fd_sc_hd__fill_1
XFILLER_0_37_345 VGND VGND VPWR VPWR sky130_fd_sc_hd__fill_2
XPHY_EDGE_ROW_38_Right_38 VGND VGND VPWR VPWR sky130_fd_sc_hd__decap_3
XFILLER_0_80_657 VGND VGND VPWR VPWR sky130_fd_sc_hd__fill_1
XFILLER_0_64_197 VGND VGND VPWR VPWR sky130_fd_sc_hd__decap_6
XFILLER_0_60_392 VGND VGND VPWR VPWR sky130_fd_sc_hd__fill_1
XFILLER_0_0_629 VPWR VGND VPWR VGND sky130_ef_sc_hd__decap_12
XFILLER_0_109_15 VPWR VGND VPWR VGND sky130_ef_sc_hd__decap_12
XFILLER_0_18_68 VGND VGND VPWR VPWR sky130_fd_sc_hd__decap_3
XPHY_EDGE_ROW_47_Right_47 VGND VGND VPWR VPWR sky130_fd_sc_hd__decap_3
XFILLER_0_34_67 VGND VGND VPWR VPWR sky130_fd_sc_hd__fill_1
XTAP_TAPCELL_ROW_16_443 VGND VPWR sky130_fd_sc_hd__tapvpwrvgnd_1
XFILLER_0_28_312 VGND VGND VPWR VPWR sky130_fd_sc_hd__decap_4
XTAP_TAPCELL_ROW_44_774 VGND VPWR sky130_fd_sc_hd__tapvpwrvgnd_1
X_4750_ _1537_ _1538_ _1128_ VGND VGND VPWR VPWR _1539_ sky130_fd_sc_hd__mux2_1
XTAP_TAPCELL_ROW_44_785 VGND VPWR sky130_fd_sc_hd__tapvpwrvgnd_1
XFILLER_0_56_643 VGND VGND VPWR VPWR sky130_fd_sc_hd__fill_1
XPHY_EDGE_ROW_56_Right_56 VGND VGND VPWR VPWR sky130_fd_sc_hd__decap_3
XFILLER_0_83_473 VPWR VGND VPWR VGND sky130_ef_sc_hd__decap_12
X_4681_ _1468_ _1469_ _1308_ VGND VGND VPWR VPWR _1470_ sky130_fd_sc_hd__mux2_1
XFILLER_0_43_326 VGND VGND VPWR VPWR sky130_fd_sc_hd__fill_1
X_6420_ _3111_ net737 _3101_ VGND VGND VPWR VPWR _3112_ sky130_fd_sc_hd__mux2_1
XFILLER_0_3_401 VGND VGND VPWR VPWR sky130_fd_sc_hd__fill_1
XFILLER_0_43_337 VGND VGND VPWR VPWR sky130_fd_sc_hd__decap_3
XFILLER_0_71_679 VGND VGND VPWR VPWR sky130_fd_sc_hd__fill_2
X_6351_ net39 VGND VGND VPWR VPWR _3065_ sky130_fd_sc_hd__clkbuf_2
XFILLER_0_101_409 VGND VGND VPWR VPWR sky130_fd_sc_hd__fill_1
X_5302_ RF.reg_arr\[20\]\[8\] RF.reg_arr\[21\]\[8\] RF.reg_arr\[22\]\[8\] RF.reg_arr\[23\]\[8\]
+ _2087_ _1596_ VGND VGND VPWR VPWR _2091_ sky130_fd_sc_hd__mux4_1
XFILLER_0_11_201 VGND VGND VPWR VPWR sky130_fd_sc_hd__fill_1
X_9070_ clknet_leaf_6_CLK _0303_ VGND VGND VPWR VPWR RF.reg_arr\[28\]\[16\] sky130_fd_sc_hd__dfxtp_1
X_6282_ _3020_ VGND VGND VPWR VPWR _0777_ sky130_fd_sc_hd__clkbuf_1
X_5233_ _2021_ VGND VGND VPWR VPWR _2022_ sky130_fd_sc_hd__clkbuf_4
X_8021_ _3981_ VGND VGND VPWR VPWR _0531_ sky130_fd_sc_hd__clkbuf_1
XPHY_EDGE_ROW_65_Right_65 VGND VGND VPWR VPWR sky130_fd_sc_hd__decap_3
X_5164_ RF.reg_arr\[24\]\[19\] RF.reg_arr\[25\]\[19\] RF.reg_arr\[26\]\[19\] RF.reg_arr\[27\]\[19\]
+ _1947_ _1948_ VGND VGND VPWR VPWR _1953_ sky130_fd_sc_hd__mux4_1
XTAP_TAPCELL_ROW_110_1567 VGND VPWR sky130_fd_sc_hd__tapvpwrvgnd_1
X_5095_ _1883_ VGND VGND VPWR VPWR _1884_ sky130_fd_sc_hd__clkbuf_8
X_8923_ clknet_leaf_25_CLK _0156_ VGND VGND VPWR VPWR RF.reg_arr\[7\]\[29\] sky130_fd_sc_hd__dfxtp_1
X_8854_ clknet_leaf_52_CLK _0087_ VGND VGND VPWR VPWR RF.reg_arr\[19\]\[24\] sky130_fd_sc_hd__dfxtp_1
XFILLER_0_91_84 VGND VGND VPWR VPWR sky130_fd_sc_hd__fill_1
XTAP_TAPCELL_ROW_65_1035 VGND VPWR sky130_fd_sc_hd__tapvpwrvgnd_1
X_7805_ _3866_ VGND VGND VPWR VPWR _0430_ sky130_fd_sc_hd__clkbuf_1
X_5997_ _2765_ _2766_ _2762_ VGND VGND VPWR VPWR _2768_ sky130_fd_sc_hd__a21o_1
XFILLER_0_78_289 VGND VGND VPWR VPWR sky130_fd_sc_hd__fill_1
XPHY_EDGE_ROW_74_Right_74 VGND VGND VPWR VPWR sky130_fd_sc_hd__decap_3
X_8785_ clknet_leaf_15_CLK _0018_ VGND VGND VPWR VPWR RF.reg_arr\[5\]\[19\] sky130_fd_sc_hd__dfxtp_1
XFILLER_0_19_301 VGND VGND VPWR VPWR sky130_fd_sc_hd__fill_1
X_4948_ _1736_ VGND VGND VPWR VPWR _1737_ sky130_fd_sc_hd__clkbuf_4
X_7736_ net226 _3420_ _3824_ VGND VGND VPWR VPWR _3830_ sky130_fd_sc_hd__mux2_1
XFILLER_0_47_643 VGND VGND VPWR VPWR sky130_fd_sc_hd__fill_2
X_4879_ _1592_ VGND VGND VPWR VPWR _1668_ sky130_fd_sc_hd__buf_4
XFILLER_0_74_473 VGND VGND VPWR VPWR sky130_fd_sc_hd__decap_3
X_7667_ _3793_ VGND VGND VPWR VPWR _0365_ sky130_fd_sc_hd__clkbuf_1
XFILLER_0_19_367 VGND VGND VPWR VPWR sky130_fd_sc_hd__fill_1
X_6618_ net591 _3039_ _3218_ VGND VGND VPWR VPWR _3219_ sky130_fd_sc_hd__mux2_1
XFILLER_0_34_348 VGND VGND VPWR VPWR sky130_fd_sc_hd__fill_1
X_9406_ clknet_leaf_71_CLK _0639_ VGND VGND VPWR VPWR RF.reg_arr\[17\]\[0\] sky130_fd_sc_hd__dfxtp_1
XFILLER_0_46_197 VGND VGND VPWR VPWR sky130_fd_sc_hd__fill_2
X_7598_ net267 _3418_ _3752_ VGND VGND VPWR VPWR _3757_ sky130_fd_sc_hd__mux2_1
X_9337_ clknet_leaf_37_CLK _0570_ VGND VGND VPWR VPWR RF.reg_arr\[20\]\[27\] sky130_fd_sc_hd__dfxtp_1
X_6549_ _3159_ VGND VGND VPWR VPWR _3182_ sky130_fd_sc_hd__clkbuf_8
XPHY_EDGE_ROW_83_Right_83 VGND VGND VPWR VPWR sky130_fd_sc_hd__decap_3
XTAP_TAPCELL_ROW_76_1164 VGND VPWR sky130_fd_sc_hd__tapvpwrvgnd_1
X_9268_ clknet_leaf_60_CLK _0501_ VGND VGND VPWR VPWR RF.reg_arr\[21\]\[22\] sky130_fd_sc_hd__dfxtp_1
XPHY_EDGE_ROW_18_Left_135 VGND VGND VPWR VPWR sky130_fd_sc_hd__decap_3
X_9199_ clknet_leaf_106_CLK _0432_ VGND VGND VPWR VPWR RF.reg_arr\[24\]\[17\] sky130_fd_sc_hd__dfxtp_1
X_8219_ _3035_ net721 _4077_ VGND VGND VPWR VPWR _4086_ sky130_fd_sc_hd__mux2_1
XFILLER_0_100_475 VGND VGND VPWR VPWR sky130_fd_sc_hd__fill_1
XFILLER_0_69_223 VGND VGND VPWR VPWR sky130_fd_sc_hd__fill_1
XPHY_EDGE_ROW_27_Left_144 VGND VGND VPWR VPWR sky130_fd_sc_hd__decap_3
XPHY_EDGE_ROW_92_Right_92 VGND VGND VPWR VPWR sky130_fd_sc_hd__decap_3
XTAP_TAPCELL_ROW_87_1293 VGND VPWR sky130_fd_sc_hd__tapvpwrvgnd_1
XFILLER_0_57_407 VGND VGND VPWR VPWR sky130_fd_sc_hd__decap_3
XTAP_TAPCELL_ROW_13_402 VGND VPWR sky130_fd_sc_hd__tapvpwrvgnd_1
XTAP_TAPCELL_ROW_13_413 VGND VPWR sky130_fd_sc_hd__tapvpwrvgnd_1
XFILLER_0_38_643 VGND VGND VPWR VPWR sky130_fd_sc_hd__fill_1
XFILLER_0_108_553 VGND VGND VPWR VPWR sky130_fd_sc_hd__decap_3
XTAP_TAPCELL_ROW_41_744 VGND VPWR sky130_fd_sc_hd__tapvpwrvgnd_1
XFILLER_0_111_27 VPWR VGND VPWR VGND sky130_ef_sc_hd__decap_12
XFILLER_0_80_432 VGND VGND VPWR VPWR sky130_fd_sc_hd__decap_4
XFILLER_0_80_421 VGND VGND VPWR VPWR sky130_fd_sc_hd__fill_2
XFILLER_0_25_337 VGND VGND VPWR VPWR sky130_fd_sc_hd__decap_3
XPHY_EDGE_ROW_36_Left_153 VGND VGND VPWR VPWR sky130_fd_sc_hd__decap_3
XFILLER_0_52_145 VGND VGND VPWR VPWR sky130_fd_sc_hd__fill_2
XFILLER_0_29_23 VGND VGND VPWR VPWR sky130_fd_sc_hd__decap_3
XPHY_EDGE_ROW_45_Left_162 VGND VGND VPWR VPWR sky130_fd_sc_hd__decap_3
XTAP_TAPCELL_ROW_49_844 VGND VPWR sky130_fd_sc_hd__tapvpwrvgnd_1
X_5920_ _2646_ _2673_ _2672_ VGND VGND VPWR VPWR _2695_ sky130_fd_sc_hd__a21oi_1
X_5851_ _2470_ _2586_ _2588_ _2477_ VGND VGND VPWR VPWR _2629_ sky130_fd_sc_hd__o22a_1
XFILLER_0_61_32 VGND VGND VPWR VPWR sky130_fd_sc_hd__fill_1
XFILLER_0_0_57 VPWR VGND VPWR VGND sky130_ef_sc_hd__decap_12
X_8570_ clknet_leaf_30_CLK _0827_ VGND VGND VPWR VPWR RF.reg_arr\[23\]\[28\] sky130_fd_sc_hd__dfxtp_1
XPHY_EDGE_ROW_100_Right_100 VGND VGND VPWR VPWR sky130_fd_sc_hd__decap_3
X_5782_ _2476_ _2468_ _2197_ VGND VGND VPWR VPWR _2564_ sky130_fd_sc_hd__mux2_1
XFILLER_0_75_259 VGND VGND VPWR VPWR sky130_fd_sc_hd__fill_1
X_4802_ _1590_ VGND VGND VPWR VPWR _1591_ sky130_fd_sc_hd__buf_4
XFILLER_0_61_65 VGND VGND VPWR VPWR sky130_fd_sc_hd__fill_2
X_7521_ _3704_ VGND VGND VPWR VPWR _3716_ sky130_fd_sc_hd__clkbuf_8
X_4733_ RF.reg_arr\[24\]\[14\] RF.reg_arr\[25\]\[14\] RF.reg_arr\[26\]\[14\] RF.reg_arr\[27\]\[14\]
+ _1357_ _1358_ VGND VGND VPWR VPWR _1522_ sky130_fd_sc_hd__mux4_1
XFILLER_0_114_501 VPWR VGND VPWR VGND sky130_ef_sc_hd__decap_12
XFILLER_0_28_197 VGND VGND VPWR VPWR sky130_fd_sc_hd__decap_4
X_7452_ _3079_ net731 _3678_ VGND VGND VPWR VPWR _3679_ sky130_fd_sc_hd__mux2_1
XFILLER_0_43_134 VGND VGND VPWR VPWR sky130_fd_sc_hd__fill_2
XPHY_EDGE_ROW_54_Left_171 VGND VGND VPWR VPWR sky130_fd_sc_hd__decap_3
XFILLER_0_71_476 VGND VGND VPWR VPWR sky130_fd_sc_hd__fill_1
X_4664_ RF.reg_arr\[16\]\[31\] RF.reg_arr\[17\]\[31\] RF.reg_arr\[18\]\[31\] RF.reg_arr\[19\]\[31\]
+ _1450_ _1451_ VGND VGND VPWR VPWR _1453_ sky130_fd_sc_hd__mux4_1
X_6403_ net26 VGND VGND VPWR VPWR _3100_ sky130_fd_sc_hd__clkbuf_2
XFILLER_0_9_55 VGND VGND VPWR VPWR sky130_fd_sc_hd__fill_1
XFILLER_0_16_359 VGND VGND VPWR VPWR sky130_fd_sc_hd__fill_1
Xhold912 RF.reg_arr\[12\]\[27\] VGND VGND VPWR VPWR net994 sky130_fd_sc_hd__dlygate4sd3_1
X_4595_ _1349_ _1367_ _1383_ VGND VGND VPWR VPWR _1384_ sky130_fd_sc_hd__and3_1
X_7383_ _3079_ net782 _3641_ VGND VGND VPWR VPWR _3642_ sky130_fd_sc_hd__mux2_1
Xhold901 RF.reg_arr\[7\]\[4\] VGND VGND VPWR VPWR net983 sky130_fd_sc_hd__dlygate4sd3_1
XFILLER_0_114_589 VPWR VGND VPWR VGND sky130_ef_sc_hd__decap_12
X_6334_ _3053_ VGND VGND VPWR VPWR _0796_ sky130_fd_sc_hd__clkbuf_1
Xhold923 RF.reg_arr\[20\]\[2\] VGND VGND VPWR VPWR net1005 sky130_fd_sc_hd__dlygate4sd3_1
Xhold945 RF.reg_arr\[20\]\[17\] VGND VGND VPWR VPWR net1027 sky130_fd_sc_hd__dlygate4sd3_1
X_9122_ clknet_leaf_77_CLK _0355_ VGND VGND VPWR VPWR RF.reg_arr\[30\]\[4\] sky130_fd_sc_hd__dfxtp_1
Xhold934 RF.reg_arr\[26\]\[14\] VGND VGND VPWR VPWR net1016 sky130_fd_sc_hd__dlygate4sd3_1
Xhold967 RF.reg_arr\[15\]\[24\] VGND VGND VPWR VPWR net1049 sky130_fd_sc_hd__dlygate4sd3_1
X_9053_ clknet_leaf_21_CLK _0286_ VGND VGND VPWR VPWR RF.reg_arr\[26\]\[31\] sky130_fd_sc_hd__dfxtp_1
Xhold956 RF.reg_arr\[22\]\[14\] VGND VGND VPWR VPWR net1038 sky130_fd_sc_hd__dlygate4sd3_1
XFILLER_0_3_297 VGND VGND VPWR VPWR sky130_fd_sc_hd__fill_2
X_6265_ net137 _3008_ _2998_ VGND VGND VPWR VPWR _3009_ sky130_fd_sc_hd__mux2_1
Xhold978 RF.reg_arr\[20\]\[0\] VGND VGND VPWR VPWR net1060 sky130_fd_sc_hd__dlygate4sd3_1
Xhold989 RF.reg_arr\[20\]\[19\] VGND VGND VPWR VPWR net1071 sky130_fd_sc_hd__dlygate4sd3_1
X_8004_ _3972_ VGND VGND VPWR VPWR _0523_ sky130_fd_sc_hd__clkbuf_1
X_5216_ RF.reg_arr\[24\]\[3\] RF.reg_arr\[25\]\[3\] RF.reg_arr\[26\]\[3\] RF.reg_arr\[27\]\[3\]
+ _1229_ _1230_ VGND VGND VPWR VPWR _2005_ sky130_fd_sc_hd__mux4_1
X_6196_ _1663_ _2954_ VGND VGND VPWR VPWR _2955_ sky130_fd_sc_hd__xnor2_1
XPHY_EDGE_ROW_63_Left_180 VGND VGND VPWR VPWR sky130_fd_sc_hd__decap_3
X_5147_ RF.reg_arr\[8\]\[18\] RF.reg_arr\[9\]\[18\] RF.reg_arr\[10\]\[18\] RF.reg_arr\[11\]\[18\]
+ _1624_ _1597_ VGND VGND VPWR VPWR _1936_ sky130_fd_sc_hd__mux4_1
X_5078_ _1618_ _1866_ _1586_ VGND VGND VPWR VPWR _1867_ sky130_fd_sc_hd__a21oi_1
XFILLER_0_79_521 VGND VGND VPWR VPWR sky130_fd_sc_hd__fill_1
X_8906_ clknet_leaf_96_CLK _0139_ VGND VGND VPWR VPWR RF.reg_arr\[7\]\[12\] sky130_fd_sc_hd__dfxtp_1
X_8837_ clknet_leaf_98_CLK _0070_ VGND VGND VPWR VPWR RF.reg_arr\[19\]\[7\] sky130_fd_sc_hd__dfxtp_1
XFILLER_0_94_579 VGND VGND VPWR VPWR sky130_fd_sc_hd__decap_8
X_8768_ clknet_leaf_60_CLK _0001_ VGND VGND VPWR VPWR RF.reg_arr\[5\]\[2\] sky130_fd_sc_hd__dfxtp_1
X_7719_ net711 _3403_ _3813_ VGND VGND VPWR VPWR _3821_ sky130_fd_sc_hd__mux2_1
X_8699_ clknet_leaf_28_CLK _0956_ VGND VGND VPWR VPWR RF.reg_arr\[15\]\[29\] sky130_fd_sc_hd__dfxtp_1
XFILLER_0_105_512 VGND VGND VPWR VPWR sky130_fd_sc_hd__fill_2
XFILLER_0_22_307 VGND VGND VPWR VPWR sky130_fd_sc_hd__fill_1
XFILLER_0_35_668 VGND VGND VPWR VPWR sky130_fd_sc_hd__fill_1
XFILLER_0_22_318 VPWR VGND VPWR VGND sky130_ef_sc_hd__decap_12
XFILLER_0_50_649 VGND VGND VPWR VPWR sky130_fd_sc_hd__fill_2
XTAP_TAPCELL_ROW_89_1322 VGND VPWR sky130_fd_sc_hd__tapvpwrvgnd_1
XTAP_TAPCELL_ROW_46_803 VGND VPWR sky130_fd_sc_hd__tapvpwrvgnd_1
XFILLER_0_97_362 VGND VGND VPWR VPWR sky130_fd_sc_hd__decap_6
XFILLER_0_15_47 VGND VGND VPWR VPWR sky130_fd_sc_hd__fill_1
XFILLER_0_85_546 VGND VGND VPWR VPWR sky130_fd_sc_hd__fill_2
XTAP_TAPCELL_ROW_26_560 VGND VPWR sky130_fd_sc_hd__tapvpwrvgnd_1
XFILLER_0_38_462 VGND VGND VPWR VPWR sky130_fd_sc_hd__fill_1
XFILLER_0_108_361 VGND VGND VPWR VPWR sky130_fd_sc_hd__decap_3
XFILLER_0_31_57 VGND VGND VPWR VPWR sky130_fd_sc_hd__decap_8
XFILLER_0_25_167 VGND VGND VPWR VPWR sky130_fd_sc_hd__fill_1
XFILLER_0_53_465 VGND VGND VPWR VPWR sky130_fd_sc_hd__fill_2
Xhold208 RF.reg_arr\[17\]\[6\] VGND VGND VPWR VPWR net290 sky130_fd_sc_hd__dlygate4sd3_1
XFILLER_0_25_178 VGND VGND VPWR VPWR sky130_fd_sc_hd__fill_1
XFILLER_0_111_515 VGND VGND VPWR VPWR sky130_fd_sc_hd__fill_1
Xhold219 RF.reg_arr\[4\]\[24\] VGND VGND VPWR VPWR net301 sky130_fd_sc_hd__dlygate4sd3_1
X_4380_ _1166_ _1167_ _1168_ VGND VGND VPWR VPWR _1169_ sky130_fd_sc_hd__mux2_1
XFILLER_0_0_223 VGND VGND VPWR VPWR sky130_fd_sc_hd__fill_1
XFILLER_0_21_362 VGND VGND VPWR VPWR sky130_fd_sc_hd__fill_1
X_6050_ _2797_ _2815_ _2816_ VGND VGND VPWR VPWR _2817_ sky130_fd_sc_hd__a21o_1
X_5001_ _1649_ _1789_ VGND VGND VPWR VPWR _1790_ sky130_fd_sc_hd__or2_1
X_6952_ net44 VGND VGND VPWR VPWR _3405_ sky130_fd_sc_hd__buf_2
X_5903_ _2600_ _2678_ _2361_ VGND VGND VPWR VPWR _2679_ sky130_fd_sc_hd__mux2_1
X_6883_ net293 _3029_ _3355_ VGND VGND VPWR VPWR _3361_ sky130_fd_sc_hd__mux2_1
X_5834_ _2603_ _2605_ _2613_ _2446_ VGND VGND VPWR VPWR net80 sky130_fd_sc_hd__o2bb2a_1
XFILLER_0_76_546 VGND VGND VPWR VPWR sky130_fd_sc_hd__fill_2
X_8622_ clknet_leaf_20_CLK _0879_ VGND VGND VPWR VPWR RF.reg_arr\[16\]\[16\] sky130_fd_sc_hd__dfxtp_1
XFILLER_0_91_505 VGND VGND VPWR VPWR sky130_fd_sc_hd__fill_1
XFILLER_0_17_602 VGND VGND VPWR VPWR sky130_fd_sc_hd__decap_3
XFILLER_0_106_309 VGND VGND VPWR VPWR sky130_fd_sc_hd__decap_4
X_5765_ _2535_ VGND VGND VPWR VPWR _2547_ sky130_fd_sc_hd__buf_2
X_8553_ clknet_leaf_12_CLK _0810_ VGND VGND VPWR VPWR RF.reg_arr\[23\]\[11\] sky130_fd_sc_hd__dfxtp_1
XFILLER_0_98_3 VPWR VGND VPWR VGND sky130_ef_sc_hd__decap_12
X_5696_ _2050_ _2477_ _2481_ _2334_ VGND VGND VPWR VPWR _2482_ sky130_fd_sc_hd__a211o_1
X_7504_ _3707_ VGND VGND VPWR VPWR _0288_ sky130_fd_sc_hd__clkbuf_1
X_8484_ net996 net20 _4222_ VGND VGND VPWR VPWR _4226_ sky130_fd_sc_hd__mux2_1
X_4716_ RF.reg_arr\[16\]\[13\] RF.reg_arr\[17\]\[13\] RF.reg_arr\[18\]\[13\] RF.reg_arr\[19\]\[13\]
+ _1357_ _1358_ VGND VGND VPWR VPWR _1505_ sky130_fd_sc_hd__mux4_1
XFILLER_0_114_342 VGND VGND VPWR VPWR sky130_fd_sc_hd__fill_1
X_4647_ RF.reg_arr\[24\]\[26\] RF.reg_arr\[25\]\[26\] RF.reg_arr\[26\]\[26\] RF.reg_arr\[27\]\[26\]
+ _1273_ _1275_ VGND VGND VPWR VPWR _1436_ sky130_fd_sc_hd__mux4_1
X_7435_ _3063_ net763 _3667_ VGND VGND VPWR VPWR _3670_ sky130_fd_sc_hd__mux2_1
Xhold720 RF.reg_arr\[26\]\[28\] VGND VGND VPWR VPWR net802 sky130_fd_sc_hd__dlygate4sd3_1
XFILLER_0_4_562 VGND VGND VPWR VPWR sky130_fd_sc_hd__fill_2
X_7366_ _3063_ net499 _3630_ VGND VGND VPWR VPWR _3633_ sky130_fd_sc_hd__mux2_1
Xhold742 RF.reg_arr\[23\]\[28\] VGND VGND VPWR VPWR net824 sky130_fd_sc_hd__dlygate4sd3_1
XFILLER_0_102_559 VGND VGND VPWR VPWR sky130_fd_sc_hd__decap_4
X_4578_ _1025_ _1356_ _1362_ _1366_ VGND VGND VPWR VPWR _1367_ sky130_fd_sc_hd__a2bb2o_1
XTAP_TAPCELL_ROW_73_1123 VGND VPWR sky130_fd_sc_hd__tapvpwrvgnd_1
X_6317_ net28 VGND VGND VPWR VPWR _3044_ sky130_fd_sc_hd__buf_2
Xhold764 RF.reg_arr\[21\]\[9\] VGND VGND VPWR VPWR net846 sky130_fd_sc_hd__dlygate4sd3_1
Xhold753 RF.reg_arr\[14\]\[8\] VGND VGND VPWR VPWR net835 sky130_fd_sc_hd__dlygate4sd3_1
Xhold731 RF.reg_arr\[2\]\[0\] VGND VGND VPWR VPWR net813 sky130_fd_sc_hd__dlygate4sd3_1
X_9105_ clknet_leaf_7_CLK _0338_ VGND VGND VPWR VPWR RF.reg_arr\[2\]\[19\] sky130_fd_sc_hd__dfxtp_1
Xhold786 RF.reg_arr\[23\]\[21\] VGND VGND VPWR VPWR net868 sky130_fd_sc_hd__dlygate4sd3_1
X_7297_ _3596_ VGND VGND VPWR VPWR _0192_ sky130_fd_sc_hd__clkbuf_1
XFILLER_0_12_395 VGND VGND VPWR VPWR sky130_fd_sc_hd__fill_1
Xhold775 RF.reg_arr\[26\]\[5\] VGND VGND VPWR VPWR net857 sky130_fd_sc_hd__dlygate4sd3_1
Xhold797 RF.reg_arr\[4\]\[5\] VGND VGND VPWR VPWR net879 sky130_fd_sc_hd__dlygate4sd3_1
X_6248_ _2974_ _2995_ _2996_ VGND VGND VPWR VPWR _2997_ sky130_fd_sc_hd__and3_4
X_9036_ clknet_leaf_101_CLK _0269_ VGND VGND VPWR VPWR RF.reg_arr\[26\]\[14\] sky130_fd_sc_hd__dfxtp_1
X_6179_ _2937_ _2938_ VGND VGND VPWR VPWR _2939_ sky130_fd_sc_hd__nor2_1
XFILLER_0_98_104 VGND VGND VPWR VPWR sky130_fd_sc_hd__decap_4
XFILLER_0_99_649 VGND VGND VPWR VPWR sky130_fd_sc_hd__decap_6
XFILLER_0_98_148 VGND VGND VPWR VPWR sky130_fd_sc_hd__fill_1
XTAP_TAPCELL_ROW_4_299 VGND VPWR sky130_fd_sc_hd__tapvpwrvgnd_1
XFILLER_0_94_343 VGND VGND VPWR VPWR sky130_fd_sc_hd__fill_1
XTAP_TAPCELL_ROW_84_1263 VGND VPWR sky130_fd_sc_hd__tapvpwrvgnd_1
XFILLER_0_94_365 VGND VGND VPWR VPWR sky130_fd_sc_hd__decap_3
XFILLER_0_82_516 VGND VGND VPWR VPWR sky130_fd_sc_hd__fill_1
XTAP_TAPCELL_ROW_23_530 VGND VPWR sky130_fd_sc_hd__tapvpwrvgnd_1
XTAP_TAPCELL_ROW_51_861 VGND VPWR sky130_fd_sc_hd__tapvpwrvgnd_1
XFILLER_0_31_660 VPWR VGND VPWR VGND sky130_ef_sc_hd__decap_12
XTAP_TAPCELL_ROW_95_1392 VGND VPWR sky130_fd_sc_hd__tapvpwrvgnd_1
XFILLER_0_30_170 VGND VGND VPWR VPWR sky130_fd_sc_hd__decap_8
Xhold80 RF.reg_arr\[19\]\[29\] VGND VGND VPWR VPWR net162 sky130_fd_sc_hd__dlygate4sd3_1
Xhold91 RF.reg_arr\[9\]\[27\] VGND VGND VPWR VPWR net173 sky130_fd_sc_hd__dlygate4sd3_1
XTAP_TAPCELL_ROW_59_961 VGND VPWR sky130_fd_sc_hd__tapvpwrvgnd_1
XFILLER_0_73_505 VGND VGND VPWR VPWR sky130_fd_sc_hd__decap_4
XFILLER_0_116_629 VPWR VGND VPWR VGND sky130_ef_sc_hd__decap_12
XFILLER_0_116_607 VGND VGND VPWR VPWR sky130_fd_sc_hd__decap_8
XFILLER_0_42_89 VGND VGND VPWR VPWR sky130_fd_sc_hd__fill_2
X_5550_ net48 VGND VGND VPWR VPWR _2339_ sky130_fd_sc_hd__inv_2
XFILLER_0_5_315 VGND VGND VPWR VPWR sky130_fd_sc_hd__fill_1
XFILLER_0_26_465 VGND VGND VPWR VPWR sky130_fd_sc_hd__decap_4
XFILLER_0_53_251 VPWR VGND VPWR VGND sky130_ef_sc_hd__decap_12
X_4501_ RF.reg_arr\[0\]\[28\] RF.reg_arr\[1\]\[28\] RF.reg_arr\[2\]\[28\] RF.reg_arr\[3\]\[28\]
+ _1274_ _1276_ VGND VGND VPWR VPWR _1290_ sky130_fd_sc_hd__mux4_1
X_5481_ _1618_ _2269_ _1586_ VGND VGND VPWR VPWR _2270_ sky130_fd_sc_hd__a21oi_1
X_7220_ _3554_ VGND VGND VPWR VPWR _0157_ sky130_fd_sc_hd__clkbuf_1
X_4432_ _1219_ _1220_ _1075_ VGND VGND VPWR VPWR _1221_ sky130_fd_sc_hd__mux2_1
X_7151_ net687 _3383_ _3484_ VGND VGND VPWR VPWR _3518_ sky130_fd_sc_hd__mux2_1
XFILLER_0_6_56 VGND VGND VPWR VPWR sky130_fd_sc_hd__fill_1
X_4363_ _1128_ _1151_ VGND VGND VPWR VPWR _1152_ sky130_fd_sc_hd__or2_1
X_6102_ _2865_ _2866_ VGND VGND VPWR VPWR _2867_ sky130_fd_sc_hd__nor2_1
X_7082_ _3481_ VGND VGND VPWR VPWR _0092_ sky130_fd_sc_hd__clkbuf_1
XFILLER_0_6_78 VGND VGND VPWR VPWR sky130_fd_sc_hd__decap_6
X_4294_ A2[1] VGND VGND VPWR VPWR _1083_ sky130_fd_sc_hd__clkbuf_4
X_6033_ _1367_ _2800_ VGND VGND VPWR VPWR _2801_ sky130_fd_sc_hd__xnor2_1
Xrebuffer12 _2666_ VGND VGND VPWR VPWR net94 sky130_fd_sc_hd__clkbuf_2
XTAP_TAPCELL_ROW_107_1539 VGND VPWR sky130_fd_sc_hd__tapvpwrvgnd_1
XFILLER_0_89_660 VPWR VGND VPWR VGND sky130_ef_sc_hd__decap_12
XFILLER_0_13_3 VPWR VGND VPWR VGND sky130_ef_sc_hd__decap_12
XTAP_TAPCELL_ROW_1_258 VGND VPWR sky130_fd_sc_hd__tapvpwrvgnd_1
X_7984_ _3004_ net648 _3958_ VGND VGND VPWR VPWR _3962_ sky130_fd_sc_hd__mux2_1
X_6935_ net360 _3393_ _3389_ VGND VGND VPWR VPWR _3394_ sky130_fd_sc_hd__mux2_1
XTAP_TAPCELL_ROW_1_269 VGND VPWR sky130_fd_sc_hd__tapvpwrvgnd_1
XFILLER_0_88_192 VGND VGND VPWR VPWR sky130_fd_sc_hd__decap_4
XTAP_TAPCELL_ROW_37_699 VGND VPWR sky130_fd_sc_hd__tapvpwrvgnd_1
XFILLER_0_76_376 VGND VGND VPWR VPWR sky130_fd_sc_hd__fill_1
X_6866_ net147 _3012_ _3344_ VGND VGND VPWR VPWR _3352_ sky130_fd_sc_hd__mux2_1
X_5817_ _2521_ _2597_ VGND VGND VPWR VPWR _2598_ sky130_fd_sc_hd__nor2_1
X_8605_ clknet_leaf_27_CLK _0862_ VGND VGND VPWR VPWR RF.reg_arr\[0\]\[31\] sky130_fd_sc_hd__dfxtp_1
XFILLER_0_29_281 VGND VGND VPWR VPWR sky130_fd_sc_hd__decap_3
X_6797_ net310 _3012_ _3307_ VGND VGND VPWR VPWR _3315_ sky130_fd_sc_hd__mux2_1
X_8536_ clknet_leaf_52_CLK _0793_ VGND VGND VPWR VPWR RF.reg_arr\[1\]\[26\] sky130_fd_sc_hd__dfxtp_1
X_5748_ _2485_ _2529_ _2530_ _2334_ VGND VGND VPWR VPWR _2531_ sky130_fd_sc_hd__a211o_1
XFILLER_0_115_673 VPWR VGND VPWR VGND sky130_ef_sc_hd__decap_12
X_5679_ _2003_ _2462_ _2464_ VGND VGND VPWR VPWR _2465_ sky130_fd_sc_hd__a21oi_1
X_8467_ net387 net43 _4211_ VGND VGND VPWR VPWR _4217_ sky130_fd_sc_hd__mux2_1
XFILLER_0_102_312 VGND VGND VPWR VPWR sky130_fd_sc_hd__fill_1
X_7418_ _3115_ net595 _3652_ VGND VGND VPWR VPWR _3660_ sky130_fd_sc_hd__mux2_1
XFILLER_0_13_671 VGND VGND VPWR VPWR sky130_fd_sc_hd__fill_1
X_8398_ net288 _3401_ _4174_ VGND VGND VPWR VPWR _4181_ sky130_fd_sc_hd__mux2_1
X_7349_ _3623_ VGND VGND VPWR VPWR _0217_ sky130_fd_sc_hd__clkbuf_1
Xhold561 RF.reg_arr\[26\]\[1\] VGND VGND VPWR VPWR net643 sky130_fd_sc_hd__dlygate4sd3_1
XTAP_TAPCELL_ROW_9_358 VGND VPWR sky130_fd_sc_hd__tapvpwrvgnd_1
Xhold550 RF.reg_arr\[6\]\[5\] VGND VGND VPWR VPWR net632 sky130_fd_sc_hd__dlygate4sd3_1
Xhold572 RF.reg_arr\[6\]\[18\] VGND VGND VPWR VPWR net654 sky130_fd_sc_hd__dlygate4sd3_1
Xhold594 RF.reg_arr\[24\]\[4\] VGND VGND VPWR VPWR net676 sky130_fd_sc_hd__dlygate4sd3_1
Xhold583 RF.reg_arr\[8\]\[8\] VGND VGND VPWR VPWR net665 sky130_fd_sc_hd__dlygate4sd3_1
X_9019_ clknet_leaf_29_CLK _0252_ VGND VGND VPWR VPWR RF.reg_arr\[27\]\[29\] sky130_fd_sc_hd__dfxtp_1
XTAP_TAPCELL_ROW_56_920 VGND VPWR sky130_fd_sc_hd__tapvpwrvgnd_1
XFILLER_0_55_505 VGND VGND VPWR VPWR sky130_fd_sc_hd__decap_3
XFILLER_0_12_15 VPWR VGND VPWR VGND sky130_ef_sc_hd__decap_12
XTAP_TAPCELL_ROW_97_1421 VGND VPWR sky130_fd_sc_hd__tapvpwrvgnd_1
XTAP_TAPCELL_ROW_97_1410 VGND VPWR sky130_fd_sc_hd__tapvpwrvgnd_1
XFILLER_0_50_265 VGND VGND VPWR VPWR sky130_fd_sc_hd__fill_1
Xoutput70 net70 VGND VGND VPWR VPWR result[29] sky130_fd_sc_hd__clkbuf_4
XFILLER_0_78_608 VGND VGND VPWR VPWR sky130_fd_sc_hd__decap_6
XFILLER_0_53_33 VPWR VGND VPWR VGND sky130_ef_sc_hd__decap_12
X_4981_ _1768_ _1769_ _1613_ VGND VGND VPWR VPWR _1770_ sky130_fd_sc_hd__mux2_1
XFILLER_0_86_685 VGND VGND VPWR VPWR sky130_fd_sc_hd__fill_1
XTAP_TAPCELL_ROW_34_658 VGND VPWR sky130_fd_sc_hd__tapvpwrvgnd_1
X_6720_ _3065_ net1074 _3270_ VGND VGND VPWR VPWR _3274_ sky130_fd_sc_hd__mux2_1
X_6651_ _3236_ VGND VGND VPWR VPWR _0930_ sky130_fd_sc_hd__clkbuf_1
X_9370_ clknet_leaf_31_CLK _0603_ VGND VGND VPWR VPWR RF.reg_arr\[18\]\[28\] sky130_fd_sc_hd__dfxtp_1
X_5602_ _1667_ _2121_ VGND VGND VPWR VPWR _2390_ sky130_fd_sc_hd__nand2_1
X_6582_ net176 _3004_ _3196_ VGND VGND VPWR VPWR _3200_ sky130_fd_sc_hd__mux2_1
X_5533_ RF.reg_arr\[8\]\[1\] RF.reg_arr\[9\]\[1\] RF.reg_arr\[10\]\[1\] RF.reg_arr\[11\]\[1\]
+ _1621_ _1594_ VGND VGND VPWR VPWR _2322_ sky130_fd_sc_hd__mux4_1
X_8321_ _4140_ VGND VGND VPWR VPWR _0672_ sky130_fd_sc_hd__clkbuf_1
XFILLER_0_54_560 VGND VGND VPWR VPWR sky130_fd_sc_hd__decap_3
XFILLER_0_5_178 VPWR VGND VPWR VGND sky130_ef_sc_hd__decap_12
XFILLER_0_5_167 VGND VGND VPWR VPWR sky130_fd_sc_hd__fill_1
XFILLER_0_112_632 VGND VGND VPWR VPWR sky130_fd_sc_hd__decap_6
X_8252_ net424 _3391_ _4102_ VGND VGND VPWR VPWR _4104_ sky130_fd_sc_hd__mux2_1
X_5464_ _1643_ _2244_ _2252_ VGND VGND VPWR VPWR _2253_ sky130_fd_sc_hd__o21ai_4
X_7203_ net146 _3435_ _3543_ VGND VGND VPWR VPWR _3546_ sky130_fd_sc_hd__mux2_1
X_4415_ _1198_ _1200_ _1203_ _1173_ _1159_ VGND VGND VPWR VPWR _1204_ sky130_fd_sc_hd__a221o_1
X_5395_ RF.reg_arr\[12\]\[13\] RF.reg_arr\[13\]\[13\] RF.reg_arr\[14\]\[13\] RF.reg_arr\[15\]\[13\]
+ _1846_ _1849_ VGND VGND VPWR VPWR _2184_ sky130_fd_sc_hd__mux4_1
X_8183_ _4067_ VGND VGND VPWR VPWR _0607_ sky130_fd_sc_hd__clkbuf_1
X_7134_ _3509_ VGND VGND VPWR VPWR _0116_ sky130_fd_sc_hd__clkbuf_1
X_4346_ _1053_ VGND VGND VPWR VPWR _1135_ sky130_fd_sc_hd__buf_4
XFILLER_0_1_373 VGND VGND VPWR VPWR sky130_fd_sc_hd__decap_3
XTAP_TAPCELL_ROW_6_328 VGND VPWR sky130_fd_sc_hd__tapvpwrvgnd_1
X_4277_ net47 _1024_ _1065_ VGND VGND VPWR VPWR _1066_ sky130_fd_sc_hd__and3_1
X_7065_ net158 _3433_ _3471_ VGND VGND VPWR VPWR _3473_ sky130_fd_sc_hd__mux2_1
X_6016_ _2782_ _2784_ _1830_ VGND VGND VPWR VPWR _2785_ sky130_fd_sc_hd__mux2_1
X_7967_ _3952_ VGND VGND VPWR VPWR _0506_ sky130_fd_sc_hd__clkbuf_1
XTAP_TAPCELL_ROW_68_1066 VGND VPWR sky130_fd_sc_hd__tapvpwrvgnd_1
XFILLER_0_49_332 VGND VGND VPWR VPWR sky130_fd_sc_hd__decap_4
X_7898_ _3115_ net946 _3908_ VGND VGND VPWR VPWR _3916_ sky130_fd_sc_hd__mux2_1
X_6918_ net291 _3381_ _3366_ VGND VGND VPWR VPWR _3382_ sky130_fd_sc_hd__mux2_1
XTAP_TAPCELL_ROW_81_1222 VGND VPWR sky130_fd_sc_hd__tapvpwrvgnd_1
XFILLER_0_37_505 VGND VGND VPWR VPWR sky130_fd_sc_hd__decap_4
X_6849_ net10 net9 VGND VGND VPWR VPWR _3342_ sky130_fd_sc_hd__or2b_2
XFILLER_0_92_666 VGND VGND VPWR VPWR sky130_fd_sc_hd__decap_8
X_9499_ clknet_leaf_27_CLK _0732_ VGND VGND VPWR VPWR RF.reg_arr\[11\]\[29\] sky130_fd_sc_hd__dfxtp_1
XFILLER_0_72_390 VGND VGND VPWR VPWR sky130_fd_sc_hd__fill_1
X_8519_ clknet_leaf_65_CLK _0776_ VGND VGND VPWR VPWR RF.reg_arr\[1\]\[9\] sky130_fd_sc_hd__dfxtp_1
XFILLER_0_102_153 VPWR VGND VPWR VGND sky130_ef_sc_hd__decap_12
XTAP_TAPCELL_ROW_79_1195 VGND VPWR sky130_fd_sc_hd__tapvpwrvgnd_1
XFILLER_0_60_585 VGND VGND VPWR VPWR sky130_fd_sc_hd__decap_3
XFILLER_0_102_186 VGND VGND VPWR VPWR sky130_fd_sc_hd__fill_1
XTAP_TAPCELL_ROW_92_1351 VGND VPWR sky130_fd_sc_hd__tapvpwrvgnd_1
XFILLER_0_2_3 VPWR VGND VPWR VGND sky130_ef_sc_hd__decap_12
Xhold380 RF.reg_arr\[3\]\[5\] VGND VGND VPWR VPWR net462 sky130_fd_sc_hd__dlygate4sd3_1
XFILLER_0_102_197 VGND VGND VPWR VPWR sky130_fd_sc_hd__decap_3
Xhold391 RF.reg_arr\[22\]\[4\] VGND VGND VPWR VPWR net473 sky130_fd_sc_hd__dlygate4sd3_1
XFILLER_0_87_449 VGND VGND VPWR VPWR sky130_fd_sc_hd__fill_1
XFILLER_0_114_49 VGND VGND VPWR VPWR sky130_fd_sc_hd__fill_1
XFILLER_0_114_27 VGND VGND VPWR VPWR sky130_fd_sc_hd__fill_1
XFILLER_0_83_600 VGND VGND VPWR VPWR sky130_fd_sc_hd__decap_8
XFILLER_0_28_516 VGND VGND VPWR VPWR sky130_fd_sc_hd__fill_2
XFILLER_0_83_633 VGND VGND VPWR VPWR sky130_fd_sc_hd__decap_8
XFILLER_0_83_622 VGND VGND VPWR VPWR sky130_fd_sc_hd__fill_1
XTAP_TAPCELL_ROW_31_628 VGND VPWR sky130_fd_sc_hd__tapvpwrvgnd_1
Xrebuffer3 _2666_ VGND VGND VPWR VPWR net85 sky130_fd_sc_hd__clkbuf_2
XTAP_TAPCELL_ROW_11_385 VGND VPWR sky130_fd_sc_hd__tapvpwrvgnd_1
X_5180_ RF.reg_arr\[28\]\[16\] RF.reg_arr\[29\]\[16\] RF.reg_arr\[30\]\[16\] RF.reg_arr\[31\]\[16\]
+ _1676_ _1682_ VGND VGND VPWR VPWR _1969_ sky130_fd_sc_hd__mux4_1
XTAP_TAPCELL_ROW_39_717 VGND VPWR sky130_fd_sc_hd__tapvpwrvgnd_1
X_8870_ clknet_leaf_88_CLK _0103_ VGND VGND VPWR VPWR RF.reg_arr\[3\]\[8\] sky130_fd_sc_hd__dfxtp_1
X_7821_ _3107_ net430 _3871_ VGND VGND VPWR VPWR _3875_ sky130_fd_sc_hd__mux2_1
XTAP_TAPCELL_ROW_19_474 VGND VPWR sky130_fd_sc_hd__tapvpwrvgnd_1
X_4964_ _1587_ _1744_ _1748_ _1752_ VGND VGND VPWR VPWR _1753_ sky130_fd_sc_hd__o2bb2a_1
X_7752_ _3838_ VGND VGND VPWR VPWR _0405_ sky130_fd_sc_hd__clkbuf_1
XTAP_TAPCELL_ROW_19_485 VGND VPWR sky130_fd_sc_hd__tapvpwrvgnd_1
X_6703_ _3263_ VGND VGND VPWR VPWR _0955_ sky130_fd_sc_hd__clkbuf_1
XFILLER_0_74_633 VGND VGND VPWR VPWR sky130_fd_sc_hd__fill_1
XFILLER_0_19_516 VGND VGND VPWR VPWR sky130_fd_sc_hd__fill_1
X_4895_ _1683_ VGND VGND VPWR VPWR _1684_ sky130_fd_sc_hd__clkbuf_4
X_7683_ _3105_ net887 _3799_ VGND VGND VPWR VPWR _3802_ sky130_fd_sc_hd__mux2_1
X_9422_ clknet_leaf_20_CLK _0655_ VGND VGND VPWR VPWR RF.reg_arr\[17\]\[16\] sky130_fd_sc_hd__dfxtp_1
XFILLER_0_116_234 VGND VGND VPWR VPWR sky130_fd_sc_hd__fill_1
X_6634_ net346 _2986_ _3218_ VGND VGND VPWR VPWR _3227_ sky130_fd_sc_hd__mux2_1
X_6565_ _3190_ VGND VGND VPWR VPWR _0890_ sky130_fd_sc_hd__clkbuf_1
XFILLER_0_80_3 VGND VGND VPWR VPWR sky130_fd_sc_hd__decap_8
X_9353_ clknet_leaf_14_CLK _0586_ VGND VGND VPWR VPWR RF.reg_arr\[18\]\[11\] sky130_fd_sc_hd__dfxtp_1
XFILLER_0_116_289 VGND VGND VPWR VPWR sky130_fd_sc_hd__fill_2
XTAP_TAPCELL_ROW_115_1627 VGND VPWR sky130_fd_sc_hd__tapvpwrvgnd_1
X_8304_ net513 _3375_ _4124_ VGND VGND VPWR VPWR _4131_ sky130_fd_sc_hd__mux2_1
X_6496_ net114 VGND VGND VPWR VPWR _3153_ sky130_fd_sc_hd__clkbuf_1
XFILLER_0_89_73 VGND VGND VPWR VPWR sky130_fd_sc_hd__fill_2
X_5516_ RF.reg_arr\[4\]\[2\] RF.reg_arr\[5\]\[2\] RF.reg_arr\[6\]\[2\] RF.reg_arr\[7\]\[2\]
+ _1846_ _1849_ VGND VGND VPWR VPWR _2305_ sky130_fd_sc_hd__mux4_1
X_9284_ clknet_leaf_83_CLK _0517_ VGND VGND VPWR VPWR RF.reg_arr\[25\]\[6\] sky130_fd_sc_hd__dfxtp_1
X_8235_ _4094_ VGND VGND VPWR VPWR _0632_ sky130_fd_sc_hd__clkbuf_1
X_5447_ _1667_ _2235_ VGND VGND VPWR VPWR _2236_ sky130_fd_sc_hd__nor2_1
X_8166_ net194 _3373_ _4052_ VGND VGND VPWR VPWR _4058_ sky130_fd_sc_hd__mux2_1
X_5378_ RF.reg_arr\[8\]\[12\] RF.reg_arr\[9\]\[12\] RF.reg_arr\[10\]\[12\] RF.reg_arr\[11\]\[12\]
+ _1589_ _1834_ VGND VGND VPWR VPWR _2167_ sky130_fd_sc_hd__mux4_1
X_8097_ _4021_ VGND VGND VPWR VPWR _0567_ sky130_fd_sc_hd__clkbuf_1
X_4329_ _1029_ VGND VGND VPWR VPWR _1118_ sky130_fd_sc_hd__buf_4
X_7117_ _3500_ VGND VGND VPWR VPWR _0108_ sky130_fd_sc_hd__clkbuf_1
X_7048_ net752 _3416_ _3460_ VGND VGND VPWR VPWR _3464_ sky130_fd_sc_hd__mux2_1
XPHY_EDGE_ROW_114_Right_114 VGND VGND VPWR VPWR sky130_fd_sc_hd__decap_3
X_8999_ clknet_leaf_78_CLK _0232_ VGND VGND VPWR VPWR RF.reg_arr\[27\]\[9\] sky130_fd_sc_hd__dfxtp_1
XFILLER_0_84_419 VGND VGND VPWR VPWR sky130_fd_sc_hd__fill_1
XFILLER_0_65_611 VGND VGND VPWR VPWR sky130_fd_sc_hd__decap_4
XFILLER_0_37_302 VGND VGND VPWR VPWR sky130_fd_sc_hd__fill_2
XFILLER_0_49_173 VGND VGND VPWR VPWR sky130_fd_sc_hd__decap_4
XFILLER_0_80_625 VGND VGND VPWR VPWR sky130_fd_sc_hd__decap_4
XFILLER_0_9_281 VGND VGND VPWR VPWR sky130_fd_sc_hd__fill_1
XFILLER_0_107_278 VGND VGND VPWR VPWR sky130_fd_sc_hd__fill_2
XFILLER_0_20_213 VPWR VGND VPWR VGND sky130_ef_sc_hd__decap_12
XFILLER_0_109_27 VGND VGND VPWR VPWR sky130_fd_sc_hd__decap_4
XTAP_TAPCELL_ROW_16_444 VGND VPWR sky130_fd_sc_hd__tapvpwrvgnd_1
XTAP_TAPCELL_ROW_44_775 VGND VPWR sky130_fd_sc_hd__tapvpwrvgnd_1
XFILLER_0_83_485 VGND VGND VPWR VPWR sky130_fd_sc_hd__fill_2
X_4680_ RF.reg_arr\[28\]\[30\] RF.reg_arr\[29\]\[30\] RF.reg_arr\[30\]\[30\] RF.reg_arr\[31\]\[30\]
+ _1450_ _1451_ VGND VGND VPWR VPWR _1469_ sky130_fd_sc_hd__mux4_1
XFILLER_0_24_530 VGND VGND VPWR VPWR sky130_fd_sc_hd__fill_2
X_6350_ _3064_ VGND VGND VPWR VPWR _0801_ sky130_fd_sc_hd__clkbuf_1
X_5301_ _2088_ _2089_ _1603_ VGND VGND VPWR VPWR _2090_ sky130_fd_sc_hd__mux2_1
X_6281_ net621 _3018_ _3019_ VGND VGND VPWR VPWR _3020_ sky130_fd_sc_hd__mux2_1
XFILLER_0_51_393 VGND VGND VPWR VPWR sky130_fd_sc_hd__decap_8
X_8020_ _3039_ net650 _3980_ VGND VGND VPWR VPWR _3981_ sky130_fd_sc_hd__mux2_1
X_5232_ _1159_ _2008_ _2012_ _2016_ _2020_ VGND VGND VPWR VPWR _2021_ sky130_fd_sc_hd__a32o_4
X_5163_ RF.reg_arr\[28\]\[19\] RF.reg_arr\[29\]\[19\] RF.reg_arr\[30\]\[19\] RF.reg_arr\[31\]\[19\]
+ _1947_ _1948_ VGND VGND VPWR VPWR _1952_ sky130_fd_sc_hd__mux4_1
XFILLER_0_45_6 VPWR VGND VPWR VGND sky130_ef_sc_hd__decap_12
XTAP_TAPCELL_ROW_110_1568 VGND VPWR sky130_fd_sc_hd__tapvpwrvgnd_1
X_5094_ _1674_ VGND VGND VPWR VPWR _1883_ sky130_fd_sc_hd__buf_4
X_8922_ clknet_leaf_26_CLK _0155_ VGND VGND VPWR VPWR RF.reg_arr\[7\]\[28\] sky130_fd_sc_hd__dfxtp_1
X_8853_ clknet_leaf_16_CLK _0086_ VGND VGND VPWR VPWR RF.reg_arr\[19\]\[23\] sky130_fd_sc_hd__dfxtp_1
XFILLER_0_93_205 VGND VGND VPWR VPWR sky130_fd_sc_hd__fill_1
XTAP_TAPCELL_ROW_65_1036 VGND VPWR sky130_fd_sc_hd__tapvpwrvgnd_1
X_7804_ _3090_ net1044 _3860_ VGND VGND VPWR VPWR _3866_ sky130_fd_sc_hd__mux2_1
XFILLER_0_115_81 VGND VGND VPWR VPWR sky130_fd_sc_hd__fill_1
X_5996_ _2762_ _2765_ _2766_ VGND VGND VPWR VPWR _2767_ sky130_fd_sc_hd__and3_1
X_8784_ clknet_leaf_3_CLK _0017_ VGND VGND VPWR VPWR RF.reg_arr\[5\]\[18\] sky130_fd_sc_hd__dfxtp_1
X_4947_ _1159_ _1723_ _1727_ _1731_ _1735_ VGND VGND VPWR VPWR _1736_ sky130_fd_sc_hd__a32o_1
X_7735_ _3829_ VGND VGND VPWR VPWR _0397_ sky130_fd_sc_hd__clkbuf_1
X_4878_ _1113_ VGND VGND VPWR VPWR _1667_ sky130_fd_sc_hd__buf_2
X_7666_ _3088_ net1001 _3788_ VGND VGND VPWR VPWR _3793_ sky130_fd_sc_hd__mux2_1
XFILLER_0_46_176 VGND VGND VPWR VPWR sky130_fd_sc_hd__decap_4
X_6617_ _3195_ VGND VGND VPWR VPWR _3218_ sky130_fd_sc_hd__clkbuf_8
X_9405_ clknet_leaf_24_CLK _0638_ VGND VGND VPWR VPWR RF.reg_arr\[13\]\[31\] sky130_fd_sc_hd__dfxtp_1
XFILLER_0_34_338 VGND VGND VPWR VPWR sky130_fd_sc_hd__fill_1
X_9336_ clknet_leaf_35_CLK _0569_ VGND VGND VPWR VPWR RF.reg_arr\[20\]\[26\] sky130_fd_sc_hd__dfxtp_1
XFILLER_0_15_552 VGND VGND VPWR VPWR sky130_fd_sc_hd__decap_8
X_7597_ _3756_ VGND VGND VPWR VPWR _0332_ sky130_fd_sc_hd__clkbuf_1
X_6548_ _3181_ VGND VGND VPWR VPWR _0882_ sky130_fd_sc_hd__clkbuf_1
X_9267_ clknet_leaf_48_CLK _0500_ VGND VGND VPWR VPWR RF.reg_arr\[21\]\[21\] sky130_fd_sc_hd__dfxtp_1
XTAP_TAPCELL_ROW_76_1165 VGND VPWR sky130_fd_sc_hd__tapvpwrvgnd_1
X_6479_ _3144_ VGND VGND VPWR VPWR _0850_ sky130_fd_sc_hd__clkbuf_1
XFILLER_0_100_421 VGND VGND VPWR VPWR sky130_fd_sc_hd__decap_4
X_8218_ _4085_ VGND VGND VPWR VPWR _0624_ sky130_fd_sc_hd__clkbuf_1
X_9198_ clknet_leaf_5_CLK _0431_ VGND VGND VPWR VPWR RF.reg_arr\[24\]\[16\] sky130_fd_sc_hd__dfxtp_1
X_8149_ net667 _3424_ _4041_ VGND VGND VPWR VPWR _4049_ sky130_fd_sc_hd__mux2_1
XFILLER_0_100_487 VPWR VGND VPWR VGND sky130_ef_sc_hd__decap_12
XFILLER_0_97_522 VPWR VGND VPWR VGND sky130_ef_sc_hd__decap_12
XTAP_TAPCELL_ROW_87_1294 VGND VPWR sky130_fd_sc_hd__tapvpwrvgnd_1
XFILLER_0_69_279 VGND VGND VPWR VPWR sky130_fd_sc_hd__fill_1
XTAP_TAPCELL_ROW_13_403 VGND VPWR sky130_fd_sc_hd__tapvpwrvgnd_1
XFILLER_0_37_143 VGND VGND VPWR VPWR sky130_fd_sc_hd__fill_1
XTAP_TAPCELL_ROW_41_745 VGND VPWR sky130_fd_sc_hd__tapvpwrvgnd_1
XFILLER_0_92_293 VGND VGND VPWR VPWR sky130_fd_sc_hd__decap_4
XFILLER_0_37_198 VGND VGND VPWR VPWR sky130_fd_sc_hd__decap_3
XFILLER_0_53_647 VGND VGND VPWR VPWR sky130_fd_sc_hd__decap_3
XFILLER_0_111_39 VGND VGND VPWR VPWR sky130_fd_sc_hd__fill_2
XFILLER_0_20_26 VGND VGND VPWR VPWR sky130_fd_sc_hd__fill_2
XFILLER_0_110_218 VGND VGND VPWR VPWR sky130_fd_sc_hd__decap_4
XFILLER_0_33_393 VGND VGND VPWR VPWR sky130_fd_sc_hd__decap_3
XTAP_TAPCELL_ROW_49_834 VGND VPWR sky130_fd_sc_hd__tapvpwrvgnd_1
XTAP_TAPCELL_ROW_49_845 VGND VPWR sky130_fd_sc_hd__tapvpwrvgnd_1
X_5850_ _2465_ _2583_ _2445_ VGND VGND VPWR VPWR _2628_ sky130_fd_sc_hd__o21a_1
X_5781_ _2381_ VGND VGND VPWR VPWR _2563_ sky130_fd_sc_hd__inv_2
XFILLER_0_0_69 VPWR VGND VPWR VGND sky130_ef_sc_hd__decap_12
XFILLER_0_29_644 VGND VGND VPWR VPWR sky130_fd_sc_hd__decap_6
X_4801_ _1589_ VGND VGND VPWR VPWR _1590_ sky130_fd_sc_hd__buf_4
X_7520_ _3715_ VGND VGND VPWR VPWR _0296_ sky130_fd_sc_hd__clkbuf_1
X_4732_ RF.reg_arr\[28\]\[14\] RF.reg_arr\[29\]\[14\] RF.reg_arr\[30\]\[14\] RF.reg_arr\[31\]\[14\]
+ _1357_ _1358_ VGND VGND VPWR VPWR _1521_ sky130_fd_sc_hd__mux4_1
X_4663_ RF.reg_arr\[20\]\[31\] RF.reg_arr\[21\]\[31\] RF.reg_arr\[22\]\[31\] RF.reg_arr\[23\]\[31\]
+ _1450_ _1451_ VGND VGND VPWR VPWR _1452_ sky130_fd_sc_hd__mux4_1
XFILLER_0_28_187 VGND VGND VPWR VPWR sky130_fd_sc_hd__fill_1
X_7451_ _3666_ VGND VGND VPWR VPWR _3678_ sky130_fd_sc_hd__clkbuf_8
XFILLER_0_9_45 VGND VGND VPWR VPWR sky130_fd_sc_hd__decap_3
X_6402_ _3099_ VGND VGND VPWR VPWR _0818_ sky130_fd_sc_hd__clkbuf_1
X_4594_ _1116_ _1374_ _1378_ _1382_ VGND VGND VPWR VPWR _1383_ sky130_fd_sc_hd__a2bb2o_2
X_7382_ _3629_ VGND VGND VPWR VPWR _3641_ sky130_fd_sc_hd__clkbuf_8
XFILLER_0_12_522 VGND VGND VPWR VPWR sky130_fd_sc_hd__fill_2
Xhold913 RF.reg_arr\[31\]\[19\] VGND VGND VPWR VPWR net995 sky130_fd_sc_hd__dlygate4sd3_1
Xhold902 RF.reg_arr\[22\]\[11\] VGND VGND VPWR VPWR net984 sky130_fd_sc_hd__dlygate4sd3_1
XFILLER_0_101_207 VGND VGND VPWR VPWR sky130_fd_sc_hd__fill_1
Xhold924 RF.reg_arr\[20\]\[27\] VGND VGND VPWR VPWR net1006 sky130_fd_sc_hd__dlygate4sd3_1
Xhold935 RF.reg_arr\[5\]\[28\] VGND VGND VPWR VPWR net1017 sky130_fd_sc_hd__dlygate4sd3_1
X_6333_ net305 _2988_ _3040_ VGND VGND VPWR VPWR _3053_ sky130_fd_sc_hd__mux2_1
XFILLER_0_12_533 VGND VGND VPWR VPWR sky130_fd_sc_hd__decap_8
Xhold946 RF.reg_arr\[24\]\[5\] VGND VGND VPWR VPWR net1028 sky130_fd_sc_hd__dlygate4sd3_1
X_9121_ clknet_leaf_70_CLK _0354_ VGND VGND VPWR VPWR RF.reg_arr\[30\]\[3\] sky130_fd_sc_hd__dfxtp_1
X_9052_ clknet_leaf_22_CLK _0285_ VGND VGND VPWR VPWR RF.reg_arr\[26\]\[30\] sky130_fd_sc_hd__dfxtp_1
Xhold957 RF.reg_arr\[29\]\[7\] VGND VGND VPWR VPWR net1039 sky130_fd_sc_hd__dlygate4sd3_1
Xhold968 RF.reg_arr\[31\]\[5\] VGND VGND VPWR VPWR net1050 sky130_fd_sc_hd__dlygate4sd3_1
X_6264_ net41 VGND VGND VPWR VPWR _3008_ sky130_fd_sc_hd__buf_2
Xhold979 RF.reg_arr\[14\]\[10\] VGND VGND VPWR VPWR net1061 sky130_fd_sc_hd__dlygate4sd3_1
X_5215_ _1930_ _2002_ _2003_ VGND VGND VPWR VPWR _2004_ sky130_fd_sc_hd__mux2_1
X_8003_ _3023_ net957 _3969_ VGND VGND VPWR VPWR _3972_ sky130_fd_sc_hd__mux2_1
X_6195_ _1483_ _2953_ VGND VGND VPWR VPWR _2954_ sky130_fd_sc_hd__xor2_1
XFILLER_0_43_3 VGND VGND VPWR VPWR sky130_fd_sc_hd__fill_2
X_5146_ _1931_ _1932_ _1933_ _1934_ _1865_ _1845_ VGND VGND VPWR VPWR _1935_ sky130_fd_sc_hd__mux4_1
X_5077_ _1861_ _1862_ _1865_ VGND VGND VPWR VPWR _1866_ sky130_fd_sc_hd__mux2_1
X_8905_ clknet_leaf_13_CLK _0138_ VGND VGND VPWR VPWR RF.reg_arr\[7\]\[11\] sky130_fd_sc_hd__dfxtp_1
X_8836_ clknet_leaf_84_CLK _0069_ VGND VGND VPWR VPWR RF.reg_arr\[19\]\[6\] sky130_fd_sc_hd__dfxtp_1
X_5979_ _2418_ _2379_ _2601_ _2718_ _2750_ VGND VGND VPWR VPWR _2751_ sky130_fd_sc_hd__o221a_1
X_8767_ clknet_leaf_58_CLK _0000_ VGND VGND VPWR VPWR RF.reg_arr\[5\]\[1\] sky130_fd_sc_hd__dfxtp_1
XFILLER_0_19_132 VGND VGND VPWR VPWR sky130_fd_sc_hd__fill_2
XFILLER_0_81_208 VGND VGND VPWR VPWR sky130_fd_sc_hd__fill_1
X_7718_ _3820_ VGND VGND VPWR VPWR _0389_ sky130_fd_sc_hd__clkbuf_1
X_8698_ clknet_leaf_28_CLK _0955_ VGND VGND VPWR VPWR RF.reg_arr\[15\]\[28\] sky130_fd_sc_hd__dfxtp_1
XFILLER_0_105_524 VGND VGND VPWR VPWR sky130_fd_sc_hd__fill_2
XFILLER_0_62_477 VPWR VGND VPWR VGND sky130_ef_sc_hd__decap_12
X_7649_ _3071_ net890 _3777_ VGND VGND VPWR VPWR _3784_ sky130_fd_sc_hd__mux2_1
XFILLER_0_50_639 VGND VGND VPWR VPWR sky130_fd_sc_hd__fill_2
X_9319_ clknet_leaf_77_CLK _0552_ VGND VGND VPWR VPWR RF.reg_arr\[20\]\[9\] sky130_fd_sc_hd__dfxtp_1
XFILLER_0_100_262 VGND VGND VPWR VPWR sky130_fd_sc_hd__decap_4
XTAP_TAPCELL_ROW_89_1323 VGND VPWR sky130_fd_sc_hd__tapvpwrvgnd_1
XFILLER_0_89_308 VGND VGND VPWR VPWR sky130_fd_sc_hd__fill_1
XTAP_TAPCELL_ROW_46_804 VGND VPWR sky130_fd_sc_hd__tapvpwrvgnd_1
XFILLER_0_15_15 VGND VGND VPWR VPWR sky130_fd_sc_hd__decap_8
XTAP_TAPCELL_ROW_26_561 VGND VPWR sky130_fd_sc_hd__tapvpwrvgnd_1
XFILLER_0_93_580 VGND VGND VPWR VPWR sky130_fd_sc_hd__fill_1
XFILLER_0_41_617 VGND VGND VPWR VPWR sky130_fd_sc_hd__fill_1
XFILLER_0_53_444 VGND VGND VPWR VPWR sky130_fd_sc_hd__decap_4
XFILLER_0_111_505 VGND VGND VPWR VPWR sky130_fd_sc_hd__decap_3
Xhold209 RF.reg_arr\[5\]\[29\] VGND VGND VPWR VPWR net291 sky130_fd_sc_hd__dlygate4sd3_1
XFILLER_0_34_691 VGND VGND VPWR VPWR sky130_fd_sc_hd__fill_1
X_5000_ _1587_ _1780_ _1784_ _1788_ VGND VGND VPWR VPWR _1789_ sky130_fd_sc_hd__o2bb2a_1
XPHY_EDGE_ROW_0_Left_117 VGND VGND VPWR VPWR sky130_fd_sc_hd__decap_3
XFILLER_0_56_77 VGND VGND VPWR VPWR sky130_fd_sc_hd__fill_2
XFILLER_0_56_99 VGND VGND VPWR VPWR sky130_fd_sc_hd__decap_3
XFILLER_0_72_32 VPWR VGND VPWR VGND sky130_ef_sc_hd__decap_12
X_6951_ _3404_ VGND VGND VPWR VPWR _0038_ sky130_fd_sc_hd__clkbuf_1
X_5902_ _2631_ _2677_ _2434_ VGND VGND VPWR VPWR _2678_ sky130_fd_sc_hd__mux2_1
X_6882_ _3360_ VGND VGND VPWR VPWR _0013_ sky130_fd_sc_hd__clkbuf_1
X_5833_ _2611_ _2612_ VGND VGND VPWR VPWR _2613_ sky130_fd_sc_hd__xnor2_1
X_8621_ clknet_leaf_101_CLK _0878_ VGND VGND VPWR VPWR RF.reg_arr\[16\]\[15\] sky130_fd_sc_hd__dfxtp_1
XFILLER_0_8_302 VGND VGND VPWR VPWR sky130_fd_sc_hd__decap_6
XFILLER_0_17_614 VGND VGND VPWR VPWR sky130_fd_sc_hd__fill_2
XFILLER_0_29_463 VGND VGND VPWR VPWR sky130_fd_sc_hd__fill_1
X_8552_ clknet_leaf_94_CLK _0809_ VGND VGND VPWR VPWR RF.reg_arr\[23\]\[10\] sky130_fd_sc_hd__dfxtp_1
X_5764_ _1401_ VGND VGND VPWR VPWR _2546_ sky130_fd_sc_hd__inv_2
X_7503_ net447 _3391_ _3705_ VGND VGND VPWR VPWR _3707_ sky130_fd_sc_hd__mux2_1
XFILLER_0_56_282 VGND VGND VPWR VPWR sky130_fd_sc_hd__decap_4
X_5695_ _2478_ _2479_ _2480_ _2200_ VGND VGND VPWR VPWR _2481_ sky130_fd_sc_hd__a2bb2o_1
XFILLER_0_16_135 VGND VGND VPWR VPWR sky130_fd_sc_hd__decap_4
X_8483_ _4225_ VGND VGND VPWR VPWR _0749_ sky130_fd_sc_hd__clkbuf_1
X_4715_ _1121_ _1503_ _1110_ VGND VGND VPWR VPWR _1504_ sky130_fd_sc_hd__o21ai_1
XFILLER_0_112_82 VGND VGND VPWR VPWR sky130_fd_sc_hd__fill_2
X_4646_ RF.reg_arr\[28\]\[26\] RF.reg_arr\[29\]\[26\] RF.reg_arr\[30\]\[26\] RF.reg_arr\[31\]\[26\]
+ _1273_ _1275_ VGND VGND VPWR VPWR _1435_ sky130_fd_sc_hd__mux4_1
X_7434_ _3669_ VGND VGND VPWR VPWR _0256_ sky130_fd_sc_hd__clkbuf_1
X_4577_ _1110_ _1365_ _1141_ VGND VGND VPWR VPWR _1366_ sky130_fd_sc_hd__a21oi_1
X_7365_ _3632_ VGND VGND VPWR VPWR _0224_ sky130_fd_sc_hd__clkbuf_1
Xhold721 RF.reg_arr\[8\]\[12\] VGND VGND VPWR VPWR net803 sky130_fd_sc_hd__dlygate4sd3_1
Xhold710 RF.reg_arr\[20\]\[10\] VGND VGND VPWR VPWR net792 sky130_fd_sc_hd__dlygate4sd3_1
XFILLER_0_114_398 VGND VGND VPWR VPWR sky130_fd_sc_hd__fill_1
Xclkbuf_3_3__f_CLK clknet_0_CLK VGND VGND VPWR VPWR clknet_3_3__leaf_CLK sky130_fd_sc_hd__clkbuf_16
X_6316_ _3043_ VGND VGND VPWR VPWR _0788_ sky130_fd_sc_hd__clkbuf_1
Xhold732 RF.reg_arr\[12\]\[30\] VGND VGND VPWR VPWR net814 sky130_fd_sc_hd__dlygate4sd3_1
Xhold754 RF.reg_arr\[28\]\[20\] VGND VGND VPWR VPWR net836 sky130_fd_sc_hd__dlygate4sd3_1
Xhold743 RF.reg_arr\[23\]\[18\] VGND VGND VPWR VPWR net825 sky130_fd_sc_hd__dlygate4sd3_1
X_9104_ clknet_leaf_2_CLK _0337_ VGND VGND VPWR VPWR RF.reg_arr\[2\]\[18\] sky130_fd_sc_hd__dfxtp_1
XTAP_TAPCELL_ROW_73_1124 VGND VPWR sky130_fd_sc_hd__tapvpwrvgnd_1
Xhold765 RF.reg_arr\[19\]\[31\] VGND VGND VPWR VPWR net847 sky130_fd_sc_hd__dlygate4sd3_1
X_7296_ _3061_ net568 _3594_ VGND VGND VPWR VPWR _3596_ sky130_fd_sc_hd__mux2_1
Xhold787 RF.reg_arr\[17\]\[15\] VGND VGND VPWR VPWR net869 sky130_fd_sc_hd__dlygate4sd3_1
Xhold776 RF.reg_arr\[13\]\[13\] VGND VGND VPWR VPWR net858 sky130_fd_sc_hd__dlygate4sd3_1
X_6247_ net10 net9 VGND VGND VPWR VPWR _2996_ sky130_fd_sc_hd__nor2b_4
Xhold798 RF.reg_arr\[16\]\[17\] VGND VGND VPWR VPWR net880 sky130_fd_sc_hd__dlygate4sd3_1
X_9035_ clknet_leaf_11_CLK _0268_ VGND VGND VPWR VPWR RF.reg_arr\[26\]\[13\] sky130_fd_sc_hd__dfxtp_1
X_6178_ _1696_ _2936_ VGND VGND VPWR VPWR _2938_ sky130_fd_sc_hd__and2_1
XFILLER_0_99_617 VPWR VGND VPWR VGND sky130_ef_sc_hd__decap_12
XFILLER_0_99_606 VGND VGND VPWR VPWR sky130_fd_sc_hd__decap_3
X_5129_ RF.reg_arr\[12\]\[21\] RF.reg_arr\[13\]\[21\] RF.reg_arr\[14\]\[21\] RF.reg_arr\[15\]\[21\]
+ _1591_ _1878_ VGND VGND VPWR VPWR _1918_ sky130_fd_sc_hd__mux4_1
XFILLER_0_67_514 VGND VGND VPWR VPWR sky130_fd_sc_hd__decap_4
XTAP_TAPCELL_ROW_84_1264 VGND VPWR sky130_fd_sc_hd__tapvpwrvgnd_1
X_8819_ clknet_leaf_45_CLK _0052_ VGND VGND VPWR VPWR RF.reg_arr\[4\]\[21\] sky130_fd_sc_hd__dfxtp_1
XTAP_TAPCELL_ROW_23_531 VGND VPWR sky130_fd_sc_hd__tapvpwrvgnd_1
XTAP_TAPCELL_ROW_51_862 VGND VPWR sky130_fd_sc_hd__tapvpwrvgnd_1
XFILLER_0_90_561 VGND VGND VPWR VPWR sky130_fd_sc_hd__decap_6
XFILLER_0_90_583 VGND VGND VPWR VPWR sky130_fd_sc_hd__decap_4
XFILLER_0_50_469 VGND VGND VPWR VPWR sky130_fd_sc_hd__fill_2
XTAP_TAPCELL_ROW_95_1393 VGND VPWR sky130_fd_sc_hd__tapvpwrvgnd_1
Xhold70 RF.reg_arr\[10\]\[25\] VGND VGND VPWR VPWR net152 sky130_fd_sc_hd__dlygate4sd3_1
Xhold81 RF.reg_arr\[1\]\[1\] VGND VGND VPWR VPWR net163 sky130_fd_sc_hd__dlygate4sd3_1
XTAP_TAPCELL_ROW_59_962 VGND VPWR sky130_fd_sc_hd__tapvpwrvgnd_1
Xhold92 RF.reg_arr\[9\]\[12\] VGND VGND VPWR VPWR net174 sky130_fd_sc_hd__dlygate4sd3_1
XFILLER_0_26_69 VGND VGND VPWR VPWR sky130_fd_sc_hd__fill_2
XPHY_EDGE_ROW_82_Left_199 VGND VGND VPWR VPWR sky130_fd_sc_hd__decap_3
XFILLER_0_109_660 VGND VGND VPWR VPWR sky130_fd_sc_hd__fill_1
XFILLER_0_26_411 VGND VGND VPWR VPWR sky130_fd_sc_hd__fill_1
XFILLER_0_108_192 VGND VGND VPWR VPWR sky130_fd_sc_hd__decap_4
X_4500_ RF.reg_arr\[4\]\[28\] RF.reg_arr\[5\]\[28\] RF.reg_arr\[6\]\[28\] RF.reg_arr\[7\]\[28\]
+ _1274_ _1276_ VGND VGND VPWR VPWR _1289_ sky130_fd_sc_hd__mux4_1
XFILLER_0_81_583 VGND VGND VPWR VPWR sky130_fd_sc_hd__decap_3
XFILLER_0_81_561 VGND VGND VPWR VPWR sky130_fd_sc_hd__fill_2
XFILLER_0_26_477 VGND VGND VPWR VPWR sky130_fd_sc_hd__fill_2
X_5480_ _2267_ _2268_ _1942_ VGND VGND VPWR VPWR _2269_ sky130_fd_sc_hd__mux2_1
XFILLER_0_53_263 VPWR VGND VPWR VGND sky130_ef_sc_hd__decap_12
X_4431_ RF.reg_arr\[0\]\[8\] RF.reg_arr\[1\]\[8\] RF.reg_arr\[2\]\[8\] RF.reg_arr\[3\]\[8\]
+ _1050_ _1052_ VGND VGND VPWR VPWR _1220_ sky130_fd_sc_hd__mux4_1
XANTENNA_1 A2[2] VGND VGND VPWR VPWR sky130_fd_sc_hd__diode_2
X_7150_ _3517_ VGND VGND VPWR VPWR _0124_ sky130_fd_sc_hd__clkbuf_1
X_4362_ RF.reg_arr\[12\]\[17\] RF.reg_arr\[13\]\[17\] RF.reg_arr\[14\]\[17\] RF.reg_arr\[15\]\[17\]
+ _1134_ _1135_ VGND VGND VPWR VPWR _1151_ sky130_fd_sc_hd__mux4_1
X_6101_ _2864_ _2858_ VGND VGND VPWR VPWR _2866_ sky130_fd_sc_hd__and2b_1
X_7081_ net162 _3381_ _3471_ VGND VGND VPWR VPWR _3481_ sky130_fd_sc_hd__mux2_1
XFILLER_0_67_54 VGND VGND VPWR VPWR sky130_fd_sc_hd__fill_2
X_4293_ _1043_ VGND VGND VPWR VPWR _1082_ sky130_fd_sc_hd__buf_4
X_6032_ _1349_ _2799_ _1550_ net1124 _2759_ VGND VGND VPWR VPWR _2800_ sky130_fd_sc_hd__a41o_1
Xrebuffer13 _2666_ VGND VGND VPWR VPWR net95 sky130_fd_sc_hd__clkbuf_1
X_7983_ _3961_ VGND VGND VPWR VPWR _0513_ sky130_fd_sc_hd__clkbuf_1
X_6934_ net36 VGND VGND VPWR VPWR _3393_ sky130_fd_sc_hd__buf_2
XTAP_TAPCELL_ROW_1_259 VGND VPWR sky130_fd_sc_hd__tapvpwrvgnd_1
XFILLER_0_49_503 VGND VGND VPWR VPWR sky130_fd_sc_hd__fill_1
XFILLER_0_49_514 VGND VGND VPWR VPWR sky130_fd_sc_hd__decap_4
X_8604_ clknet_leaf_23_CLK _0861_ VGND VGND VPWR VPWR RF.reg_arr\[0\]\[30\] sky130_fd_sc_hd__dfxtp_1
X_6865_ _3351_ VGND VGND VPWR VPWR _0005_ sky130_fd_sc_hd__clkbuf_1
X_5816_ _2313_ _2591_ _2596_ _2051_ VGND VGND VPWR VPWR _2597_ sky130_fd_sc_hd__o2bb2a_1
X_6796_ _3314_ VGND VGND VPWR VPWR _0997_ sky130_fd_sc_hd__clkbuf_1
X_5747_ _2430_ _2423_ _2429_ _2421_ VGND VGND VPWR VPWR _2530_ sky130_fd_sc_hd__a22o_1
XFILLER_0_91_369 VGND VGND VPWR VPWR sky130_fd_sc_hd__fill_1
X_8535_ clknet_leaf_42_CLK _0792_ VGND VGND VPWR VPWR RF.reg_arr\[1\]\[25\] sky130_fd_sc_hd__dfxtp_1
XFILLER_0_17_433 VGND VGND VPWR VPWR sky130_fd_sc_hd__fill_1
XFILLER_0_115_641 VPWR VGND VPWR VGND sky130_ef_sc_hd__decap_12
X_8466_ _4216_ VGND VGND VPWR VPWR _0741_ sky130_fd_sc_hd__clkbuf_1
XFILLER_0_115_685 VGND VGND VPWR VPWR sky130_fd_sc_hd__decap_6
X_7417_ _3659_ VGND VGND VPWR VPWR _0249_ sky130_fd_sc_hd__clkbuf_1
X_5678_ _1831_ _2463_ VGND VGND VPWR VPWR _2464_ sky130_fd_sc_hd__nor2_1
X_4629_ RF.reg_arr\[28\]\[27\] RF.reg_arr\[29\]\[27\] RF.reg_arr\[30\]\[27\] RF.reg_arr\[31\]\[27\]
+ _1175_ _1176_ VGND VGND VPWR VPWR _1418_ sky130_fd_sc_hd__mux4_1
X_8397_ _4180_ VGND VGND VPWR VPWR _0708_ sky130_fd_sc_hd__clkbuf_1
XFILLER_0_32_469 VGND VGND VPWR VPWR sky130_fd_sc_hd__decap_6
Xhold540 RF.reg_arr\[13\]\[26\] VGND VGND VPWR VPWR net622 sky130_fd_sc_hd__dlygate4sd3_1
X_7348_ _3113_ net616 _3616_ VGND VGND VPWR VPWR _3623_ sky130_fd_sc_hd__mux2_1
Xclkbuf_leaf_50_CLK clknet_3_6__leaf_CLK VGND VGND VPWR VPWR clknet_leaf_50_CLK sky130_fd_sc_hd__clkbuf_8
Xhold551 RF.reg_arr\[27\]\[31\] VGND VGND VPWR VPWR net633 sky130_fd_sc_hd__dlygate4sd3_1
Xhold562 RF.reg_arr\[8\]\[5\] VGND VGND VPWR VPWR net644 sky130_fd_sc_hd__dlygate4sd3_1
Xhold584 RF.reg_arr\[3\]\[26\] VGND VGND VPWR VPWR net666 sky130_fd_sc_hd__dlygate4sd3_1
X_7279_ _3586_ VGND VGND VPWR VPWR _0184_ sky130_fd_sc_hd__clkbuf_1
XTAP_TAPCELL_ROW_9_359 VGND VPWR sky130_fd_sc_hd__tapvpwrvgnd_1
Xhold573 RF.reg_arr\[18\]\[5\] VGND VGND VPWR VPWR net655 sky130_fd_sc_hd__dlygate4sd3_1
Xhold595 RF.reg_arr\[22\]\[3\] VGND VGND VPWR VPWR net677 sky130_fd_sc_hd__dlygate4sd3_1
X_9018_ clknet_leaf_29_CLK _0251_ VGND VGND VPWR VPWR RF.reg_arr\[27\]\[28\] sky130_fd_sc_hd__dfxtp_1
XTAP_TAPCELL_ROW_56_921 VGND VPWR sky130_fd_sc_hd__tapvpwrvgnd_1
XFILLER_0_67_388 VGND VGND VPWR VPWR sky130_fd_sc_hd__decap_4
XFILLER_0_12_27 VGND VGND VPWR VPWR sky130_fd_sc_hd__fill_1
XFILLER_0_27_219 VGND VGND VPWR VPWR sky130_fd_sc_hd__fill_2
XFILLER_0_70_509 VGND VGND VPWR VPWR sky130_fd_sc_hd__fill_1
XFILLER_0_106_630 VGND VGND VPWR VPWR sky130_fd_sc_hd__fill_1
XTAP_TAPCELL_ROW_97_1411 VGND VPWR sky130_fd_sc_hd__tapvpwrvgnd_1
XFILLER_0_35_285 VGND VGND VPWR VPWR sky130_fd_sc_hd__fill_1
XFILLER_0_105_173 VGND VGND VPWR VPWR sky130_fd_sc_hd__fill_1
Xclkbuf_leaf_41_CLK clknet_3_3__leaf_CLK VGND VGND VPWR VPWR clknet_leaf_41_CLK sky130_fd_sc_hd__clkbuf_8
Xoutput60 net60 VGND VGND VPWR VPWR result[1] sky130_fd_sc_hd__clkbuf_4
Xoutput71 net71 VGND VGND VPWR VPWR result[2] sky130_fd_sc_hd__clkbuf_4
XFILLER_0_37_57 VGND VGND VPWR VPWR sky130_fd_sc_hd__fill_2
XFILLER_0_37_79 VGND VGND VPWR VPWR sky130_fd_sc_hd__fill_1
XPHY_EDGE_ROW_90_Left_207 VGND VGND VPWR VPWR sky130_fd_sc_hd__decap_3
XFILLER_0_53_45 VGND VGND VPWR VPWR sky130_fd_sc_hd__decap_8
X_4980_ RF.reg_arr\[8\]\[27\] RF.reg_arr\[9\]\[27\] RF.reg_arr\[10\]\[27\] RF.reg_arr\[11\]\[27\]
+ _1626_ _1628_ VGND VGND VPWR VPWR _1769_ sky130_fd_sc_hd__mux4_1
XFILLER_0_86_642 VGND VGND VPWR VPWR sky130_fd_sc_hd__fill_2
XTAP_TAPCELL_ROW_34_659 VGND VPWR sky130_fd_sc_hd__tapvpwrvgnd_1
XFILLER_0_73_314 VPWR VGND VPWR VGND sky130_ef_sc_hd__decap_12
X_6650_ _3065_ net764 _3232_ VGND VGND VPWR VPWR _3236_ sky130_fd_sc_hd__mux2_1
X_5601_ _2387_ _2388_ VGND VGND VPWR VPWR _2389_ sky130_fd_sc_hd__nand2_1
X_6581_ _3199_ VGND VGND VPWR VPWR _0897_ sky130_fd_sc_hd__clkbuf_1
XFILLER_0_116_449 VGND VGND VPWR VPWR sky130_fd_sc_hd__decap_3
X_5532_ _2317_ _2320_ _1616_ VGND VGND VPWR VPWR _2321_ sky130_fd_sc_hd__mux2_1
XFILLER_0_14_414 VGND VGND VPWR VPWR sky130_fd_sc_hd__decap_3
XFILLER_0_5_135 VGND VGND VPWR VPWR sky130_fd_sc_hd__decap_8
X_8320_ _3000_ net454 _4138_ VGND VGND VPWR VPWR _4140_ sky130_fd_sc_hd__mux2_1
XFILLER_0_81_380 VGND VGND VPWR VPWR sky130_fd_sc_hd__fill_1
XFILLER_0_111_110 VGND VGND VPWR VPWR sky130_fd_sc_hd__fill_2
X_5463_ _2246_ _2248_ _2251_ _1842_ _1585_ VGND VGND VPWR VPWR _2252_ sky130_fd_sc_hd__a221o_1
X_8251_ _4103_ VGND VGND VPWR VPWR _0639_ sky130_fd_sc_hd__clkbuf_1
Xclkbuf_leaf_32_CLK clknet_3_3__leaf_CLK VGND VGND VPWR VPWR clknet_leaf_32_CLK sky130_fd_sc_hd__clkbuf_8
X_7202_ _3545_ VGND VGND VPWR VPWR _0148_ sky130_fd_sc_hd__clkbuf_1
X_4414_ _1201_ _1202_ _1133_ VGND VGND VPWR VPWR _1203_ sky130_fd_sc_hd__mux2_1
X_8182_ _2994_ net554 _4066_ VGND VGND VPWR VPWR _4067_ sky130_fd_sc_hd__mux2_1
X_5394_ _2179_ _2182_ _1617_ VGND VGND VPWR VPWR _2183_ sky130_fd_sc_hd__mux2_1
X_7133_ net144 _3433_ _3507_ VGND VGND VPWR VPWR _3509_ sky130_fd_sc_hd__mux2_1
X_4345_ _1051_ VGND VGND VPWR VPWR _1134_ sky130_fd_sc_hd__buf_8
XTAP_TAPCELL_ROW_6_329 VGND VPWR sky130_fd_sc_hd__tapvpwrvgnd_1
XTAP_TAPCELL_ROW_6_318 VGND VPWR sky130_fd_sc_hd__tapvpwrvgnd_1
XFILLER_0_94_41 VPWR VGND VPWR VGND sky130_ef_sc_hd__decap_12
X_7064_ _3472_ VGND VGND VPWR VPWR _0083_ sky130_fd_sc_hd__clkbuf_1
X_4276_ _1025_ _1040_ _1064_ VGND VGND VPWR VPWR _1065_ sky130_fd_sc_hd__o21ai_4
X_6015_ _2754_ _2783_ _2000_ VGND VGND VPWR VPWR _2784_ sky130_fd_sc_hd__mux2_1
X_7966_ _2984_ net223 _3944_ VGND VGND VPWR VPWR _3952_ sky130_fd_sc_hd__mux2_1
XTAP_TAPCELL_ROW_68_1067 VGND VPWR sky130_fd_sc_hd__tapvpwrvgnd_1
Xclkbuf_leaf_99_CLK clknet_3_4__leaf_CLK VGND VGND VPWR VPWR clknet_leaf_99_CLK sky130_fd_sc_hd__clkbuf_8
X_7897_ _3915_ VGND VGND VPWR VPWR _0473_ sky130_fd_sc_hd__clkbuf_1
X_6917_ net35 VGND VGND VPWR VPWR _3381_ sky130_fd_sc_hd__buf_2
XTAP_TAPCELL_ROW_81_1223 VGND VPWR sky130_fd_sc_hd__tapvpwrvgnd_1
XFILLER_0_76_141 VGND VGND VPWR VPWR sky130_fd_sc_hd__decap_3
X_6848_ _3341_ VGND VGND VPWR VPWR _1022_ sky130_fd_sc_hd__clkbuf_1
XFILLER_0_64_336 VGND VGND VPWR VPWR sky130_fd_sc_hd__fill_2
X_6779_ _3304_ VGND VGND VPWR VPWR _0990_ sky130_fd_sc_hd__clkbuf_1
X_8518_ clknet_leaf_87_CLK _0775_ VGND VGND VPWR VPWR RF.reg_arr\[1\]\[8\] sky130_fd_sc_hd__dfxtp_1
XFILLER_0_45_572 VGND VGND VPWR VPWR sky130_fd_sc_hd__fill_1
X_9498_ clknet_leaf_28_CLK _0731_ VGND VGND VPWR VPWR RF.reg_arr\[11\]\[28\] sky130_fd_sc_hd__dfxtp_1
XFILLER_0_60_531 VGND VGND VPWR VPWR sky130_fd_sc_hd__fill_1
XFILLER_0_103_611 VGND VGND VPWR VPWR sky130_fd_sc_hd__fill_2
X_8449_ _4207_ VGND VGND VPWR VPWR _0733_ sky130_fd_sc_hd__clkbuf_1
XFILLER_0_5_691 VGND VGND VPWR VPWR sky130_fd_sc_hd__fill_1
Xclkbuf_leaf_23_CLK clknet_3_2__leaf_CLK VGND VGND VPWR VPWR clknet_leaf_23_CLK sky130_fd_sc_hd__clkbuf_8
XTAP_TAPCELL_ROW_79_1196 VGND VPWR sky130_fd_sc_hd__tapvpwrvgnd_1
XFILLER_0_20_417 VGND VGND VPWR VPWR sky130_fd_sc_hd__decap_3
Xhold381 RF.reg_arr\[24\]\[24\] VGND VGND VPWR VPWR net463 sky130_fd_sc_hd__dlygate4sd3_1
XFILLER_0_102_165 VGND VGND VPWR VPWR sky130_fd_sc_hd__decap_4
XTAP_TAPCELL_ROW_92_1352 VGND VPWR sky130_fd_sc_hd__tapvpwrvgnd_1
Xhold370 RF.reg_arr\[8\]\[16\] VGND VGND VPWR VPWR net452 sky130_fd_sc_hd__dlygate4sd3_1
Xhold392 RF.reg_arr\[18\]\[27\] VGND VGND VPWR VPWR net474 sky130_fd_sc_hd__dlygate4sd3_1
XFILLER_0_99_222 VGND VGND VPWR VPWR sky130_fd_sc_hd__fill_2
XFILLER_0_82_111 VGND VGND VPWR VPWR sky130_fd_sc_hd__fill_2
XFILLER_0_83_667 VGND VGND VPWR VPWR sky130_fd_sc_hd__decap_4
XTAP_TAPCELL_ROW_31_618 VGND VPWR sky130_fd_sc_hd__tapvpwrvgnd_1
XTAP_TAPCELL_ROW_31_629 VGND VPWR sky130_fd_sc_hd__tapvpwrvgnd_1
Xrebuffer4 _1446_ VGND VGND VPWR VPWR net86 sky130_fd_sc_hd__dlygate4sd1_1
XFILLER_0_3_617 VGND VGND VPWR VPWR sky130_fd_sc_hd__decap_4
XFILLER_0_36_583 VGND VGND VPWR VPWR sky130_fd_sc_hd__decap_4
XTAP_TAPCELL_ROW_11_386 VGND VPWR sky130_fd_sc_hd__tapvpwrvgnd_1
XFILLER_0_2_138 VGND VGND VPWR VPWR sky130_fd_sc_hd__fill_2
Xclkbuf_leaf_14_CLK clknet_3_3__leaf_CLK VGND VGND VPWR VPWR clknet_leaf_14_CLK sky130_fd_sc_hd__clkbuf_8
XFILLER_0_48_67 VGND VGND VPWR VPWR sky130_fd_sc_hd__fill_1
XTAP_TAPCELL_ROW_39_718 VGND VPWR sky130_fd_sc_hd__tapvpwrvgnd_1
XFILLER_0_78_406 VGND VGND VPWR VPWR sky130_fd_sc_hd__decap_6
X_7820_ _3874_ VGND VGND VPWR VPWR _0437_ sky130_fd_sc_hd__clkbuf_1
X_4963_ _1637_ _1751_ _1644_ VGND VGND VPWR VPWR _1752_ sky130_fd_sc_hd__o21ai_1
XFILLER_0_74_601 VGND VGND VPWR VPWR sky130_fd_sc_hd__fill_1
X_7751_ net131 _3435_ _3835_ VGND VGND VPWR VPWR _3838_ sky130_fd_sc_hd__mux2_1
XFILLER_0_59_642 VGND VGND VPWR VPWR sky130_fd_sc_hd__fill_1
XTAP_TAPCELL_ROW_19_475 VGND VPWR sky130_fd_sc_hd__tapvpwrvgnd_1
X_6702_ _3117_ net571 _3254_ VGND VGND VPWR VPWR _3263_ sky130_fd_sc_hd__mux2_1
X_7682_ _3801_ VGND VGND VPWR VPWR _0372_ sky130_fd_sc_hd__clkbuf_1
XFILLER_0_74_623 VGND VGND VPWR VPWR sky130_fd_sc_hd__fill_1
X_6633_ _3226_ VGND VGND VPWR VPWR _0922_ sky130_fd_sc_hd__clkbuf_1
X_4894_ _1682_ VGND VGND VPWR VPWR _1683_ sky130_fd_sc_hd__clkbuf_4
XFILLER_0_74_645 VGND VGND VPWR VPWR sky130_fd_sc_hd__decap_3
XFILLER_0_73_122 VGND VGND VPWR VPWR sky130_fd_sc_hd__decap_4
X_9421_ clknet_leaf_105_CLK _0654_ VGND VGND VPWR VPWR RF.reg_arr\[17\]\[15\] sky130_fd_sc_hd__dfxtp_1
XFILLER_0_46_336 VGND VGND VPWR VPWR sky130_fd_sc_hd__decap_3
XFILLER_0_46_358 VGND VGND VPWR VPWR sky130_fd_sc_hd__decap_6
XFILLER_0_104_83 VGND VGND VPWR VPWR sky130_fd_sc_hd__fill_1
XFILLER_0_13_81 VGND VGND VPWR VPWR sky130_fd_sc_hd__fill_1
X_6564_ net860 _2984_ _3182_ VGND VGND VPWR VPWR _3190_ sky130_fd_sc_hd__mux2_1
XFILLER_0_89_52 VGND VGND VPWR VPWR sky130_fd_sc_hd__fill_1
XFILLER_0_6_466 VGND VGND VPWR VPWR sky130_fd_sc_hd__fill_1
XFILLER_0_6_455 VGND VGND VPWR VPWR sky130_fd_sc_hd__decap_3
X_9352_ clknet_leaf_11_CLK _0585_ VGND VGND VPWR VPWR RF.reg_arr\[18\]\[10\] sky130_fd_sc_hd__dfxtp_1
X_6495_ _3152_ VGND VGND VPWR VPWR _0858_ sky130_fd_sc_hd__clkbuf_1
X_8303_ _4130_ VGND VGND VPWR VPWR _0664_ sky130_fd_sc_hd__clkbuf_1
X_5515_ _1617_ _2303_ VGND VGND VPWR VPWR _2304_ sky130_fd_sc_hd__nor2_1
X_9283_ clknet_leaf_73_CLK _0516_ VGND VGND VPWR VPWR RF.reg_arr\[25\]\[5\] sky130_fd_sc_hd__dfxtp_1
XFILLER_0_42_553 VGND VGND VPWR VPWR sky130_fd_sc_hd__fill_1
XTAP_TAPCELL_ROW_115_1628 VGND VPWR sky130_fd_sc_hd__tapvpwrvgnd_1
XFILLER_0_89_96 VGND VGND VPWR VPWR sky130_fd_sc_hd__decap_6
X_8234_ _2980_ net216 _4088_ VGND VGND VPWR VPWR _4094_ sky130_fd_sc_hd__mux2_1
X_5446_ _1584_ _2234_ VGND VGND VPWR VPWR _2235_ sky130_fd_sc_hd__or2_1
XFILLER_0_73_3 VGND VGND VPWR VPWR sky130_fd_sc_hd__decap_6
XFILLER_0_100_614 VGND VGND VPWR VPWR sky130_fd_sc_hd__decap_3
X_8165_ _4057_ VGND VGND VPWR VPWR _0599_ sky130_fd_sc_hd__clkbuf_1
XFILLER_0_100_636 VGND VGND VPWR VPWR sky130_fd_sc_hd__decap_8
X_5377_ _2162_ _2165_ _1634_ VGND VGND VPWR VPWR _2166_ sky130_fd_sc_hd__mux2_1
X_8096_ _2970_ net806 _4016_ VGND VGND VPWR VPWR _4021_ sky130_fd_sc_hd__mux2_1
X_4328_ _1027_ VGND VGND VPWR VPWR _1117_ sky130_fd_sc_hd__clkbuf_8
XFILLER_0_10_494 VGND VGND VPWR VPWR sky130_fd_sc_hd__decap_4
X_7116_ net414 _3416_ _3496_ VGND VGND VPWR VPWR _3500_ sky130_fd_sc_hd__mux2_1
X_7047_ _3463_ VGND VGND VPWR VPWR _0075_ sky130_fd_sc_hd__clkbuf_1
X_4259_ _1042_ _1047_ VGND VGND VPWR VPWR _1048_ sky130_fd_sc_hd__or2_1
X_8998_ clknet_leaf_82_CLK _0231_ VGND VGND VPWR VPWR RF.reg_arr\[27\]\[8\] sky130_fd_sc_hd__dfxtp_1
X_7949_ _3037_ net1058 _3933_ VGND VGND VPWR VPWR _3943_ sky130_fd_sc_hd__mux2_1
XFILLER_0_49_163 VGND VGND VPWR VPWR sky130_fd_sc_hd__fill_2
XFILLER_0_92_475 VGND VGND VPWR VPWR sky130_fd_sc_hd__fill_1
XFILLER_0_20_225 VGND VGND VPWR VPWR sky130_fd_sc_hd__decap_4
XFILLER_0_87_225 VGND VGND VPWR VPWR sky130_fd_sc_hd__fill_1
Xclkbuf_leaf_3_CLK clknet_3_0__leaf_CLK VGND VGND VPWR VPWR clknet_leaf_3_CLK sky130_fd_sc_hd__clkbuf_8
XTAP_TAPCELL_ROW_16_445 VGND VPWR sky130_fd_sc_hd__tapvpwrvgnd_1
XTAP_TAPCELL_ROW_44_776 VGND VPWR sky130_fd_sc_hd__tapvpwrvgnd_1
XFILLER_0_56_645 VGND VGND VPWR VPWR sky130_fd_sc_hd__decap_4
XFILLER_0_55_166 VGND VGND VPWR VPWR sky130_fd_sc_hd__fill_2
XFILLER_0_59_22 VGND VGND VPWR VPWR sky130_fd_sc_hd__fill_2
X_5300_ RF.reg_arr\[28\]\[8\] RF.reg_arr\[29\]\[8\] RF.reg_arr\[30\]\[8\] RF.reg_arr\[31\]\[8\]
+ _2087_ _1859_ VGND VGND VPWR VPWR _2089_ sky130_fd_sc_hd__mux4_1
XFILLER_0_3_447 VGND VGND VPWR VPWR sky130_fd_sc_hd__fill_1
XFILLER_0_11_225 VGND VGND VPWR VPWR sky130_fd_sc_hd__decap_8
X_6280_ _2997_ VGND VGND VPWR VPWR _3019_ sky130_fd_sc_hd__clkbuf_8
X_5231_ _1061_ _2019_ net8 VGND VGND VPWR VPWR _2020_ sky130_fd_sc_hd__a21oi_2
XFILLER_0_75_21 VGND VGND VPWR VPWR sky130_fd_sc_hd__fill_1
X_5162_ _1949_ _1950_ _1942_ VGND VGND VPWR VPWR _1951_ sky130_fd_sc_hd__mux2_1
XTAP_TAPCELL_ROW_110_1569 VGND VPWR sky130_fd_sc_hd__tapvpwrvgnd_1
X_5093_ _1854_ _1881_ _1842_ VGND VGND VPWR VPWR _1882_ sky130_fd_sc_hd__o21a_1
X_8921_ clknet_leaf_49_CLK _0154_ VGND VGND VPWR VPWR RF.reg_arr\[7\]\[27\] sky130_fd_sc_hd__dfxtp_1
X_8852_ clknet_leaf_62_CLK _0085_ VGND VGND VPWR VPWR RF.reg_arr\[19\]\[22\] sky130_fd_sc_hd__dfxtp_1
XTAP_TAPCELL_ROW_65_1037 VGND VPWR sky130_fd_sc_hd__tapvpwrvgnd_1
XTAP_TAPCELL_ROW_65_1026 VGND VPWR sky130_fd_sc_hd__tapvpwrvgnd_1
X_7803_ _3865_ VGND VGND VPWR VPWR _0429_ sky130_fd_sc_hd__clkbuf_1
X_8783_ clknet_leaf_1_CLK _0016_ VGND VGND VPWR VPWR RF.reg_arr\[5\]\[17\] sky130_fd_sc_hd__dfxtp_1
X_5995_ _2727_ _2741_ _2736_ VGND VGND VPWR VPWR _2766_ sky130_fd_sc_hd__or3b_1
X_7734_ net228 _3418_ _3824_ VGND VGND VPWR VPWR _3829_ sky130_fd_sc_hd__mux2_1
XFILLER_0_74_442 VGND VGND VPWR VPWR sky130_fd_sc_hd__fill_2
X_4946_ _1039_ _1734_ _1063_ VGND VGND VPWR VPWR _1735_ sky130_fd_sc_hd__a21oi_2
X_4877_ _1115_ _1647_ _1665_ VGND VGND VPWR VPWR _1666_ sky130_fd_sc_hd__o21ai_1
X_7665_ _3792_ VGND VGND VPWR VPWR _0364_ sky130_fd_sc_hd__clkbuf_1
XFILLER_0_46_144 VGND VGND VPWR VPWR sky130_fd_sc_hd__fill_2
X_9404_ clknet_leaf_17_CLK _0637_ VGND VGND VPWR VPWR RF.reg_arr\[13\]\[30\] sky130_fd_sc_hd__dfxtp_1
X_7596_ net724 _3416_ _3752_ VGND VGND VPWR VPWR _3756_ sky130_fd_sc_hd__mux2_1
X_6616_ _3217_ VGND VGND VPWR VPWR _0914_ sky130_fd_sc_hd__clkbuf_1
X_9335_ clknet_leaf_40_CLK _0568_ VGND VGND VPWR VPWR RF.reg_arr\[20\]\[25\] sky130_fd_sc_hd__dfxtp_1
XFILLER_0_6_274 VGND VGND VPWR VPWR sky130_fd_sc_hd__fill_1
XFILLER_0_15_542 VGND VGND VPWR VPWR sky130_fd_sc_hd__fill_1
XFILLER_0_27_391 VGND VGND VPWR VPWR sky130_fd_sc_hd__fill_1
X_6547_ net896 _3037_ _3171_ VGND VGND VPWR VPWR _3181_ sky130_fd_sc_hd__mux2_1
XTAP_TAPCELL_ROW_76_1166 VGND VPWR sky130_fd_sc_hd__tapvpwrvgnd_1
X_9266_ clknet_leaf_16_CLK _0499_ VGND VGND VPWR VPWR RF.reg_arr\[21\]\[20\] sky130_fd_sc_hd__dfxtp_1
XFILLER_0_30_556 VGND VGND VPWR VPWR sky130_fd_sc_hd__decap_8
X_6478_ net118 VGND VGND VPWR VPWR _3144_ sky130_fd_sc_hd__clkbuf_1
X_5429_ _1756_ _2217_ VGND VGND VPWR VPWR _2218_ sky130_fd_sc_hd__nor2_1
X_8217_ _3033_ net417 _4077_ VGND VGND VPWR VPWR _4085_ sky130_fd_sc_hd__mux2_1
X_9197_ clknet_leaf_105_CLK _0430_ VGND VGND VPWR VPWR RF.reg_arr\[24\]\[15\] sky130_fd_sc_hd__dfxtp_1
XFILLER_0_30_589 VGND VGND VPWR VPWR sky130_fd_sc_hd__fill_2
XFILLER_0_100_477 VGND VGND VPWR VPWR sky130_fd_sc_hd__fill_2
X_8148_ _4048_ VGND VGND VPWR VPWR _0591_ sky130_fd_sc_hd__clkbuf_1
XFILLER_0_100_499 VGND VGND VPWR VPWR sky130_fd_sc_hd__decap_8
X_8079_ _3031_ net928 _4005_ VGND VGND VPWR VPWR _4012_ sky130_fd_sc_hd__mux2_1
XFILLER_0_97_534 VGND VGND VPWR VPWR sky130_fd_sc_hd__decap_8
XTAP_TAPCELL_ROW_87_1295 VGND VPWR sky130_fd_sc_hd__tapvpwrvgnd_1
XFILLER_0_69_258 VGND VGND VPWR VPWR sky130_fd_sc_hd__decap_8
XTAP_TAPCELL_ROW_13_404 VGND VPWR sky130_fd_sc_hd__tapvpwrvgnd_1
XFILLER_0_108_533 VPWR VGND VPWR VGND sky130_ef_sc_hd__decap_12
XFILLER_0_80_401 VGND VGND VPWR VPWR sky130_fd_sc_hd__fill_1
XFILLER_0_38_667 VGND VGND VPWR VPWR sky130_fd_sc_hd__fill_2
XTAP_TAPCELL_ROW_41_746 VGND VPWR sky130_fd_sc_hd__tapvpwrvgnd_1
XFILLER_0_53_615 VGND VGND VPWR VPWR sky130_fd_sc_hd__fill_1
XFILLER_0_61_670 VGND VGND VPWR VPWR sky130_fd_sc_hd__fill_2
XFILLER_0_21_578 VGND VGND VPWR VPWR sky130_fd_sc_hd__decap_3
XTAP_TAPCELL_ROW_49_835 VGND VPWR sky130_fd_sc_hd__tapvpwrvgnd_1
XFILLER_0_88_512 VGND VGND VPWR VPWR sky130_fd_sc_hd__decap_3
XFILLER_0_0_15 VPWR VGND VPWR VGND sky130_ef_sc_hd__decap_12
X_4800_ _1588_ VGND VGND VPWR VPWR _1589_ sky130_fd_sc_hd__buf_4
X_5780_ _2003_ _2474_ _2561_ VGND VGND VPWR VPWR _2562_ sky130_fd_sc_hd__o21ai_1
XFILLER_0_68_291 VGND VGND VPWR VPWR sky130_fd_sc_hd__decap_6
XFILLER_0_68_280 VGND VGND VPWR VPWR sky130_fd_sc_hd__decap_8
XFILLER_0_28_111 VGND VGND VPWR VPWR sky130_fd_sc_hd__decap_4
X_4731_ _1518_ _1519_ _1121_ VGND VGND VPWR VPWR _1520_ sky130_fd_sc_hd__mux2_1
X_4662_ _1176_ VGND VGND VPWR VPWR _1451_ sky130_fd_sc_hd__clkbuf_4
X_7450_ _3677_ VGND VGND VPWR VPWR _0264_ sky130_fd_sc_hd__clkbuf_1
XFILLER_0_3_200 VGND VGND VPWR VPWR sky130_fd_sc_hd__decap_3
X_6401_ _3098_ net1111 _3080_ VGND VGND VPWR VPWR _3099_ sky130_fd_sc_hd__mux2_1
X_4593_ _1158_ _1381_ _1141_ VGND VGND VPWR VPWR _1382_ sky130_fd_sc_hd__a21oi_1
X_7381_ _3640_ VGND VGND VPWR VPWR _0232_ sky130_fd_sc_hd__clkbuf_1
Xhold903 RF.reg_arr\[20\]\[3\] VGND VGND VPWR VPWR net985 sky130_fd_sc_hd__dlygate4sd3_1
XFILLER_0_43_169 VGND VGND VPWR VPWR sky130_fd_sc_hd__decap_8
XFILLER_0_52_681 VGND VGND VPWR VPWR sky130_fd_sc_hd__decap_3
X_9120_ clknet_leaf_68_CLK _0353_ VGND VGND VPWR VPWR RF.reg_arr\[30\]\[2\] sky130_fd_sc_hd__dfxtp_1
X_6332_ _3052_ VGND VGND VPWR VPWR _0795_ sky130_fd_sc_hd__clkbuf_1
Xhold936 RF.reg_arr\[21\]\[17\] VGND VGND VPWR VPWR net1018 sky130_fd_sc_hd__dlygate4sd3_1
Xhold925 RF.reg_arr\[20\]\[6\] VGND VGND VPWR VPWR net1007 sky130_fd_sc_hd__dlygate4sd3_1
Xhold914 RF.reg_arr\[10\]\[15\] VGND VGND VPWR VPWR net996 sky130_fd_sc_hd__dlygate4sd3_1
X_9051_ clknet_leaf_29_CLK _0284_ VGND VGND VPWR VPWR RF.reg_arr\[26\]\[29\] sky130_fd_sc_hd__dfxtp_1
Xhold969 RF.reg_arr\[24\]\[28\] VGND VGND VPWR VPWR net1051 sky130_fd_sc_hd__dlygate4sd3_1
XFILLER_0_12_589 VGND VGND VPWR VPWR sky130_fd_sc_hd__decap_4
Xhold958 RF.reg_arr\[28\]\[7\] VGND VGND VPWR VPWR net1040 sky130_fd_sc_hd__dlygate4sd3_1
X_6263_ _3007_ VGND VGND VPWR VPWR _0771_ sky130_fd_sc_hd__clkbuf_1
Xhold947 RF.reg_arr\[2\]\[19\] VGND VGND VPWR VPWR net1029 sky130_fd_sc_hd__dlygate4sd3_1
X_5214_ _1830_ VGND VGND VPWR VPWR _2003_ sky130_fd_sc_hd__clkbuf_4
XFILLER_0_86_64 VGND VGND VPWR VPWR sky130_fd_sc_hd__decap_6
X_8002_ _3971_ VGND VGND VPWR VPWR _0522_ sky130_fd_sc_hd__clkbuf_1
X_6194_ _1293_ _1315_ _2913_ _2759_ VGND VGND VPWR VPWR _2953_ sky130_fd_sc_hd__a31o_1
XFILLER_0_86_97 VGND VGND VPWR VPWR sky130_fd_sc_hd__fill_1
X_5145_ RF.reg_arr\[24\]\[18\] RF.reg_arr\[25\]\[18\] RF.reg_arr\[26\]\[18\] RF.reg_arr\[27\]\[18\]
+ _1884_ _1886_ VGND VGND VPWR VPWR _1934_ sky130_fd_sc_hd__mux4_1
XFILLER_0_98_309 VGND VGND VPWR VPWR sky130_fd_sc_hd__fill_2
X_5076_ _1864_ VGND VGND VPWR VPWR _1865_ sky130_fd_sc_hd__clkbuf_8
X_8904_ clknet_leaf_63_CLK _0137_ VGND VGND VPWR VPWR RF.reg_arr\[7\]\[10\] sky130_fd_sc_hd__dfxtp_1
XFILLER_0_79_567 VGND VGND VPWR VPWR sky130_fd_sc_hd__decap_4
XFILLER_0_94_504 VGND VGND VPWR VPWR sky130_fd_sc_hd__decap_8
X_8835_ clknet_leaf_73_CLK _0068_ VGND VGND VPWR VPWR RF.reg_arr\[19\]\[5\] sky130_fd_sc_hd__dfxtp_1
X_5978_ _2386_ _2746_ _2749_ _2381_ VGND VGND VPWR VPWR _2750_ sky130_fd_sc_hd__o22a_1
X_8766_ clknet_leaf_66_CLK _1023_ VGND VGND VPWR VPWR RF.reg_arr\[5\]\[0\] sky130_fd_sc_hd__dfxtp_1
X_4929_ _1700_ _1717_ VGND VGND VPWR VPWR _1718_ sky130_fd_sc_hd__or2_1
X_8697_ clknet_leaf_36_CLK _0954_ VGND VGND VPWR VPWR RF.reg_arr\[15\]\[27\] sky130_fd_sc_hd__dfxtp_1
XFILLER_0_74_250 VGND VGND VPWR VPWR sky130_fd_sc_hd__fill_2
X_7717_ net647 _3401_ _3813_ VGND VGND VPWR VPWR _3820_ sky130_fd_sc_hd__mux2_1
X_7648_ _3783_ VGND VGND VPWR VPWR _0356_ sky130_fd_sc_hd__clkbuf_1
XFILLER_0_34_125 VGND VGND VPWR VPWR sky130_fd_sc_hd__fill_1
XFILLER_0_105_503 VGND VGND VPWR VPWR sky130_fd_sc_hd__fill_1
XFILLER_0_7_561 VGND VGND VPWR VPWR sky130_fd_sc_hd__decap_3
XFILLER_0_105_569 VGND VGND VPWR VPWR sky130_fd_sc_hd__fill_2
XFILLER_0_15_372 VGND VGND VPWR VPWR sky130_fd_sc_hd__decap_4
X_7579_ net596 _3399_ _3741_ VGND VGND VPWR VPWR _3747_ sky130_fd_sc_hd__mux2_1
XFILLER_0_50_618 VGND VGND VPWR VPWR sky130_fd_sc_hd__fill_2
X_9318_ clknet_leaf_78_CLK _0551_ VGND VGND VPWR VPWR RF.reg_arr\[20\]\[8\] sky130_fd_sc_hd__dfxtp_1
XFILLER_0_42_180 VGND VGND VPWR VPWR sky130_fd_sc_hd__decap_3
X_9249_ clknet_leaf_69_CLK _0482_ VGND VGND VPWR VPWR RF.reg_arr\[21\]\[3\] sky130_fd_sc_hd__dfxtp_1
XTAP_TAPCELL_ROW_89_1324 VGND VPWR sky130_fd_sc_hd__tapvpwrvgnd_1
XTAP_TAPCELL_ROW_46_805 VGND VPWR sky130_fd_sc_hd__tapvpwrvgnd_1
XTAP_TAPCELL_ROW_26_562 VGND VPWR sky130_fd_sc_hd__tapvpwrvgnd_1
XFILLER_0_31_15 VGND VGND VPWR VPWR sky130_fd_sc_hd__decap_4
XFILLER_0_26_648 VGND VGND VPWR VPWR sky130_fd_sc_hd__fill_2
XFILLER_0_40_139 VGND VGND VPWR VPWR sky130_fd_sc_hd__fill_1
X_6950_ net320 _3403_ _3389_ VGND VGND VPWR VPWR _3404_ sky130_fd_sc_hd__mux2_1
XTAP_TAPCELL_ROW_109_1560 VGND VPWR sky130_fd_sc_hd__tapvpwrvgnd_1
XFILLER_0_88_331 VGND VGND VPWR VPWR sky130_fd_sc_hd__fill_1
X_5901_ _2388_ _2397_ VGND VGND VPWR VPWR _2677_ sky130_fd_sc_hd__nand2_1
X_6881_ net544 _3027_ _3355_ VGND VGND VPWR VPWR _3360_ sky130_fd_sc_hd__mux2_1
X_5832_ _2572_ _2581_ VGND VGND VPWR VPWR _2612_ sky130_fd_sc_hd__nor2_1
X_8620_ clknet_leaf_99_CLK _0877_ VGND VGND VPWR VPWR RF.reg_arr\[16\]\[14\] sky130_fd_sc_hd__dfxtp_1
X_5763_ _2526_ _2532_ _2545_ _2446_ VGND VGND VPWR VPWR net77 sky130_fd_sc_hd__o22a_1
X_8551_ clknet_leaf_77_CLK _0808_ VGND VGND VPWR VPWR RF.reg_arr\[23\]\[9\] sky130_fd_sc_hd__dfxtp_1
XFILLER_0_29_453 VGND VGND VPWR VPWR sky130_fd_sc_hd__fill_1
XPHY_EDGE_ROW_101_Left_218 VGND VGND VPWR VPWR sky130_fd_sc_hd__decap_3
X_7502_ _3706_ VGND VGND VPWR VPWR _0287_ sky130_fd_sc_hd__clkbuf_1
X_4714_ RF.reg_arr\[20\]\[13\] RF.reg_arr\[21\]\[13\] RF.reg_arr\[22\]\[13\] RF.reg_arr\[23\]\[13\]
+ _1342_ _1343_ VGND VGND VPWR VPWR _1503_ sky130_fd_sc_hd__mux4_1
X_5694_ _2392_ _2404_ _2000_ VGND VGND VPWR VPWR _2480_ sky130_fd_sc_hd__mux2_1
X_8482_ net351 net19 _4222_ VGND VGND VPWR VPWR _4225_ sky130_fd_sc_hd__mux2_1
X_4645_ RF.reg_arr\[16\]\[26\] RF.reg_arr\[17\]\[26\] RF.reg_arr\[18\]\[26\] RF.reg_arr\[19\]\[26\]
+ _1316_ _1304_ VGND VGND VPWR VPWR _1434_ sky130_fd_sc_hd__mux4_1
X_7433_ _3061_ net643 _3667_ VGND VGND VPWR VPWR _3669_ sky130_fd_sc_hd__mux2_1
XFILLER_0_4_531 VGND VGND VPWR VPWR sky130_fd_sc_hd__fill_1
XFILLER_0_114_355 VGND VGND VPWR VPWR sky130_fd_sc_hd__fill_1
XFILLER_0_102_517 VPWR VGND VPWR VGND sky130_ef_sc_hd__decap_12
X_4576_ _1363_ _1364_ _1042_ VGND VGND VPWR VPWR _1365_ sky130_fd_sc_hd__mux2_1
X_7364_ _3061_ net1014 _3630_ VGND VGND VPWR VPWR _3632_ sky130_fd_sc_hd__mux2_1
Xhold711 RF.reg_arr\[23\]\[10\] VGND VGND VPWR VPWR net793 sky130_fd_sc_hd__dlygate4sd3_1
Xhold700 RF.reg_arr\[27\]\[10\] VGND VGND VPWR VPWR net782 sky130_fd_sc_hd__dlygate4sd3_1
Xhold744 RF.reg_arr\[14\]\[28\] VGND VGND VPWR VPWR net826 sky130_fd_sc_hd__dlygate4sd3_1
XFILLER_0_97_52 VGND VGND VPWR VPWR sky130_fd_sc_hd__decap_4
X_6315_ net569 _3042_ _3040_ VGND VGND VPWR VPWR _3043_ sky130_fd_sc_hd__mux2_1
Xhold722 RF.reg_arr\[26\]\[4\] VGND VGND VPWR VPWR net804 sky130_fd_sc_hd__dlygate4sd3_1
Xhold733 RF.reg_arr\[30\]\[8\] VGND VGND VPWR VPWR net815 sky130_fd_sc_hd__dlygate4sd3_1
X_9103_ clknet_leaf_1_CLK _0336_ VGND VGND VPWR VPWR RF.reg_arr\[2\]\[17\] sky130_fd_sc_hd__dfxtp_1
XFILLER_0_24_191 VGND VGND VPWR VPWR sky130_fd_sc_hd__decap_4
Xhold755 RF.reg_arr\[17\]\[5\] VGND VGND VPWR VPWR net837 sky130_fd_sc_hd__dlygate4sd3_1
Xhold788 RF.reg_arr\[21\]\[24\] VGND VGND VPWR VPWR net870 sky130_fd_sc_hd__dlygate4sd3_1
XTAP_TAPCELL_ROW_73_1125 VGND VPWR sky130_fd_sc_hd__tapvpwrvgnd_1
Xhold766 RF.reg_arr\[20\]\[9\] VGND VGND VPWR VPWR net848 sky130_fd_sc_hd__dlygate4sd3_1
X_9034_ clknet_leaf_100_CLK _0267_ VGND VGND VPWR VPWR RF.reg_arr\[26\]\[12\] sky130_fd_sc_hd__dfxtp_1
Xhold777 RF.reg_arr\[23\]\[12\] VGND VGND VPWR VPWR net859 sky130_fd_sc_hd__dlygate4sd3_1
X_7295_ _3595_ VGND VGND VPWR VPWR _0191_ sky130_fd_sc_hd__clkbuf_1
XPHY_EDGE_ROW_110_Left_227 VGND VGND VPWR VPWR sky130_fd_sc_hd__decap_3
X_6246_ _2972_ _2975_ _2973_ VGND VGND VPWR VPWR _2995_ sky130_fd_sc_hd__nor3_1
Xhold799 RF.reg_arr\[28\]\[0\] VGND VGND VPWR VPWR net881 sky130_fd_sc_hd__dlygate4sd3_1
X_6177_ _1696_ _2936_ VGND VGND VPWR VPWR _2937_ sky130_fd_sc_hd__nor2_1
XFILLER_0_99_629 VGND VGND VPWR VPWR sky130_fd_sc_hd__fill_2
X_5128_ _1913_ _1914_ _1915_ _1916_ _1612_ _1845_ VGND VGND VPWR VPWR _1917_ sky130_fd_sc_hd__mux4_1
X_5059_ _1847_ VGND VGND VPWR VPWR _1848_ sky130_fd_sc_hd__buf_4
XFILLER_0_94_323 VGND VGND VPWR VPWR sky130_fd_sc_hd__decap_4
XFILLER_0_94_312 VGND VGND VPWR VPWR sky130_fd_sc_hd__fill_2
XTAP_TAPCELL_ROW_84_1265 VGND VPWR sky130_fd_sc_hd__tapvpwrvgnd_1
XTAP_TAPCELL_ROW_84_1254 VGND VPWR sky130_fd_sc_hd__tapvpwrvgnd_1
X_8818_ clknet_leaf_43_CLK _0051_ VGND VGND VPWR VPWR RF.reg_arr\[4\]\[20\] sky130_fd_sc_hd__dfxtp_1
XTAP_TAPCELL_ROW_23_532 VGND VPWR sky130_fd_sc_hd__tapvpwrvgnd_1
XFILLER_0_75_581 VGND VGND VPWR VPWR sky130_fd_sc_hd__decap_3
X_8749_ clknet_leaf_2_CLK _1006_ VGND VGND VPWR VPWR RF.reg_arr\[6\]\[15\] sky130_fd_sc_hd__dfxtp_1
XTAP_TAPCELL_ROW_51_863 VGND VPWR sky130_fd_sc_hd__tapvpwrvgnd_1
XPHY_EDGE_ROW_109_Right_109 VGND VGND VPWR VPWR sky130_fd_sc_hd__decap_3
XFILLER_0_7_391 VGND VGND VPWR VPWR sky130_fd_sc_hd__fill_1
XFILLER_0_22_139 VGND VGND VPWR VPWR sky130_fd_sc_hd__fill_1
XFILLER_0_31_673 VGND VGND VPWR VPWR sky130_fd_sc_hd__decap_3
XTAP_TAPCELL_ROW_95_1394 VGND VPWR sky130_fd_sc_hd__tapvpwrvgnd_1
XFILLER_0_101_561 VGND VGND VPWR VPWR sky130_fd_sc_hd__decap_8
Xhold82 RF.reg_arr\[1\]\[24\] VGND VGND VPWR VPWR net164 sky130_fd_sc_hd__dlygate4sd3_1
Xhold71 RF.reg_arr\[18\]\[21\] VGND VGND VPWR VPWR net153 sky130_fd_sc_hd__dlygate4sd3_1
XTAP_TAPCELL_ROW_59_963 VGND VPWR sky130_fd_sc_hd__tapvpwrvgnd_1
Xhold60 RF.reg_arr\[1\]\[16\] VGND VGND VPWR VPWR net142 sky130_fd_sc_hd__dlygate4sd3_1
Xhold93 RF.reg_arr\[3\]\[14\] VGND VGND VPWR VPWR net175 sky130_fd_sc_hd__dlygate4sd3_1
XTAP_TAPCELL_ROW_3_290 VGND VPWR sky130_fd_sc_hd__tapvpwrvgnd_1
XFILLER_0_85_345 VGND VGND VPWR VPWR sky130_fd_sc_hd__fill_2
XFILLER_0_85_334 VGND VGND VPWR VPWR sky130_fd_sc_hd__fill_2
XFILLER_0_14_607 VGND VGND VPWR VPWR sky130_fd_sc_hd__fill_1
XFILLER_0_53_275 VGND VGND VPWR VPWR sky130_fd_sc_hd__fill_2
XFILLER_0_81_595 VGND VGND VPWR VPWR sky130_fd_sc_hd__fill_1
X_4430_ RF.reg_arr\[4\]\[8\] RF.reg_arr\[5\]\[8\] RF.reg_arr\[6\]\[8\] RF.reg_arr\[7\]\[8\]
+ net93 _1094_ VGND VGND VPWR VPWR _1219_ sky130_fd_sc_hd__mux4_1
XFILLER_0_53_297 VGND VGND VPWR VPWR sky130_fd_sc_hd__decap_3
XANTENNA_2 A3[0] VGND VGND VPWR VPWR sky130_fd_sc_hd__diode_2
X_6100_ _2858_ _2864_ VGND VGND VPWR VPWR _2865_ sky130_fd_sc_hd__and2b_1
X_4361_ _1146_ _1149_ _1126_ VGND VGND VPWR VPWR _1150_ sky130_fd_sc_hd__mux2_1
X_7080_ _3480_ VGND VGND VPWR VPWR _0091_ sky130_fd_sc_hd__clkbuf_1
X_4292_ _1079_ _1080_ _1075_ VGND VGND VPWR VPWR _1081_ sky130_fd_sc_hd__mux2_1
X_6031_ _1162_ _1185_ _1205_ VGND VGND VPWR VPWR _2799_ sky130_fd_sc_hd__and3_1
Xrebuffer14 _2666_ VGND VGND VPWR VPWR net96 sky130_fd_sc_hd__buf_2
XFILLER_0_83_87 VGND VGND VPWR VPWR sky130_fd_sc_hd__fill_1
X_7982_ _3002_ net465 _3958_ VGND VGND VPWR VPWR _3961_ sky130_fd_sc_hd__mux2_1
XFILLER_0_89_673 VGND VGND VPWR VPWR sky130_fd_sc_hd__decap_3
X_6933_ _3392_ VGND VGND VPWR VPWR _0032_ sky130_fd_sc_hd__clkbuf_1
X_6864_ net361 _3010_ _3344_ VGND VGND VPWR VPWR _3351_ sky130_fd_sc_hd__mux2_1
X_8603_ clknet_leaf_26_CLK _0860_ VGND VGND VPWR VPWR RF.reg_arr\[0\]\[29\] sky130_fd_sc_hd__dfxtp_1
X_5815_ _2592_ _2595_ _1831_ VGND VGND VPWR VPWR _2596_ sky130_fd_sc_hd__mux2_1
XFILLER_0_57_581 VGND VGND VPWR VPWR sky130_fd_sc_hd__fill_1
X_6795_ net156 _3010_ _3307_ VGND VGND VPWR VPWR _3314_ sky130_fd_sc_hd__mux2_1
XFILLER_0_106_119 VGND VGND VPWR VPWR sky130_fd_sc_hd__fill_1
X_8534_ clknet_leaf_53_CLK _0791_ VGND VGND VPWR VPWR RF.reg_arr\[1\]\[24\] sky130_fd_sc_hd__dfxtp_1
X_5746_ _2438_ _2424_ _2003_ VGND VGND VPWR VPWR _2529_ sky130_fd_sc_hd__mux2_1
X_5677_ _2276_ _2348_ VGND VGND VPWR VPWR _2463_ sky130_fd_sc_hd__nand2_1
XFILLER_0_72_551 VGND VGND VPWR VPWR sky130_fd_sc_hd__decap_6
X_8465_ net627 net42 _4211_ VGND VGND VPWR VPWR _4216_ sky130_fd_sc_hd__mux2_1
XFILLER_0_44_242 VGND VGND VPWR VPWR sky130_fd_sc_hd__fill_1
XFILLER_0_44_253 VGND VGND VPWR VPWR sky130_fd_sc_hd__fill_2
XFILLER_0_44_264 VGND VGND VPWR VPWR sky130_fd_sc_hd__decap_6
X_7416_ _3113_ net1098 _3652_ VGND VGND VPWR VPWR _3659_ sky130_fd_sc_hd__mux2_1
XFILLER_0_115_653 VPWR VGND VPWR VGND sky130_ef_sc_hd__decap_12
XFILLER_0_114_141 VGND VGND VPWR VPWR sky130_fd_sc_hd__decap_6
X_4628_ RF.reg_arr\[24\]\[27\] RF.reg_arr\[25\]\[27\] RF.reg_arr\[26\]\[27\] RF.reg_arr\[27\]\[27\]
+ _1175_ _1176_ VGND VGND VPWR VPWR _1417_ sky130_fd_sc_hd__mux4_1
X_8396_ net304 _3399_ _4174_ VGND VGND VPWR VPWR _4180_ sky130_fd_sc_hd__mux2_1
Xhold530 RF.reg_arr\[13\]\[4\] VGND VGND VPWR VPWR net612 sky130_fd_sc_hd__dlygate4sd3_1
X_7347_ _3622_ VGND VGND VPWR VPWR _0216_ sky130_fd_sc_hd__clkbuf_1
Xhold563 RF.reg_arr\[15\]\[31\] VGND VGND VPWR VPWR net645 sky130_fd_sc_hd__dlygate4sd3_1
X_4559_ _1126_ _1341_ _1345_ _1347_ _1141_ VGND VGND VPWR VPWR _1348_ sky130_fd_sc_hd__a221o_1
Xhold552 RF.reg_arr\[25\]\[4\] VGND VGND VPWR VPWR net634 sky130_fd_sc_hd__dlygate4sd3_1
XFILLER_0_13_673 VGND VGND VPWR VPWR sky130_fd_sc_hd__decap_3
Xhold541 RF.reg_arr\[16\]\[5\] VGND VGND VPWR VPWR net623 sky130_fd_sc_hd__dlygate4sd3_1
X_7278_ _3111_ net970 _3580_ VGND VGND VPWR VPWR _3586_ sky130_fd_sc_hd__mux2_1
Xhold574 RF.reg_arr\[24\]\[20\] VGND VGND VPWR VPWR net656 sky130_fd_sc_hd__dlygate4sd3_1
Xhold596 RF.reg_arr\[7\]\[10\] VGND VGND VPWR VPWR net678 sky130_fd_sc_hd__dlygate4sd3_1
Xhold585 RF.reg_arr\[18\]\[17\] VGND VGND VPWR VPWR net667 sky130_fd_sc_hd__dlygate4sd3_1
X_6229_ _2983_ VGND VGND VPWR VPWR _0761_ sky130_fd_sc_hd__clkbuf_1
X_9017_ clknet_leaf_32_CLK _0250_ VGND VGND VPWR VPWR RF.reg_arr\[27\]\[27\] sky130_fd_sc_hd__dfxtp_1
XTAP_TAPCELL_ROW_56_922 VGND VPWR sky130_fd_sc_hd__tapvpwrvgnd_1
XFILLER_0_67_301 VGND VGND VPWR VPWR sky130_fd_sc_hd__decap_4
XFILLER_0_67_334 VGND VGND VPWR VPWR sky130_fd_sc_hd__fill_2
XFILLER_0_94_197 VGND VGND VPWR VPWR sky130_fd_sc_hd__decap_3
XFILLER_0_106_642 VGND VGND VPWR VPWR sky130_fd_sc_hd__fill_2
XTAP_TAPCELL_ROW_97_1412 VGND VPWR sky130_fd_sc_hd__tapvpwrvgnd_1
XFILLER_0_106_664 VGND VGND VPWR VPWR sky130_fd_sc_hd__decap_8
XFILLER_0_50_201 VGND VGND VPWR VPWR sky130_fd_sc_hd__decap_3
Xoutput61 net61 VGND VGND VPWR VPWR result[20] sky130_fd_sc_hd__clkbuf_4
Xoutput50 net50 VGND VGND VPWR VPWR result[10] sky130_fd_sc_hd__clkbuf_4
Xoutput72 net72 VGND VGND VPWR VPWR result[30] sky130_fd_sc_hd__clkbuf_4
XFILLER_0_101_391 VGND VGND VPWR VPWR sky130_fd_sc_hd__fill_1
XFILLER_0_53_57 VGND VGND VPWR VPWR sky130_fd_sc_hd__fill_2
XFILLER_0_53_68 VGND VGND VPWR VPWR sky130_fd_sc_hd__fill_2
XFILLER_0_58_356 VGND VGND VPWR VPWR sky130_fd_sc_hd__fill_2
XFILLER_0_53_79 VGND VGND VPWR VPWR sky130_fd_sc_hd__fill_2
XFILLER_0_73_326 VGND VGND VPWR VPWR sky130_fd_sc_hd__decap_4
XFILLER_0_73_304 VGND VGND VPWR VPWR sky130_fd_sc_hd__fill_1
XFILLER_0_46_529 VGND VGND VPWR VPWR sky130_fd_sc_hd__decap_3
X_5600_ _1833_ _2175_ _1700_ VGND VGND VPWR VPWR _2388_ sky130_fd_sc_hd__o21ai_1
XFILLER_0_73_359 VGND VGND VPWR VPWR sky130_fd_sc_hd__decap_4
XFILLER_0_73_337 VGND VGND VPWR VPWR sky130_fd_sc_hd__decap_6
XFILLER_0_6_615 VGND VGND VPWR VPWR sky130_fd_sc_hd__decap_8
X_6580_ net220 _3002_ _3196_ VGND VGND VPWR VPWR _3199_ sky130_fd_sc_hd__mux2_1
X_5531_ _2318_ _2319_ _1609_ VGND VGND VPWR VPWR _2320_ sky130_fd_sc_hd__mux2_1
XFILLER_0_26_253 VGND VGND VPWR VPWR sky130_fd_sc_hd__decap_3
X_8250_ net765 _3387_ _4102_ VGND VGND VPWR VPWR _4103_ sky130_fd_sc_hd__mux2_1
XFILLER_0_78_32 VGND VGND VPWR VPWR sky130_fd_sc_hd__fill_1
X_7201_ net282 _3433_ _3543_ VGND VGND VPWR VPWR _3545_ sky130_fd_sc_hd__mux2_1
X_5462_ _2249_ _2250_ _1611_ VGND VGND VPWR VPWR _2251_ sky130_fd_sc_hd__mux2_1
X_4413_ RF.reg_arr\[12\]\[18\] RF.reg_arr\[13\]\[18\] RF.reg_arr\[14\]\[18\] RF.reg_arr\[15\]\[18\]
+ _1187_ _1189_ VGND VGND VPWR VPWR _1202_ sky130_fd_sc_hd__mux4_1
X_5393_ _2180_ _2181_ _1863_ VGND VGND VPWR VPWR _2182_ sky130_fd_sc_hd__mux2_1
X_8181_ _4065_ VGND VGND VPWR VPWR _4066_ sky130_fd_sc_hd__clkbuf_8
X_7132_ _3508_ VGND VGND VPWR VPWR _0115_ sky130_fd_sc_hd__clkbuf_1
X_4344_ _1049_ VGND VGND VPWR VPWR _1133_ sky130_fd_sc_hd__buf_4
XFILLER_0_10_654 VGND VGND VPWR VPWR sky130_fd_sc_hd__fill_1
XFILLER_0_1_353 VGND VGND VPWR VPWR sky130_fd_sc_hd__fill_1
XFILLER_0_111_199 VGND VGND VPWR VPWR sky130_fd_sc_hd__fill_2
X_7063_ net515 _3430_ _3471_ VGND VGND VPWR VPWR _3472_ sky130_fd_sc_hd__mux2_1
XTAP_TAPCELL_ROW_6_319 VGND VPWR sky130_fd_sc_hd__tapvpwrvgnd_1
X_6014_ _1912_ _1965_ VGND VGND VPWR VPWR _2783_ sky130_fd_sc_hd__nand2_1
XFILLER_0_94_53 VGND VGND VPWR VPWR sky130_fd_sc_hd__decap_8
X_4275_ _1048_ _1056_ _1060_ _1062_ _1063_ VGND VGND VPWR VPWR _1064_ sky130_fd_sc_hd__a221o_1
X_7965_ _3951_ VGND VGND VPWR VPWR _0505_ sky130_fd_sc_hd__clkbuf_1
XTAP_TAPCELL_ROW_68_1068 VGND VPWR sky130_fd_sc_hd__tapvpwrvgnd_1
X_7896_ _3113_ net701 _3908_ VGND VGND VPWR VPWR _3915_ sky130_fd_sc_hd__mux2_1
X_6916_ _3380_ VGND VGND VPWR VPWR _0027_ sky130_fd_sc_hd__clkbuf_1
XTAP_TAPCELL_ROW_81_1224 VGND VPWR sky130_fd_sc_hd__tapvpwrvgnd_1
XFILLER_0_49_367 VGND VGND VPWR VPWR sky130_fd_sc_hd__decap_6
XFILLER_0_91_101 VGND VGND VPWR VPWR sky130_fd_sc_hd__fill_1
X_6847_ net379 _2992_ _3306_ VGND VGND VPWR VPWR _3341_ sky130_fd_sc_hd__mux2_1
XFILLER_0_9_442 VGND VGND VPWR VPWR sky130_fd_sc_hd__fill_2
XFILLER_0_9_420 VGND VGND VPWR VPWR sky130_fd_sc_hd__fill_1
X_6778_ _3123_ net888 _3269_ VGND VGND VPWR VPWR _3304_ sky130_fd_sc_hd__mux2_1
XTAP_TAPCELL_ROW_61_980 VGND VPWR sky130_fd_sc_hd__tapvpwrvgnd_1
X_5729_ _2485_ _2511_ _2512_ _2334_ VGND VGND VPWR VPWR _2513_ sky130_fd_sc_hd__a211o_1
XFILLER_0_91_167 VGND VGND VPWR VPWR sky130_fd_sc_hd__fill_1
X_8517_ clknet_leaf_88_CLK _0774_ VGND VGND VPWR VPWR RF.reg_arr\[1\]\[7\] sky130_fd_sc_hd__dfxtp_1
X_9497_ clknet_leaf_37_CLK _0730_ VGND VGND VPWR VPWR RF.reg_arr\[11\]\[27\] sky130_fd_sc_hd__dfxtp_1
XFILLER_0_45_595 VGND VGND VPWR VPWR sky130_fd_sc_hd__decap_3
X_8448_ net149 net37 _4173_ VGND VGND VPWR VPWR _4207_ sky130_fd_sc_hd__mux2_1
X_8379_ _4170_ VGND VGND VPWR VPWR _0700_ sky130_fd_sc_hd__clkbuf_1
XTAP_TAPCELL_ROW_79_1197 VGND VPWR sky130_fd_sc_hd__tapvpwrvgnd_1
XFILLER_0_4_191 VGND VGND VPWR VPWR sky130_fd_sc_hd__fill_2
XFILLER_0_103_689 VGND VGND VPWR VPWR sky130_fd_sc_hd__decap_3
Xhold371 RF.reg_arr\[7\]\[26\] VGND VGND VPWR VPWR net453 sky130_fd_sc_hd__dlygate4sd3_1
XTAP_TAPCELL_ROW_92_1353 VGND VPWR sky130_fd_sc_hd__tapvpwrvgnd_1
Xhold360 RF.reg_arr\[1\]\[17\] VGND VGND VPWR VPWR net442 sky130_fd_sc_hd__dlygate4sd3_1
Xhold393 RF.reg_arr\[10\]\[30\] VGND VGND VPWR VPWR net475 sky130_fd_sc_hd__dlygate4sd3_1
Xhold382 RF.reg_arr\[7\]\[9\] VGND VGND VPWR VPWR net464 sky130_fd_sc_hd__dlygate4sd3_1
XFILLER_0_99_289 VGND VGND VPWR VPWR sky130_fd_sc_hd__fill_2
XFILLER_0_68_610 VGND VGND VPWR VPWR sky130_fd_sc_hd__decap_8
XFILLER_0_114_29 VPWR VGND VPWR VGND sky130_ef_sc_hd__decap_12
XFILLER_0_23_27 VGND VGND VPWR VPWR sky130_fd_sc_hd__decap_4
XFILLER_0_95_484 VGND VGND VPWR VPWR sky130_fd_sc_hd__decap_6
XFILLER_0_28_529 VGND VGND VPWR VPWR sky130_fd_sc_hd__decap_3
XTAP_TAPCELL_ROW_101_1460 VGND VPWR sky130_fd_sc_hd__tapvpwrvgnd_1
XTAP_TAPCELL_ROW_31_619 VGND VPWR sky130_fd_sc_hd__tapvpwrvgnd_1
XFILLER_0_55_337 VGND VGND VPWR VPWR sky130_fd_sc_hd__fill_1
XFILLER_0_113_409 VGND VGND VPWR VPWR sky130_fd_sc_hd__decap_8
Xrebuffer5 net86 VGND VGND VPWR VPWR net87 sky130_fd_sc_hd__dlymetal6s2s_1
XTAP_TAPCELL_ROW_11_387 VGND VPWR sky130_fd_sc_hd__tapvpwrvgnd_1
XFILLER_0_3_15 VPWR VGND VPWR VGND sky130_ef_sc_hd__decap_12
XTAP_TAPCELL_ROW_39_719 VGND VPWR sky130_fd_sc_hd__tapvpwrvgnd_1
X_4962_ _1749_ _1750_ _1613_ VGND VGND VPWR VPWR _1751_ sky130_fd_sc_hd__mux2_1
XFILLER_0_80_11 VGND VGND VPWR VPWR sky130_fd_sc_hd__fill_1
X_7750_ _3837_ VGND VGND VPWR VPWR _0404_ sky130_fd_sc_hd__clkbuf_1
XTAP_TAPCELL_ROW_19_476 VGND VPWR sky130_fd_sc_hd__tapvpwrvgnd_1
X_6701_ _3262_ VGND VGND VPWR VPWR _0954_ sky130_fd_sc_hd__clkbuf_1
X_7681_ _3103_ net546 _3799_ VGND VGND VPWR VPWR _3801_ sky130_fd_sc_hd__mux2_1
X_4893_ _1681_ VGND VGND VPWR VPWR _1682_ sky130_fd_sc_hd__clkbuf_4
X_6632_ net657 _2984_ _3218_ VGND VGND VPWR VPWR _3226_ sky130_fd_sc_hd__mux2_1
XFILLER_0_80_77 VGND VGND VPWR VPWR sky130_fd_sc_hd__decap_4
X_9420_ clknet_leaf_101_CLK _0653_ VGND VGND VPWR VPWR RF.reg_arr\[17\]\[14\] sky130_fd_sc_hd__dfxtp_1
XFILLER_0_73_167 VGND VGND VPWR VPWR sky130_fd_sc_hd__fill_1
X_6563_ _3189_ VGND VGND VPWR VPWR _0889_ sky130_fd_sc_hd__clkbuf_1
XFILLER_0_73_189 VGND VGND VPWR VPWR sky130_fd_sc_hd__decap_4
XFILLER_0_14_223 VGND VGND VPWR VPWR sky130_fd_sc_hd__decap_3
X_9351_ clknet_leaf_78_CLK _0584_ VGND VGND VPWR VPWR RF.reg_arr\[18\]\[9\] sky130_fd_sc_hd__dfxtp_1
X_6494_ net102 VGND VGND VPWR VPWR _3152_ sky130_fd_sc_hd__clkbuf_1
X_8302_ net991 _3373_ _4124_ VGND VGND VPWR VPWR _4130_ sky130_fd_sc_hd__mux2_1
X_9282_ clknet_leaf_76_CLK _0515_ VGND VGND VPWR VPWR RF.reg_arr\[25\]\[4\] sky130_fd_sc_hd__dfxtp_1
X_5514_ _2301_ _2302_ net3 VGND VGND VPWR VPWR _2303_ sky130_fd_sc_hd__mux2_1
XTAP_TAPCELL_ROW_115_1629 VGND VPWR sky130_fd_sc_hd__tapvpwrvgnd_1
X_8233_ _4093_ VGND VGND VPWR VPWR _0631_ sky130_fd_sc_hd__clkbuf_1
XFILLER_0_14_267 VPWR VGND VPWR VGND sky130_ef_sc_hd__decap_12
X_5445_ _1586_ _2225_ _2233_ VGND VGND VPWR VPWR _2234_ sky130_fd_sc_hd__a21oi_4
XFILLER_0_112_453 VGND VGND VPWR VPWR sky130_fd_sc_hd__fill_2
X_8164_ net132 _3371_ _4052_ VGND VGND VPWR VPWR _4057_ sky130_fd_sc_hd__mux2_1
XFILLER_0_100_626 VGND VGND VPWR VPWR sky130_fd_sc_hd__fill_1
XFILLER_0_66_3 VGND VGND VPWR VPWR sky130_fd_sc_hd__fill_2
X_5376_ _2163_ _2164_ _1863_ VGND VGND VPWR VPWR _2165_ sky130_fd_sc_hd__mux2_1
X_7115_ _3499_ VGND VGND VPWR VPWR _0107_ sky130_fd_sc_hd__clkbuf_1
X_8095_ _4020_ VGND VGND VPWR VPWR _0566_ sky130_fd_sc_hd__clkbuf_1
X_4327_ _1025_ VGND VGND VPWR VPWR _1116_ sky130_fd_sc_hd__buf_6
X_7046_ net521 _3414_ _3460_ VGND VGND VPWR VPWR _3463_ sky130_fd_sc_hd__mux2_1
X_4258_ RF.reg_arr\[4\]\[5\] RF.reg_arr\[5\]\[5\] RF.reg_arr\[6\]\[5\] RF.reg_arr\[7\]\[5\]
+ _1044_ _1046_ VGND VGND VPWR VPWR _1047_ sky130_fd_sc_hd__mux4_1
X_8997_ clknet_leaf_83_CLK _0230_ VGND VGND VPWR VPWR RF.reg_arr\[27\]\[7\] sky130_fd_sc_hd__dfxtp_1
XFILLER_0_96_259 VGND VGND VPWR VPWR sky130_fd_sc_hd__fill_1
X_7948_ _3942_ VGND VGND VPWR VPWR _0497_ sky130_fd_sc_hd__clkbuf_1
XFILLER_0_77_462 VGND VGND VPWR VPWR sky130_fd_sc_hd__fill_1
X_7879_ _3096_ net1010 _3897_ VGND VGND VPWR VPWR _3906_ sky130_fd_sc_hd__mux2_1
XFILLER_0_103_420 VGND VGND VPWR VPWR sky130_fd_sc_hd__decap_6
XFILLER_0_60_362 VGND VGND VPWR VPWR sky130_fd_sc_hd__fill_2
Xhold190 RF.reg_arr\[1\]\[15\] VGND VGND VPWR VPWR net272 sky130_fd_sc_hd__dlygate4sd3_1
XFILLER_0_18_27 VGND VGND VPWR VPWR sky130_fd_sc_hd__fill_1
XPHY_EDGE_ROW_16_Right_16 VGND VGND VPWR VPWR sky130_fd_sc_hd__decap_3
XFILLER_0_34_26 VGND VGND VPWR VPWR sky130_fd_sc_hd__fill_2
XTAP_TAPCELL_ROW_16_446 VGND VPWR sky130_fd_sc_hd__tapvpwrvgnd_1
XFILLER_0_95_281 VGND VGND VPWR VPWR sky130_fd_sc_hd__decap_3
XTAP_TAPCELL_ROW_44_777 VGND VPWR sky130_fd_sc_hd__tapvpwrvgnd_1
XFILLER_0_113_228 VGND VGND VPWR VPWR sky130_fd_sc_hd__decap_3
XPHY_EDGE_ROW_25_Right_25 VGND VGND VPWR VPWR sky130_fd_sc_hd__decap_3
XFILLER_0_11_215 VGND VGND VPWR VPWR sky130_fd_sc_hd__fill_1
XFILLER_0_24_587 VGND VGND VPWR VPWR sky130_fd_sc_hd__fill_1
XFILLER_0_51_373 VGND VGND VPWR VPWR sky130_fd_sc_hd__decap_3
X_5230_ _2017_ _2018_ net6 VGND VGND VPWR VPWR _2019_ sky130_fd_sc_hd__mux2_1
X_5161_ RF.reg_arr\[16\]\[19\] RF.reg_arr\[17\]\[19\] RF.reg_arr\[18\]\[19\] RF.reg_arr\[19\]\[19\]
+ _1947_ _1948_ VGND VGND VPWR VPWR _1950_ sky130_fd_sc_hd__mux4_1
X_5092_ RF.reg_arr\[0\]\[23\] RF.reg_arr\[1\]\[23\] RF.reg_arr\[2\]\[23\] RF.reg_arr\[3\]\[23\]
+ _1591_ _1878_ VGND VGND VPWR VPWR _1881_ sky130_fd_sc_hd__mux4_1
XFILLER_0_75_55 VGND VGND VPWR VPWR sky130_fd_sc_hd__fill_1
X_8920_ clknet_leaf_50_CLK _0153_ VGND VGND VPWR VPWR RF.reg_arr\[7\]\[26\] sky130_fd_sc_hd__dfxtp_1
XPHY_EDGE_ROW_34_Right_34 VGND VGND VPWR VPWR sky130_fd_sc_hd__decap_3
X_8851_ clknet_leaf_47_CLK _0084_ VGND VGND VPWR VPWR RF.reg_arr\[19\]\[21\] sky130_fd_sc_hd__dfxtp_1
X_5994_ _2743_ _2763_ _2764_ VGND VGND VPWR VPWR _2765_ sky130_fd_sc_hd__a21oi_2
XTAP_TAPCELL_ROW_65_1027 VGND VPWR sky130_fd_sc_hd__tapvpwrvgnd_1
X_7802_ _3088_ net726 _3860_ VGND VGND VPWR VPWR _3865_ sky130_fd_sc_hd__mux2_1
X_8782_ clknet_leaf_10_CLK _0015_ VGND VGND VPWR VPWR RF.reg_arr\[5\]\[16\] sky130_fd_sc_hd__dfxtp_1
X_7733_ _3828_ VGND VGND VPWR VPWR _0396_ sky130_fd_sc_hd__clkbuf_1
X_4945_ _1732_ _1733_ net6 VGND VGND VPWR VPWR _1734_ sky130_fd_sc_hd__mux2_1
XFILLER_0_19_337 VGND VGND VPWR VPWR sky130_fd_sc_hd__fill_2
X_4876_ _1648_ _1664_ VGND VGND VPWR VPWR _1665_ sky130_fd_sc_hd__nand2_1
X_7664_ _3086_ net1081 _3788_ VGND VGND VPWR VPWR _3792_ sky130_fd_sc_hd__mux2_1
X_9403_ clknet_leaf_28_CLK _0636_ VGND VGND VPWR VPWR RF.reg_arr\[13\]\[29\] sky130_fd_sc_hd__dfxtp_1
XFILLER_0_6_253 VGND VGND VPWR VPWR sky130_fd_sc_hd__fill_1
X_7595_ _3755_ VGND VGND VPWR VPWR _0331_ sky130_fd_sc_hd__clkbuf_1
XPHY_EDGE_ROW_43_Right_43 VGND VGND VPWR VPWR sky130_fd_sc_hd__decap_3
X_6615_ net821 _3037_ _3207_ VGND VGND VPWR VPWR _3217_ sky130_fd_sc_hd__mux2_1
X_9334_ clknet_leaf_53_CLK _0567_ VGND VGND VPWR VPWR RF.reg_arr\[20\]\[24\] sky130_fd_sc_hd__dfxtp_1
XFILLER_0_104_206 VGND VGND VPWR VPWR sky130_fd_sc_hd__fill_1
X_6546_ _3180_ VGND VGND VPWR VPWR _0881_ sky130_fd_sc_hd__clkbuf_1
XFILLER_0_112_250 VGND VGND VPWR VPWR sky130_fd_sc_hd__fill_2
XTAP_TAPCELL_ROW_76_1167 VGND VPWR sky130_fd_sc_hd__tapvpwrvgnd_1
X_9265_ clknet_leaf_3_CLK _0498_ VGND VGND VPWR VPWR RF.reg_arr\[21\]\[19\] sky130_fd_sc_hd__dfxtp_1
X_6477_ _3143_ VGND VGND VPWR VPWR _0849_ sky130_fd_sc_hd__clkbuf_1
X_5428_ _1649_ _2216_ VGND VGND VPWR VPWR _2217_ sky130_fd_sc_hd__or2_1
X_9196_ clknet_leaf_100_CLK _0429_ VGND VGND VPWR VPWR RF.reg_arr\[24\]\[14\] sky130_fd_sc_hd__dfxtp_1
X_8216_ _4084_ VGND VGND VPWR VPWR _0623_ sky130_fd_sc_hd__clkbuf_1
X_5359_ _2144_ _2147_ _1635_ VGND VGND VPWR VPWR _2148_ sky130_fd_sc_hd__mux2_1
X_8147_ net570 _3422_ _4041_ VGND VGND VPWR VPWR _4048_ sky130_fd_sc_hd__mux2_1
X_8078_ _4011_ VGND VGND VPWR VPWR _0558_ sky130_fd_sc_hd__clkbuf_1
X_7029_ net585 _3397_ _3449_ VGND VGND VPWR VPWR _3454_ sky130_fd_sc_hd__mux2_1
XPHY_EDGE_ROW_52_Right_52 VGND VGND VPWR VPWR sky130_fd_sc_hd__decap_3
XFILLER_0_97_502 VGND VGND VPWR VPWR sky130_fd_sc_hd__fill_2
XFILLER_0_69_215 VGND VGND VPWR VPWR sky130_fd_sc_hd__decap_8
XTAP_TAPCELL_ROW_87_1296 VGND VPWR sky130_fd_sc_hd__tapvpwrvgnd_1
XTAP_TAPCELL_ROW_13_405 VGND VPWR sky130_fd_sc_hd__tapvpwrvgnd_1
XPHY_EDGE_ROW_61_Right_61 VGND VGND VPWR VPWR sky130_fd_sc_hd__decap_3
XTAP_TAPCELL_ROW_41_747 VGND VPWR sky130_fd_sc_hd__tapvpwrvgnd_1
XFILLER_0_108_545 VGND VGND VPWR VPWR sky130_fd_sc_hd__decap_8
XFILLER_0_65_487 VPWR VGND VPWR VGND sky130_ef_sc_hd__decap_12
XFILLER_0_108_589 VPWR VGND VPWR VGND sky130_ef_sc_hd__decap_12
XFILLER_0_46_690 VGND VGND VPWR VPWR sky130_fd_sc_hd__fill_2
XFILLER_0_103_272 VGND VGND VPWR VPWR sky130_fd_sc_hd__fill_2
XFILLER_0_0_429 VGND VGND VPWR VPWR sky130_fd_sc_hd__fill_2
XFILLER_0_21_557 VGND VGND VPWR VPWR sky130_fd_sc_hd__decap_3
XPHY_EDGE_ROW_70_Right_70 VGND VGND VPWR VPWR sky130_fd_sc_hd__decap_3
XTAP_TAPCELL_ROW_49_836 VGND VPWR sky130_fd_sc_hd__tapvpwrvgnd_1
XPHY_EDGE_ROW_14_Left_131 VGND VGND VPWR VPWR sky130_fd_sc_hd__decap_3
XFILLER_0_0_27 VGND VGND VPWR VPWR sky130_fd_sc_hd__fill_1
XFILLER_0_29_613 VGND VGND VPWR VPWR sky130_fd_sc_hd__decap_3
X_4730_ RF.reg_arr\[16\]\[14\] RF.reg_arr\[17\]\[14\] RF.reg_arr\[18\]\[14\] RF.reg_arr\[19\]\[14\]
+ _1357_ _1358_ VGND VGND VPWR VPWR _1519_ sky130_fd_sc_hd__mux4_1
XFILLER_0_28_134 VGND VGND VPWR VPWR sky130_fd_sc_hd__decap_6
X_4661_ _1175_ VGND VGND VPWR VPWR _1450_ sky130_fd_sc_hd__buf_6
XFILLER_0_71_446 VGND VGND VPWR VPWR sky130_fd_sc_hd__fill_2
X_7380_ _3077_ net788 _3630_ VGND VGND VPWR VPWR _3640_ sky130_fd_sc_hd__mux2_1
XFILLER_0_37_690 VGND VGND VPWR VPWR sky130_fd_sc_hd__fill_2
X_6400_ net24 VGND VGND VPWR VPWR _3098_ sky130_fd_sc_hd__clkbuf_2
X_6331_ net234 _2986_ _3040_ VGND VGND VPWR VPWR _3052_ sky130_fd_sc_hd__mux2_1
Xhold904 RF.reg_arr\[13\]\[31\] VGND VGND VPWR VPWR net986 sky130_fd_sc_hd__dlygate4sd3_1
X_4592_ _1379_ _1380_ _1042_ VGND VGND VPWR VPWR _1381_ sky130_fd_sc_hd__mux2_1
XFILLER_0_3_223 VGND VGND VPWR VPWR sky130_fd_sc_hd__fill_1
XFILLER_0_52_671 VGND VGND VPWR VPWR sky130_fd_sc_hd__fill_1
XFILLER_0_101_74 VGND VGND VPWR VPWR sky130_fd_sc_hd__decap_3
Xhold926 RF.reg_arr\[14\]\[0\] VGND VGND VPWR VPWR net1008 sky130_fd_sc_hd__dlygate4sd3_1
Xhold937 RF.reg_arr\[4\]\[9\] VGND VGND VPWR VPWR net1019 sky130_fd_sc_hd__dlygate4sd3_1
Xhold915 RF.reg_arr\[24\]\[11\] VGND VGND VPWR VPWR net997 sky130_fd_sc_hd__dlygate4sd3_1
X_9050_ clknet_leaf_29_CLK _0283_ VGND VGND VPWR VPWR RF.reg_arr\[26\]\[28\] sky130_fd_sc_hd__dfxtp_1
Xhold959 RF.reg_arr\[20\]\[1\] VGND VGND VPWR VPWR net1041 sky130_fd_sc_hd__dlygate4sd3_1
Xhold948 RF.reg_arr\[29\]\[31\] VGND VGND VPWR VPWR net1030 sky130_fd_sc_hd__dlygate4sd3_1
XPHY_EDGE_ROW_23_Left_140 VGND VGND VPWR VPWR sky130_fd_sc_hd__decap_3
X_6262_ net428 _3006_ _2998_ VGND VGND VPWR VPWR _3007_ sky130_fd_sc_hd__mux2_1
X_6193_ _2689_ _2714_ _2928_ _2433_ _2443_ VGND VGND VPWR VPWR _2952_ sky130_fd_sc_hd__o221a_1
X_5213_ _1966_ _1999_ _2001_ VGND VGND VPWR VPWR _2002_ sky130_fd_sc_hd__mux2_1
X_8001_ _3021_ net537 _3969_ VGND VGND VPWR VPWR _3971_ sky130_fd_sc_hd__mux2_1
X_5144_ RF.reg_arr\[28\]\[18\] RF.reg_arr\[29\]\[18\] RF.reg_arr\[30\]\[18\] RF.reg_arr\[31\]\[18\]
+ _1884_ _1886_ VGND VGND VPWR VPWR _1933_ sky130_fd_sc_hd__mux4_1
X_5075_ _1863_ VGND VGND VPWR VPWR _1864_ sky130_fd_sc_hd__buf_4
XFILLER_0_29_3 VGND VGND VPWR VPWR sky130_fd_sc_hd__decap_4
X_8903_ clknet_leaf_88_CLK _0136_ VGND VGND VPWR VPWR RF.reg_arr\[7\]\[9\] sky130_fd_sc_hd__dfxtp_1
X_8834_ clknet_leaf_77_CLK _0067_ VGND VGND VPWR VPWR RF.reg_arr\[19\]\[4\] sky130_fd_sc_hd__dfxtp_1
X_5977_ _2678_ _2748_ _2003_ VGND VGND VPWR VPWR _2749_ sky130_fd_sc_hd__mux2_1
X_8765_ clknet_leaf_23_CLK _1022_ VGND VGND VPWR VPWR RF.reg_arr\[6\]\[31\] sky130_fd_sc_hd__dfxtp_1
X_8696_ clknet_leaf_35_CLK _0953_ VGND VGND VPWR VPWR RF.reg_arr\[15\]\[26\] sky130_fd_sc_hd__dfxtp_1
X_4928_ _1649_ _1716_ VGND VGND VPWR VPWR _1717_ sky130_fd_sc_hd__nor2_1
X_7716_ _3819_ VGND VGND VPWR VPWR _0388_ sky130_fd_sc_hd__clkbuf_1
X_7647_ _3069_ net882 _3777_ VGND VGND VPWR VPWR _3783_ sky130_fd_sc_hd__mux2_1
XFILLER_0_19_189 VGND VGND VPWR VPWR sky130_fd_sc_hd__decap_6
XFILLER_0_35_638 VGND VGND VPWR VPWR sky130_fd_sc_hd__fill_2
X_4859_ _1113_ VGND VGND VPWR VPWR _1648_ sky130_fd_sc_hd__clkbuf_4
XFILLER_0_15_340 VGND VGND VPWR VPWR sky130_fd_sc_hd__decap_8
X_7578_ _3746_ VGND VGND VPWR VPWR _0323_ sky130_fd_sc_hd__clkbuf_1
X_9317_ clknet_leaf_83_CLK _0550_ VGND VGND VPWR VPWR RF.reg_arr\[20\]\[7\] sky130_fd_sc_hd__dfxtp_1
X_6529_ net966 _3018_ _3171_ VGND VGND VPWR VPWR _3172_ sky130_fd_sc_hd__mux2_1
X_9248_ clknet_leaf_57_CLK _0481_ VGND VGND VPWR VPWR RF.reg_arr\[21\]\[2\] sky130_fd_sc_hd__dfxtp_1
XFILLER_0_30_365 VGND VGND VPWR VPWR sky130_fd_sc_hd__decap_3
XFILLER_0_42_192 VGND VGND VPWR VPWR sky130_fd_sc_hd__decap_4
X_9179_ clknet_leaf_27_CLK _0412_ VGND VGND VPWR VPWR RF.reg_arr\[9\]\[29\] sky130_fd_sc_hd__dfxtp_1
XTAP_TAPCELL_ROW_89_1325 VGND VPWR sky130_fd_sc_hd__tapvpwrvgnd_1
XTAP_TAPCELL_ROW_89_1314 VGND VPWR sky130_fd_sc_hd__tapvpwrvgnd_1
XTAP_TAPCELL_ROW_46_806 VGND VPWR sky130_fd_sc_hd__tapvpwrvgnd_1
XFILLER_0_106_19 VGND VGND VPWR VPWR sky130_fd_sc_hd__fill_1
XFILLER_0_85_538 VGND VGND VPWR VPWR sky130_fd_sc_hd__decap_8
XTAP_TAPCELL_ROW_26_563 VGND VPWR sky130_fd_sc_hd__tapvpwrvgnd_1
XTAP_TAPCELL_ROW_54_894 VGND VPWR sky130_fd_sc_hd__tapvpwrvgnd_1
XTAP_TAPCELL_ROW_109_1561 VGND VPWR sky130_fd_sc_hd__tapvpwrvgnd_1
X_5900_ _2674_ _2675_ VGND VGND VPWR VPWR _2676_ sky130_fd_sc_hd__xnor2_1
XFILLER_0_88_365 VGND VGND VPWR VPWR sky130_fd_sc_hd__fill_1
X_6880_ _3359_ VGND VGND VPWR VPWR _0012_ sky130_fd_sc_hd__clkbuf_1
X_5831_ _2609_ _2610_ VGND VGND VPWR VPWR _2611_ sky130_fd_sc_hd__and2_1
XFILLER_0_72_78 VGND VGND VPWR VPWR sky130_fd_sc_hd__decap_6
XFILLER_0_91_519 VGND VGND VPWR VPWR sky130_fd_sc_hd__fill_1
X_5762_ _2540_ _2544_ VGND VGND VPWR VPWR _2545_ sky130_fd_sc_hd__xnor2_1
X_8550_ clknet_leaf_81_CLK _0807_ VGND VGND VPWR VPWR RF.reg_arr\[23\]\[8\] sky130_fd_sc_hd__dfxtp_1
XFILLER_0_84_593 VGND VGND VPWR VPWR sky130_fd_sc_hd__fill_1
X_7501_ net881 _3387_ _3705_ VGND VGND VPWR VPWR _3706_ sky130_fd_sc_hd__mux2_1
X_4713_ _1500_ _1501_ _1034_ VGND VGND VPWR VPWR _1502_ sky130_fd_sc_hd__mux2_1
XFILLER_0_114_301 VGND VGND VPWR VPWR sky130_fd_sc_hd__decap_3
X_5693_ _2000_ _2410_ _2411_ _2027_ VGND VGND VPWR VPWR _2479_ sky130_fd_sc_hd__a31o_1
XFILLER_0_71_232 VGND VGND VPWR VPWR sky130_fd_sc_hd__decap_3
X_8481_ _4224_ VGND VGND VPWR VPWR _0748_ sky130_fd_sc_hd__clkbuf_1
X_4644_ RF.reg_arr\[20\]\[26\] RF.reg_arr\[21\]\[26\] RF.reg_arr\[22\]\[26\] RF.reg_arr\[23\]\[26\]
+ _1273_ _1275_ VGND VGND VPWR VPWR _1433_ sky130_fd_sc_hd__mux4_1
XFILLER_0_71_276 VGND VGND VPWR VPWR sky130_fd_sc_hd__decap_4
XFILLER_0_71_254 VGND VGND VPWR VPWR sky130_fd_sc_hd__fill_1
X_7432_ _3668_ VGND VGND VPWR VPWR _0255_ sky130_fd_sc_hd__clkbuf_1
XFILLER_0_25_671 VGND VGND VPWR VPWR sky130_fd_sc_hd__fill_1
Xhold712 RF.reg_arr\[15\]\[26\] VGND VGND VPWR VPWR net794 sky130_fd_sc_hd__dlygate4sd3_1
X_4575_ RF.reg_arr\[0\]\[21\] RF.reg_arr\[1\]\[21\] RF.reg_arr\[2\]\[21\] RF.reg_arr\[3\]\[21\]
+ _1186_ _1188_ VGND VGND VPWR VPWR _1364_ sky130_fd_sc_hd__mux4_1
X_7363_ _3631_ VGND VGND VPWR VPWR _0223_ sky130_fd_sc_hd__clkbuf_1
Xhold701 RF.reg_arr\[11\]\[10\] VGND VGND VPWR VPWR net783 sky130_fd_sc_hd__dlygate4sd3_1
XFILLER_0_102_529 VGND VGND VPWR VPWR sky130_fd_sc_hd__decap_3
X_6314_ net27 VGND VGND VPWR VPWR _3042_ sky130_fd_sc_hd__buf_2
Xhold734 RF.reg_arr\[30\]\[7\] VGND VGND VPWR VPWR net816 sky130_fd_sc_hd__dlygate4sd3_1
Xhold745 RF.reg_arr\[6\]\[17\] VGND VGND VPWR VPWR net827 sky130_fd_sc_hd__dlygate4sd3_1
X_7294_ _3056_ net936 _3594_ VGND VGND VPWR VPWR _3595_ sky130_fd_sc_hd__mux2_1
Xhold723 RF.reg_arr\[22\]\[10\] VGND VGND VPWR VPWR net805 sky130_fd_sc_hd__dlygate4sd3_1
X_9102_ clknet_leaf_9_CLK _0335_ VGND VGND VPWR VPWR RF.reg_arr\[2\]\[16\] sky130_fd_sc_hd__dfxtp_1
Xhold756 RF.reg_arr\[23\]\[29\] VGND VGND VPWR VPWR net838 sky130_fd_sc_hd__dlygate4sd3_1
XFILLER_0_97_75 VGND VGND VPWR VPWR sky130_fd_sc_hd__fill_1
Xhold778 RF.reg_arr\[16\]\[27\] VGND VGND VPWR VPWR net860 sky130_fd_sc_hd__dlygate4sd3_1
XTAP_TAPCELL_ROW_73_1126 VGND VPWR sky130_fd_sc_hd__tapvpwrvgnd_1
XFILLER_0_12_365 VGND VGND VPWR VPWR sky130_fd_sc_hd__fill_2
X_6245_ net14 VGND VGND VPWR VPWR _2994_ sky130_fd_sc_hd__buf_2
X_9033_ clknet_leaf_12_CLK _0266_ VGND VGND VPWR VPWR RF.reg_arr\[26\]\[11\] sky130_fd_sc_hd__dfxtp_1
Xhold767 RF.reg_arr\[16\]\[11\] VGND VGND VPWR VPWR net849 sky130_fd_sc_hd__dlygate4sd3_1
Xhold789 RF.reg_arr\[23\]\[20\] VGND VGND VPWR VPWR net871 sky130_fd_sc_hd__dlygate4sd3_1
X_6176_ _1315_ _2935_ VGND VGND VPWR VPWR _2936_ sky130_fd_sc_hd__xor2_1
X_5127_ RF.reg_arr\[24\]\[21\] RF.reg_arr\[25\]\[21\] RF.reg_arr\[26\]\[21\] RF.reg_arr\[27\]\[21\]
+ _1677_ _1683_ VGND VGND VPWR VPWR _1916_ sky130_fd_sc_hd__mux4_1
XPHY_EDGE_ROW_2_Right_2 VGND VGND VPWR VPWR sky130_fd_sc_hd__decap_3
X_5058_ _1846_ VGND VGND VPWR VPWR _1847_ sky130_fd_sc_hd__clkbuf_8
XTAP_TAPCELL_ROW_84_1255 VGND VPWR sky130_fd_sc_hd__tapvpwrvgnd_1
X_8817_ clknet_leaf_19_CLK _0050_ VGND VGND VPWR VPWR RF.reg_arr\[4\]\[19\] sky130_fd_sc_hd__dfxtp_1
XFILLER_0_1_81 VPWR VGND VPWR VGND sky130_ef_sc_hd__decap_12
X_8748_ clknet_leaf_102_CLK _1005_ VGND VGND VPWR VPWR RF.reg_arr\[6\]\[14\] sky130_fd_sc_hd__dfxtp_1
XTAP_TAPCELL_ROW_23_522 VGND VPWR sky130_fd_sc_hd__tapvpwrvgnd_1
XTAP_TAPCELL_ROW_23_533 VGND VPWR sky130_fd_sc_hd__tapvpwrvgnd_1
XTAP_TAPCELL_ROW_51_864 VGND VPWR sky130_fd_sc_hd__tapvpwrvgnd_1
XFILLER_0_35_435 VGND VGND VPWR VPWR sky130_fd_sc_hd__fill_1
X_8679_ clknet_leaf_64_CLK _0936_ VGND VGND VPWR VPWR RF.reg_arr\[15\]\[9\] sky130_fd_sc_hd__dfxtp_1
XFILLER_0_62_276 VGND VGND VPWR VPWR sky130_fd_sc_hd__fill_1
XFILLER_0_105_389 VGND VGND VPWR VPWR sky130_fd_sc_hd__decap_3
XTAP_TAPCELL_ROW_95_1395 VGND VPWR sky130_fd_sc_hd__tapvpwrvgnd_1
XFILLER_0_30_195 VGND VGND VPWR VPWR sky130_fd_sc_hd__fill_1
Xhold50 RF.reg_arr\[18\]\[24\] VGND VGND VPWR VPWR net132 sky130_fd_sc_hd__dlygate4sd3_1
Xhold72 RF.reg_arr\[3\]\[25\] VGND VGND VPWR VPWR net154 sky130_fd_sc_hd__dlygate4sd3_1
Xhold83 RF.reg_arr\[16\]\[23\] VGND VGND VPWR VPWR net165 sky130_fd_sc_hd__dlygate4sd3_1
XTAP_TAPCELL_ROW_59_964 VGND VPWR sky130_fd_sc_hd__tapvpwrvgnd_1
Xhold61 RF.reg_arr\[3\]\[3\] VGND VGND VPWR VPWR net143 sky130_fd_sc_hd__dlygate4sd3_1
Xhold94 RF.reg_arr\[8\]\[3\] VGND VGND VPWR VPWR net176 sky130_fd_sc_hd__dlygate4sd3_1
XTAP_TAPCELL_ROW_3_291 VGND VPWR sky130_fd_sc_hd__tapvpwrvgnd_1
XFILLER_0_93_390 VGND VGND VPWR VPWR sky130_fd_sc_hd__fill_2
XFILLER_0_53_221 VGND VGND VPWR VPWR sky130_fd_sc_hd__decap_3
XANTENNA_3 A3[1] VGND VGND VPWR VPWR sky130_fd_sc_hd__diode_2
XFILLER_0_13_129 VGND VGND VPWR VPWR sky130_fd_sc_hd__fill_1
X_4360_ _1147_ _1148_ _1121_ VGND VGND VPWR VPWR _1149_ sky130_fd_sc_hd__mux2_1
XFILLER_0_6_15 VPWR VGND VPWR VGND sky130_ef_sc_hd__decap_12
XFILLER_0_111_337 VGND VGND VPWR VPWR sky130_fd_sc_hd__fill_2
X_4291_ RF.reg_arr\[8\]\[4\] RF.reg_arr\[9\]\[4\] RF.reg_arr\[10\]\[4\] RF.reg_arr\[11\]\[4\]
+ _1027_ _1029_ VGND VGND VPWR VPWR _1080_ sky130_fd_sc_hd__mux4_1
X_6030_ _2792_ _2794_ _2789_ VGND VGND VPWR VPWR _2798_ sky130_fd_sc_hd__o21ba_1
XFILLER_0_83_55 VGND VGND VPWR VPWR sky130_fd_sc_hd__fill_1
Xrebuffer15 _1699_ VGND VGND VPWR VPWR net97 sky130_fd_sc_hd__dlygate4sd1_1
X_7981_ _3960_ VGND VGND VPWR VPWR _0512_ sky130_fd_sc_hd__clkbuf_1
XFILLER_0_89_685 VGND VGND VPWR VPWR sky130_fd_sc_hd__fill_1
X_6932_ net192 _3391_ _3389_ VGND VGND VPWR VPWR _3392_ sky130_fd_sc_hd__mux2_1
XFILLER_0_16_60 VGND VGND VPWR VPWR sky130_fd_sc_hd__decap_6
XFILLER_0_16_82 VGND VGND VPWR VPWR sky130_fd_sc_hd__fill_2
X_6863_ _3350_ VGND VGND VPWR VPWR _0004_ sky130_fd_sc_hd__clkbuf_1
X_8602_ clknet_leaf_26_CLK _0859_ VGND VGND VPWR VPWR RF.reg_arr\[0\]\[28\] sky130_fd_sc_hd__dfxtp_1
X_5814_ _2593_ _2594_ _1738_ VGND VGND VPWR VPWR _2595_ sky130_fd_sc_hd__mux2_1
XFILLER_0_76_357 VGND VGND VPWR VPWR sky130_fd_sc_hd__decap_6
XFILLER_0_76_346 VGND VGND VPWR VPWR sky130_fd_sc_hd__fill_2
XFILLER_0_8_134 VGND VGND VPWR VPWR sky130_fd_sc_hd__decap_3
X_6794_ _3313_ VGND VGND VPWR VPWR _0996_ sky130_fd_sc_hd__clkbuf_1
XFILLER_0_29_251 VGND VGND VPWR VPWR sky130_fd_sc_hd__decap_4
X_5745_ _2433_ _2489_ _2527_ _2485_ VGND VGND VPWR VPWR _2528_ sky130_fd_sc_hd__o22a_1
X_8533_ clknet_leaf_41_CLK _0790_ VGND VGND VPWR VPWR RF.reg_arr\[1\]\[23\] sky130_fd_sc_hd__dfxtp_1
XFILLER_0_72_530 VGND VGND VPWR VPWR sky130_fd_sc_hd__fill_2
X_5676_ _2461_ _2356_ _2366_ VGND VGND VPWR VPWR _2462_ sky130_fd_sc_hd__mux2_1
XFILLER_0_96_3 VGND VGND VPWR VPWR sky130_fd_sc_hd__decap_8
X_8464_ _4215_ VGND VGND VPWR VPWR _0740_ sky130_fd_sc_hd__clkbuf_1
XFILLER_0_115_665 VGND VGND VPWR VPWR sky130_fd_sc_hd__decap_6
X_7415_ _3658_ VGND VGND VPWR VPWR _0248_ sky130_fd_sc_hd__clkbuf_1
X_4627_ _1401_ _1415_ VGND VGND VPWR VPWR _1416_ sky130_fd_sc_hd__nand2_4
XFILLER_0_44_287 VGND VGND VPWR VPWR sky130_fd_sc_hd__decap_4
Xhold520 RF.reg_arr\[21\]\[13\] VGND VGND VPWR VPWR net602 sky130_fd_sc_hd__dlygate4sd3_1
X_8395_ _4179_ VGND VGND VPWR VPWR _0707_ sky130_fd_sc_hd__clkbuf_1
XFILLER_0_102_359 VGND VGND VPWR VPWR sky130_fd_sc_hd__fill_2
X_7346_ _3111_ net388 _3616_ VGND VGND VPWR VPWR _3622_ sky130_fd_sc_hd__mux2_1
Xhold531 RF.reg_arr\[27\]\[30\] VGND VGND VPWR VPWR net613 sky130_fd_sc_hd__dlygate4sd3_1
X_4558_ _1049_ _1346_ _1077_ VGND VGND VPWR VPWR _1347_ sky130_fd_sc_hd__o21a_1
Xhold542 RF.reg_arr\[9\]\[17\] VGND VGND VPWR VPWR net624 sky130_fd_sc_hd__dlygate4sd3_1
Xhold553 RF.reg_arr\[8\]\[0\] VGND VGND VPWR VPWR net635 sky130_fd_sc_hd__dlygate4sd3_1
Xhold586 RF.reg_arr\[23\]\[24\] VGND VGND VPWR VPWR net668 sky130_fd_sc_hd__dlygate4sd3_1
X_7277_ _3585_ VGND VGND VPWR VPWR _0183_ sky130_fd_sc_hd__clkbuf_1
Xhold597 RF.reg_arr\[30\]\[28\] VGND VGND VPWR VPWR net679 sky130_fd_sc_hd__dlygate4sd3_1
X_4489_ RF.reg_arr\[16\]\[28\] RF.reg_arr\[17\]\[28\] RF.reg_arr\[18\]\[28\] RF.reg_arr\[19\]\[28\]
+ _1274_ _1276_ VGND VGND VPWR VPWR _1278_ sky130_fd_sc_hd__mux4_1
Xhold575 RF.reg_arr\[8\]\[27\] VGND VGND VPWR VPWR net657 sky130_fd_sc_hd__dlygate4sd3_1
XFILLER_0_40_493 VGND VGND VPWR VPWR sky130_fd_sc_hd__decap_4
Xhold564 RF.reg_arr\[24\]\[16\] VGND VGND VPWR VPWR net646 sky130_fd_sc_hd__dlygate4sd3_1
X_9016_ clknet_leaf_34_CLK _0249_ VGND VGND VPWR VPWR RF.reg_arr\[27\]\[26\] sky130_fd_sc_hd__dfxtp_1
XFILLER_0_110_392 VGND VGND VPWR VPWR sky130_fd_sc_hd__fill_1
X_6228_ net299 _2982_ _2978_ VGND VGND VPWR VPWR _2983_ sky130_fd_sc_hd__mux2_1
X_6159_ _2864_ _2874_ VGND VGND VPWR VPWR _2920_ sky130_fd_sc_hd__nand2_1
XFILLER_0_99_449 VGND VGND VPWR VPWR sky130_fd_sc_hd__fill_2
XTAP_TAPCELL_ROW_56_923 VGND VPWR sky130_fd_sc_hd__tapvpwrvgnd_1
XTAP_TAPCELL_ROW_0_250 VGND VPWR sky130_fd_sc_hd__tapvpwrvgnd_1
XTAP_TAPCELL_ROW_36_680 VGND VPWR sky130_fd_sc_hd__tapvpwrvgnd_1
XFILLER_0_82_305 VGND VGND VPWR VPWR sky130_fd_sc_hd__decap_3
XFILLER_0_63_541 VGND VGND VPWR VPWR sky130_fd_sc_hd__decap_3
XFILLER_0_12_29 VGND VGND VPWR VPWR sky130_fd_sc_hd__decap_3
XTAP_TAPCELL_ROW_97_1413 VGND VPWR sky130_fd_sc_hd__tapvpwrvgnd_1
XFILLER_0_105_131 VGND VGND VPWR VPWR sky130_fd_sc_hd__decap_3
XFILLER_0_35_276 VGND VGND VPWR VPWR sky130_fd_sc_hd__decap_4
XFILLER_0_50_224 VGND VGND VPWR VPWR sky130_fd_sc_hd__decap_3
XFILLER_0_31_460 VGND VGND VPWR VPWR sky130_fd_sc_hd__decap_3
Xoutput51 net51 VGND VGND VPWR VPWR result[11] sky130_fd_sc_hd__clkbuf_4
Xoutput73 net73 VGND VGND VPWR VPWR result[31] sky130_fd_sc_hd__buf_4
Xoutput62 net62 VGND VGND VPWR VPWR result[21] sky130_fd_sc_hd__clkbuf_4
XTAP_TAPCELL_ROW_8_350 VGND VPWR sky130_fd_sc_hd__tapvpwrvgnd_1
XFILLER_0_37_26 VGND VGND VPWR VPWR sky130_fd_sc_hd__fill_2
XTAP_TAPCELL_ROW_106_1520 VGND VPWR sky130_fd_sc_hd__tapvpwrvgnd_1
XFILLER_0_86_622 VGND VGND VPWR VPWR sky130_fd_sc_hd__decap_6
XFILLER_0_85_110 VGND VGND VPWR VPWR sky130_fd_sc_hd__fill_2
XFILLER_0_58_335 VGND VGND VPWR VPWR sky130_fd_sc_hd__fill_1
XFILLER_0_39_582 VGND VGND VPWR VPWR sky130_fd_sc_hd__fill_1
X_5530_ RF.reg_arr\[16\]\[1\] RF.reg_arr\[17\]\[1\] RF.reg_arr\[18\]\[1\] RF.reg_arr\[19\]\[1\]
+ net1 net2 VGND VGND VPWR VPWR _2319_ sky130_fd_sc_hd__mux4_1
XFILLER_0_81_393 VGND VGND VPWR VPWR sky130_fd_sc_hd__fill_2
X_5461_ RF.reg_arr\[0\]\[7\] RF.reg_arr\[1\]\[7\] RF.reg_arr\[2\]\[7\] RF.reg_arr\[3\]\[7\]
+ _1590_ _1835_ VGND VGND VPWR VPWR _2250_ sky130_fd_sc_hd__mux4_1
X_7200_ _3544_ VGND VGND VPWR VPWR _0147_ sky130_fd_sc_hd__clkbuf_1
X_4412_ RF.reg_arr\[8\]\[18\] RF.reg_arr\[9\]\[18\] RF.reg_arr\[10\]\[18\] RF.reg_arr\[11\]\[18\]
+ _1187_ _1189_ VGND VGND VPWR VPWR _1201_ sky130_fd_sc_hd__mux4_1
XFILLER_0_41_235 VGND VGND VPWR VPWR sky130_fd_sc_hd__decap_3
XFILLER_0_112_657 VGND VGND VPWR VPWR sky130_fd_sc_hd__decap_8
X_5392_ RF.reg_arr\[16\]\[13\] RF.reg_arr\[17\]\[13\] RF.reg_arr\[18\]\[13\] RF.reg_arr\[19\]\[13\]
+ _2030_ _1858_ VGND VGND VPWR VPWR _2181_ sky130_fd_sc_hd__mux4_1
XFILLER_0_41_279 VGND VGND VPWR VPWR sky130_fd_sc_hd__fill_1
X_8180_ _2996_ _3268_ VGND VGND VPWR VPWR _4065_ sky130_fd_sc_hd__nand2_2
XPHY_EDGE_ROW_99_Right_99 VGND VGND VPWR VPWR sky130_fd_sc_hd__decap_3
X_7131_ net157 _3430_ _3507_ VGND VGND VPWR VPWR _3508_ sky130_fd_sc_hd__mux2_1
X_4343_ _1128_ _1131_ VGND VGND VPWR VPWR _1132_ sky130_fd_sc_hd__or2_1
X_7062_ _3448_ VGND VGND VPWR VPWR _3471_ sky130_fd_sc_hd__clkbuf_8
X_4274_ net8 VGND VGND VPWR VPWR _1063_ sky130_fd_sc_hd__buf_6
X_6013_ _2686_ _2720_ _2434_ VGND VGND VPWR VPWR _2782_ sky130_fd_sc_hd__mux2_1
X_7964_ _2982_ net911 _3944_ VGND VGND VPWR VPWR _3951_ sky130_fd_sc_hd__mux2_1
XPHY_EDGE_ROW_6_Left_123 VGND VGND VPWR VPWR sky130_fd_sc_hd__decap_3
X_6915_ net1017 _3379_ _3366_ VGND VGND VPWR VPWR _3380_ sky130_fd_sc_hd__mux2_1
XFILLER_0_77_622 VPWR VGND VPWR VGND sky130_ef_sc_hd__decap_12
XTAP_TAPCELL_ROW_68_1069 VGND VPWR sky130_fd_sc_hd__tapvpwrvgnd_1
XFILLER_0_11_3 VPWR VGND VPWR VGND sky130_ef_sc_hd__decap_12
X_7895_ _3914_ VGND VGND VPWR VPWR _0472_ sky130_fd_sc_hd__clkbuf_1
XTAP_TAPCELL_ROW_81_1225 VGND VPWR sky130_fd_sc_hd__tapvpwrvgnd_1
XFILLER_0_92_603 VPWR VGND VPWR VGND sky130_ef_sc_hd__decap_12
X_6846_ _3340_ VGND VGND VPWR VPWR _1021_ sky130_fd_sc_hd__clkbuf_1
X_6777_ _3303_ VGND VGND VPWR VPWR _0989_ sky130_fd_sc_hd__clkbuf_1
XTAP_TAPCELL_ROW_61_981 VGND VPWR sky130_fd_sc_hd__tapvpwrvgnd_1
XFILLER_0_9_465 VGND VGND VPWR VPWR sky130_fd_sc_hd__fill_1
XTAP_TAPCELL_ROW_33_650 VGND VPWR sky130_fd_sc_hd__tapvpwrvgnd_1
X_5728_ _2430_ _2393_ _2408_ _2421_ VGND VGND VPWR VPWR _2512_ sky130_fd_sc_hd__a22o_1
X_8516_ clknet_leaf_85_CLK _0773_ VGND VGND VPWR VPWR RF.reg_arr\[1\]\[6\] sky130_fd_sc_hd__dfxtp_1
X_9496_ clknet_leaf_35_CLK _0729_ VGND VGND VPWR VPWR RF.reg_arr\[11\]\[26\] sky130_fd_sc_hd__dfxtp_1
XFILLER_0_72_360 VGND VGND VPWR VPWR sky130_fd_sc_hd__fill_1
XFILLER_0_60_533 VGND VGND VPWR VPWR sky130_fd_sc_hd__fill_1
XFILLER_0_32_224 VGND VGND VPWR VPWR sky130_fd_sc_hd__decap_3
X_5659_ _2445_ VGND VGND VPWR VPWR _2446_ sky130_fd_sc_hd__buf_2
X_8447_ _4206_ VGND VGND VPWR VPWR _0732_ sky130_fd_sc_hd__clkbuf_1
X_8378_ _2988_ net917 _4160_ VGND VGND VPWR VPWR _4170_ sky130_fd_sc_hd__mux2_1
XTAP_TAPCELL_ROW_79_1198 VGND VPWR sky130_fd_sc_hd__tapvpwrvgnd_1
XFILLER_0_102_178 VGND VGND VPWR VPWR sky130_fd_sc_hd__decap_8
XTAP_TAPCELL_ROW_92_1354 VGND VPWR sky130_fd_sc_hd__tapvpwrvgnd_1
Xhold361 RF.reg_arr\[2\]\[30\] VGND VGND VPWR VPWR net443 sky130_fd_sc_hd__dlygate4sd3_1
Xhold350 RF.reg_arr\[18\]\[8\] VGND VGND VPWR VPWR net432 sky130_fd_sc_hd__dlygate4sd3_1
X_7329_ _3094_ net889 _3605_ VGND VGND VPWR VPWR _3613_ sky130_fd_sc_hd__mux2_1
Xhold372 RF.reg_arr\[12\]\[1\] VGND VGND VPWR VPWR net454 sky130_fd_sc_hd__dlygate4sd3_1
Xhold394 RF.reg_arr\[2\]\[11\] VGND VGND VPWR VPWR net476 sky130_fd_sc_hd__dlygate4sd3_1
Xhold383 RF.reg_arr\[25\]\[2\] VGND VGND VPWR VPWR net465 sky130_fd_sc_hd__dlygate4sd3_1
Xclkbuf_leaf_100_CLK clknet_3_1__leaf_CLK VGND VGND VPWR VPWR clknet_leaf_100_CLK
+ sky130_fd_sc_hd__clkbuf_8
XFILLER_0_67_110 VGND VGND VPWR VPWR sky130_fd_sc_hd__fill_2
XFILLER_0_23_39 VPWR VGND VPWR VGND sky130_ef_sc_hd__decap_12
XFILLER_0_67_198 VGND VGND VPWR VPWR sky130_fd_sc_hd__decap_4
XTAP_TAPCELL_ROW_101_1461 VGND VPWR sky130_fd_sc_hd__tapvpwrvgnd_1
XFILLER_0_82_157 VGND VGND VPWR VPWR sky130_fd_sc_hd__decap_4
XFILLER_0_63_382 VGND VGND VPWR VPWR sky130_fd_sc_hd__fill_2
XFILLER_0_51_500 VGND VGND VPWR VPWR sky130_fd_sc_hd__decap_4
Xrebuffer6 net81 VGND VGND VPWR VPWR net1123 sky130_fd_sc_hd__dlymetal6s2s_1
XTAP_TAPCELL_ROW_11_388 VGND VPWR sky130_fd_sc_hd__tapvpwrvgnd_1
XFILLER_0_23_279 VGND VGND VPWR VPWR sky130_fd_sc_hd__fill_1
XTAP_TAPCELL_ROW_112_1590 VGND VPWR sky130_fd_sc_hd__tapvpwrvgnd_1
XPHY_EDGE_ROW_79_Left_196 VGND VGND VPWR VPWR sky130_fd_sc_hd__decap_3
XFILLER_0_3_27 VPWR VGND VPWR VGND sky130_ef_sc_hd__decap_12
X_4961_ RF.reg_arr\[0\]\[26\] RF.reg_arr\[1\]\[26\] RF.reg_arr\[2\]\[26\] RF.reg_arr\[3\]\[26\]
+ _1626_ _1628_ VGND VGND VPWR VPWR _1750_ sky130_fd_sc_hd__mux4_1
XFILLER_0_59_633 VGND VGND VPWR VPWR sky130_fd_sc_hd__fill_2
XTAP_TAPCELL_ROW_19_477 VGND VPWR sky130_fd_sc_hd__tapvpwrvgnd_1
X_6700_ _3115_ net914 _3254_ VGND VGND VPWR VPWR _3262_ sky130_fd_sc_hd__mux2_1
X_7680_ _3800_ VGND VGND VPWR VPWR _0371_ sky130_fd_sc_hd__clkbuf_1
X_4892_ _1680_ VGND VGND VPWR VPWR _1681_ sky130_fd_sc_hd__buf_4
X_6631_ _3225_ VGND VGND VPWR VPWR _0921_ sky130_fd_sc_hd__clkbuf_1
XFILLER_0_104_85 VGND VGND VPWR VPWR sky130_fd_sc_hd__fill_2
X_9350_ clknet_leaf_81_CLK _0583_ VGND VGND VPWR VPWR RF.reg_arr\[18\]\[8\] sky130_fd_sc_hd__dfxtp_1
XFILLER_0_6_413 VGND VGND VPWR VPWR sky130_fd_sc_hd__decap_4
X_8301_ _4129_ VGND VGND VPWR VPWR _0663_ sky130_fd_sc_hd__clkbuf_1
X_6562_ net730 _2982_ _3182_ VGND VGND VPWR VPWR _3189_ sky130_fd_sc_hd__mux2_1
XFILLER_0_54_371 VGND VGND VPWR VPWR sky130_fd_sc_hd__fill_1
XFILLER_0_112_410 VGND VGND VPWR VPWR sky130_fd_sc_hd__decap_8
X_6493_ _3151_ VGND VGND VPWR VPWR _0857_ sky130_fd_sc_hd__clkbuf_1
X_9281_ clknet_leaf_69_CLK _0514_ VGND VGND VPWR VPWR RF.reg_arr\[25\]\[3\] sky130_fd_sc_hd__dfxtp_1
X_5513_ RF.reg_arr\[12\]\[2\] RF.reg_arr\[13\]\[2\] RF.reg_arr\[14\]\[2\] RF.reg_arr\[15\]\[2\]
+ _1846_ _1849_ VGND VGND VPWR VPWR _2302_ sky130_fd_sc_hd__mux4_1
X_8232_ _2970_ net873 _4088_ VGND VGND VPWR VPWR _4093_ sky130_fd_sc_hd__mux2_1
XFILLER_0_14_279 VPWR VGND VPWR VGND sky130_ef_sc_hd__decap_12
XFILLER_0_14_257 VGND VGND VPWR VPWR sky130_fd_sc_hd__fill_1
X_5444_ _1842_ _2228_ _2230_ _2232_ _1642_ VGND VGND VPWR VPWR _2233_ sky130_fd_sc_hd__o221a_1
X_8163_ _4056_ VGND VGND VPWR VPWR _0598_ sky130_fd_sc_hd__clkbuf_1
XFILLER_0_112_498 VGND VGND VPWR VPWR sky130_fd_sc_hd__decap_8
X_5375_ RF.reg_arr\[24\]\[12\] RF.reg_arr\[25\]\[12\] RF.reg_arr\[26\]\[12\] RF.reg_arr\[27\]\[12\]
+ _1622_ _1595_ VGND VGND VPWR VPWR _2164_ sky130_fd_sc_hd__mux4_1
X_7114_ net508 _3414_ _3496_ VGND VGND VPWR VPWR _3499_ sky130_fd_sc_hd__mux2_1
X_4326_ _1114_ VGND VGND VPWR VPWR _1115_ sky130_fd_sc_hd__clkbuf_4
X_8094_ _3046_ net663 _4016_ VGND VGND VPWR VPWR _4020_ sky130_fd_sc_hd__mux2_1
X_7045_ _3462_ VGND VGND VPWR VPWR _0074_ sky130_fd_sc_hd__clkbuf_1
X_4257_ _1045_ VGND VGND VPWR VPWR _1046_ sky130_fd_sc_hd__buf_4
X_8996_ clknet_leaf_83_CLK _0229_ VGND VGND VPWR VPWR RF.reg_arr\[27\]\[6\] sky130_fd_sc_hd__dfxtp_1
X_7947_ _3035_ net662 _3933_ VGND VGND VPWR VPWR _3942_ sky130_fd_sc_hd__mux2_1
XFILLER_0_49_110 VGND VGND VPWR VPWR sky130_fd_sc_hd__fill_2
X_7878_ _3905_ VGND VGND VPWR VPWR _0464_ sky130_fd_sc_hd__clkbuf_1
X_6829_ net409 _3044_ _3329_ VGND VGND VPWR VPWR _3332_ sky130_fd_sc_hd__mux2_1
XFILLER_0_92_455 VPWR VGND VPWR VGND sky130_ef_sc_hd__decap_12
XFILLER_0_80_639 VGND VGND VPWR VPWR sky130_fd_sc_hd__fill_1
XFILLER_0_18_585 VGND VGND VPWR VPWR sky130_fd_sc_hd__decap_3
X_9479_ clknet_leaf_63_CLK _0712_ VGND VGND VPWR VPWR RF.reg_arr\[11\]\[9\] sky130_fd_sc_hd__dfxtp_1
XFILLER_0_103_443 VGND VGND VPWR VPWR sky130_fd_sc_hd__decap_4
Xhold180 RF.reg_arr\[2\]\[6\] VGND VGND VPWR VPWR net262 sky130_fd_sc_hd__dlygate4sd3_1
Xhold191 RF.reg_arr\[2\]\[26\] VGND VGND VPWR VPWR net273 sky130_fd_sc_hd__dlygate4sd3_1
XFILLER_0_0_3 VPWR VGND VPWR VGND sky130_ef_sc_hd__decap_12
XTAP_TAPCELL_ROW_16_447 VGND VPWR sky130_fd_sc_hd__tapvpwrvgnd_1
XTAP_TAPCELL_ROW_44_778 VGND VPWR sky130_fd_sc_hd__tapvpwrvgnd_1
XFILLER_0_55_102 VGND VGND VPWR VPWR sky130_fd_sc_hd__fill_2
XFILLER_0_55_113 VGND VGND VPWR VPWR sky130_fd_sc_hd__fill_1
XFILLER_0_71_617 VGND VGND VPWR VPWR sky130_fd_sc_hd__decap_6
XFILLER_0_50_37 VGND VGND VPWR VPWR sky130_fd_sc_hd__fill_1
XFILLER_0_36_393 VGND VGND VPWR VPWR sky130_fd_sc_hd__decap_8
XFILLER_0_3_449 VPWR VGND VPWR VGND sky130_ef_sc_hd__decap_12
XPHY_EDGE_ROW_87_Left_204 VGND VGND VPWR VPWR sky130_fd_sc_hd__decap_3
X_5160_ RF.reg_arr\[20\]\[19\] RF.reg_arr\[21\]\[19\] RF.reg_arr\[22\]\[19\] RF.reg_arr\[23\]\[19\]
+ _1947_ _1948_ VGND VGND VPWR VPWR _1949_ sky130_fd_sc_hd__mux4_1
X_5091_ _1612_ _1879_ VGND VGND VPWR VPWR _1880_ sky130_fd_sc_hd__or2_1
XFILLER_0_78_227 VGND VGND VPWR VPWR sky130_fd_sc_hd__decap_4
X_8850_ clknet_leaf_15_CLK _0083_ VGND VGND VPWR VPWR RF.reg_arr\[19\]\[20\] sky130_fd_sc_hd__dfxtp_1
XFILLER_0_91_66 VGND VGND VPWR VPWR sky130_fd_sc_hd__decap_6
XFILLER_0_91_55 VGND VGND VPWR VPWR sky130_fd_sc_hd__fill_1
X_5993_ _1997_ _2740_ VGND VGND VPWR VPWR _2764_ sky130_fd_sc_hd__nor2_1
XTAP_TAPCELL_ROW_65_1028 VGND VPWR sky130_fd_sc_hd__tapvpwrvgnd_1
X_8781_ clknet_leaf_103_CLK _0014_ VGND VGND VPWR VPWR RF.reg_arr\[5\]\[15\] sky130_fd_sc_hd__dfxtp_1
X_7801_ _3864_ VGND VGND VPWR VPWR _0428_ sky130_fd_sc_hd__clkbuf_1
XFILLER_0_115_51 VGND VGND VPWR VPWR sky130_fd_sc_hd__decap_4
XPHY_EDGE_ROW_96_Left_213 VGND VGND VPWR VPWR sky130_fd_sc_hd__decap_3
XFILLER_0_59_463 VGND VGND VPWR VPWR sky130_fd_sc_hd__decap_3
X_7732_ net236 _3416_ _3824_ VGND VGND VPWR VPWR _3828_ sky130_fd_sc_hd__mux2_1
X_4944_ RF.reg_arr\[12\]\[1\] RF.reg_arr\[13\]\[1\] RF.reg_arr\[14\]\[1\] RF.reg_arr\[15\]\[1\]
+ _1262_ _1045_ VGND VGND VPWR VPWR _1733_ sky130_fd_sc_hd__mux4_1
X_9402_ clknet_leaf_28_CLK _0635_ VGND VGND VPWR VPWR RF.reg_arr\[13\]\[28\] sky130_fd_sc_hd__dfxtp_1
X_4875_ _1649_ _1663_ VGND VGND VPWR VPWR _1664_ sky130_fd_sc_hd__or2_1
X_7663_ _3791_ VGND VGND VPWR VPWR _0363_ sky130_fd_sc_hd__clkbuf_1
XFILLER_0_74_477 VGND VGND VPWR VPWR sky130_fd_sc_hd__decap_4
X_7594_ net1078 _3414_ _3752_ VGND VGND VPWR VPWR _3755_ sky130_fd_sc_hd__mux2_1
X_6614_ _3216_ VGND VGND VPWR VPWR _0913_ sky130_fd_sc_hd__clkbuf_1
X_9333_ clknet_leaf_40_CLK _0566_ VGND VGND VPWR VPWR RF.reg_arr\[20\]\[23\] sky130_fd_sc_hd__dfxtp_1
X_6545_ net761 _3035_ _3171_ VGND VGND VPWR VPWR _3180_ sky130_fd_sc_hd__mux2_1
XFILLER_0_70_661 VGND VGND VPWR VPWR sky130_fd_sc_hd__fill_1
X_9264_ clknet_leaf_1_CLK _0497_ VGND VGND VPWR VPWR RF.reg_arr\[21\]\[18\] sky130_fd_sc_hd__dfxtp_1
XFILLER_0_30_503 VGND VGND VPWR VPWR sky130_fd_sc_hd__decap_4
XFILLER_0_42_341 VGND VGND VPWR VPWR sky130_fd_sc_hd__fill_1
XFILLER_0_42_363 VGND VGND VPWR VPWR sky130_fd_sc_hd__fill_1
XFILLER_0_112_240 VGND VGND VPWR VPWR sky130_fd_sc_hd__fill_2
XFILLER_0_30_536 VGND VGND VPWR VPWR sky130_fd_sc_hd__decap_4
X_6476_ net125 VGND VGND VPWR VPWR _3143_ sky130_fd_sc_hd__clkbuf_1
X_8215_ _3031_ net341 _4077_ VGND VGND VPWR VPWR _4084_ sky130_fd_sc_hd__mux2_1
XTAP_TAPCELL_ROW_76_1168 VGND VPWR sky130_fd_sc_hd__tapvpwrvgnd_1
X_5427_ _1585_ _2207_ _2211_ _2215_ VGND VGND VPWR VPWR _2216_ sky130_fd_sc_hd__o2bb2a_2
X_9195_ clknet_leaf_91_CLK _0428_ VGND VGND VPWR VPWR RF.reg_arr\[24\]\[13\] sky130_fd_sc_hd__dfxtp_1
X_8146_ _4047_ VGND VGND VPWR VPWR _0590_ sky130_fd_sc_hd__clkbuf_1
X_5358_ _2145_ _2146_ _1864_ VGND VGND VPWR VPWR _2147_ sky130_fd_sc_hd__mux2_1
X_8077_ _3029_ net1119 _4005_ VGND VGND VPWR VPWR _4011_ sky130_fd_sc_hd__mux2_1
X_4309_ RF.reg_arr\[24\]\[0\] RF.reg_arr\[25\]\[0\] RF.reg_arr\[26\]\[0\] RF.reg_arr\[27\]\[0\]
+ _1093_ _1094_ VGND VGND VPWR VPWR _1098_ sky130_fd_sc_hd__mux4_2
X_7028_ _3453_ VGND VGND VPWR VPWR _0066_ sky130_fd_sc_hd__clkbuf_1
X_5289_ _1636_ _2077_ VGND VGND VPWR VPWR _2078_ sky130_fd_sc_hd__nand2_1
XFILLER_0_97_514 VGND VGND VPWR VPWR sky130_fd_sc_hd__decap_4
X_8979_ clknet_leaf_48_CLK _0212_ VGND VGND VPWR VPWR RF.reg_arr\[31\]\[21\] sky130_fd_sc_hd__dfxtp_1
XTAP_TAPCELL_ROW_87_1297 VGND VPWR sky130_fd_sc_hd__tapvpwrvgnd_1
XTAP_TAPCELL_ROW_13_406 VGND VPWR sky130_fd_sc_hd__tapvpwrvgnd_1
XFILLER_0_37_113 VGND VGND VPWR VPWR sky130_fd_sc_hd__decap_6
XTAP_TAPCELL_ROW_41_748 VGND VPWR sky130_fd_sc_hd__tapvpwrvgnd_1
XFILLER_0_65_499 VGND VGND VPWR VPWR sky130_fd_sc_hd__decap_4
XFILLER_0_53_628 VGND VGND VPWR VPWR sky130_fd_sc_hd__fill_2
XFILLER_0_80_436 VGND VGND VPWR VPWR sky130_fd_sc_hd__fill_1
XTAP_TAPCELL_ROW_49_837 VGND VPWR sky130_fd_sc_hd__tapvpwrvgnd_1
XFILLER_0_88_525 VGND VGND VPWR VPWR sky130_fd_sc_hd__fill_2
XFILLER_0_88_536 VPWR VGND VPWR VGND sky130_ef_sc_hd__decap_12
XTAP_TAPCELL_ROW_29_594 VGND VPWR sky130_fd_sc_hd__tapvpwrvgnd_1
XFILLER_0_56_455 VGND VGND VPWR VPWR sky130_fd_sc_hd__fill_2
X_4660_ _1293_ _1315_ _1385_ _1448_ VGND VGND VPWR VPWR _1449_ sky130_fd_sc_hd__nand4_1
XFILLER_0_9_15 VGND VGND VPWR VPWR sky130_fd_sc_hd__decap_6
XFILLER_0_56_477 VGND VGND VPWR VPWR sky130_fd_sc_hd__decap_4
XFILLER_0_56_499 VGND VGND VPWR VPWR sky130_fd_sc_hd__fill_2
X_6330_ _3051_ VGND VGND VPWR VPWR _0794_ sky130_fd_sc_hd__clkbuf_1
X_4591_ RF.reg_arr\[0\]\[22\] RF.reg_arr\[1\]\[22\] RF.reg_arr\[2\]\[22\] RF.reg_arr\[3\]\[22\]
+ _1342_ _1343_ VGND VGND VPWR VPWR _1380_ sky130_fd_sc_hd__mux4_1
XFILLER_0_24_363 VGND VGND VPWR VPWR sky130_fd_sc_hd__fill_1
Xhold905 RF.reg_arr\[12\]\[26\] VGND VGND VPWR VPWR net987 sky130_fd_sc_hd__dlygate4sd3_1
Xhold916 RF.reg_arr\[14\]\[13\] VGND VGND VPWR VPWR net998 sky130_fd_sc_hd__dlygate4sd3_1
Xhold927 RF.reg_arr\[26\]\[16\] VGND VGND VPWR VPWR net1009 sky130_fd_sc_hd__dlygate4sd3_1
Xhold938 RF.reg_arr\[14\]\[29\] VGND VGND VPWR VPWR net1020 sky130_fd_sc_hd__dlygate4sd3_1
X_6261_ net40 VGND VGND VPWR VPWR _3006_ sky130_fd_sc_hd__buf_2
Xhold949 RF.reg_arr\[22\]\[16\] VGND VGND VPWR VPWR net1031 sky130_fd_sc_hd__dlygate4sd3_1
X_5212_ _2000_ VGND VGND VPWR VPWR _2001_ sky130_fd_sc_hd__clkbuf_4
X_6192_ _2026_ _2948_ _2950_ VGND VGND VPWR VPWR _2951_ sky130_fd_sc_hd__or3b_1
X_8000_ _3970_ VGND VGND VPWR VPWR _0521_ sky130_fd_sc_hd__clkbuf_1
X_5143_ RF.reg_arr\[16\]\[18\] RF.reg_arr\[17\]\[18\] RF.reg_arr\[18\]\[18\] RF.reg_arr\[19\]\[18\]
+ _1884_ _1886_ VGND VGND VPWR VPWR _1932_ sky130_fd_sc_hd__mux4_1
XTAP_TAPCELL_ROW_71_1098 VGND VPWR sky130_fd_sc_hd__tapvpwrvgnd_1
X_5074_ _1609_ VGND VGND VPWR VPWR _1863_ sky130_fd_sc_hd__clkbuf_8
XFILLER_0_79_503 VGND VGND VPWR VPWR sky130_fd_sc_hd__fill_1
X_8902_ clknet_leaf_87_CLK _0135_ VGND VGND VPWR VPWR RF.reg_arr\[7\]\[8\] sky130_fd_sc_hd__dfxtp_1
XFILLER_0_79_558 VGND VGND VPWR VPWR sky130_fd_sc_hd__fill_2
X_8833_ clknet_leaf_70_CLK _0066_ VGND VGND VPWR VPWR RF.reg_arr\[19\]\[3\] sky130_fd_sc_hd__dfxtp_1
XFILLER_0_94_528 VGND VGND VPWR VPWR sky130_fd_sc_hd__decap_4
X_5976_ _2705_ _2747_ _2001_ VGND VGND VPWR VPWR _2748_ sky130_fd_sc_hd__mux2_1
X_8764_ clknet_leaf_23_CLK _1021_ VGND VGND VPWR VPWR RF.reg_arr\[6\]\[30\] sky130_fd_sc_hd__dfxtp_1
XFILLER_0_19_113 VGND VGND VPWR VPWR sky130_fd_sc_hd__decap_3
X_4927_ _1587_ _1707_ _1711_ _1715_ VGND VGND VPWR VPWR _1716_ sky130_fd_sc_hd__o2bb2a_2
X_8695_ clknet_leaf_39_CLK _0952_ VGND VGND VPWR VPWR RF.reg_arr\[15\]\[25\] sky130_fd_sc_hd__dfxtp_1
X_7715_ net478 _3399_ _3813_ VGND VGND VPWR VPWR _3819_ sky130_fd_sc_hd__mux2_1
XFILLER_0_47_444 VGND VGND VPWR VPWR sky130_fd_sc_hd__decap_4
X_4858_ _1584_ _1646_ VGND VGND VPWR VPWR _1647_ sky130_fd_sc_hd__nor2_1
X_7646_ _3782_ VGND VGND VPWR VPWR _0355_ sky130_fd_sc_hd__clkbuf_1
XFILLER_0_35_628 VGND VGND VPWR VPWR sky130_fd_sc_hd__fill_1
XFILLER_0_105_505 VGND VGND VPWR VPWR sky130_fd_sc_hd__decap_4
XFILLER_0_34_138 VGND VGND VPWR VPWR sky130_fd_sc_hd__fill_2
X_4789_ _1281_ _1577_ _1173_ VGND VGND VPWR VPWR _1578_ sky130_fd_sc_hd__a21o_1
X_9316_ clknet_leaf_82_CLK _0549_ VGND VGND VPWR VPWR RF.reg_arr\[20\]\[6\] sky130_fd_sc_hd__dfxtp_1
X_7577_ net660 _3397_ _3741_ VGND VGND VPWR VPWR _3746_ sky130_fd_sc_hd__mux2_1
XFILLER_0_43_650 VGND VGND VPWR VPWR sky130_fd_sc_hd__fill_1
X_6528_ _3159_ VGND VGND VPWR VPWR _3171_ sky130_fd_sc_hd__clkbuf_8
Xclkbuf_leaf_80_CLK clknet_3_5__leaf_CLK VGND VGND VPWR VPWR clknet_leaf_80_CLK sky130_fd_sc_hd__clkbuf_8
X_9247_ clknet_leaf_55_CLK _0480_ VGND VGND VPWR VPWR RF.reg_arr\[21\]\[1\] sky130_fd_sc_hd__dfxtp_1
X_6459_ _3134_ VGND VGND VPWR VPWR _0840_ sky130_fd_sc_hd__clkbuf_1
X_9178_ clknet_leaf_28_CLK _0411_ VGND VGND VPWR VPWR RF.reg_arr\[9\]\[28\] sky130_fd_sc_hd__dfxtp_1
X_8129_ _4038_ VGND VGND VPWR VPWR _0582_ sky130_fd_sc_hd__clkbuf_1
XTAP_TAPCELL_ROW_89_1315 VGND VPWR sky130_fd_sc_hd__tapvpwrvgnd_1
XTAP_TAPCELL_ROW_46_807 VGND VPWR sky130_fd_sc_hd__tapvpwrvgnd_1
XTAP_TAPCELL_ROW_26_564 VGND VPWR sky130_fd_sc_hd__tapvpwrvgnd_1
XFILLER_0_93_550 VGND VGND VPWR VPWR sky130_fd_sc_hd__fill_1
XFILLER_0_65_241 VGND VGND VPWR VPWR sky130_fd_sc_hd__fill_1
XTAP_TAPCELL_ROW_54_895 VGND VPWR sky130_fd_sc_hd__tapvpwrvgnd_1
XFILLER_0_93_561 VGND VGND VPWR VPWR sky130_fd_sc_hd__fill_2
XFILLER_0_108_365 VGND VGND VPWR VPWR sky130_fd_sc_hd__decap_3
Xclkbuf_leaf_71_CLK clknet_3_5__leaf_CLK VGND VGND VPWR VPWR clknet_leaf_71_CLK sky130_fd_sc_hd__clkbuf_8
XFILLER_0_21_377 VGND VGND VPWR VPWR sky130_fd_sc_hd__fill_1
XTAP_TAPCELL_ROW_109_1562 VGND VPWR sky130_fd_sc_hd__tapvpwrvgnd_1
XFILLER_0_72_68 VGND VGND VPWR VPWR sky130_fd_sc_hd__fill_1
X_5830_ _2120_ _2608_ VGND VGND VPWR VPWR _2610_ sky130_fd_sc_hd__or2_1
X_5761_ _2503_ _2541_ _2542_ _2543_ VGND VGND VPWR VPWR _2544_ sky130_fd_sc_hd__a22o_1
X_7500_ _3704_ VGND VGND VPWR VPWR _3705_ sky130_fd_sc_hd__clkbuf_8
X_4712_ RF.reg_arr\[24\]\[13\] RF.reg_arr\[25\]\[13\] RF.reg_arr\[26\]\[13\] RF.reg_arr\[27\]\[13\]
+ _1044_ _1046_ VGND VGND VPWR VPWR _1501_ sky130_fd_sc_hd__mux4_1
X_8480_ net611 net18 _4222_ VGND VGND VPWR VPWR _4224_ sky130_fd_sc_hd__mux2_1
XFILLER_0_112_41 VGND VGND VPWR VPWR sky130_fd_sc_hd__decap_6
X_5692_ _2001_ _2407_ VGND VGND VPWR VPWR _2478_ sky130_fd_sc_hd__nor2_1
XFILLER_0_71_222 VGND VGND VPWR VPWR sky130_fd_sc_hd__fill_2
X_7431_ _3056_ net945 _3667_ VGND VGND VPWR VPWR _3668_ sky130_fd_sc_hd__mux2_1
XFILLER_0_112_85 VGND VGND VPWR VPWR sky130_fd_sc_hd__fill_2
XFILLER_0_112_63 VGND VGND VPWR VPWR sky130_fd_sc_hd__decap_4
X_4643_ _1272_ _1423_ _1427_ _1431_ VGND VGND VPWR VPWR _1432_ sky130_fd_sc_hd__o2bb2a_1
XFILLER_0_4_533 VGND VGND VPWR VPWR sky130_fd_sc_hd__fill_2
XFILLER_0_31_108 VGND VGND VPWR VPWR sky130_fd_sc_hd__decap_4
X_4574_ RF.reg_arr\[4\]\[21\] RF.reg_arr\[5\]\[21\] RF.reg_arr\[6\]\[21\] RF.reg_arr\[7\]\[21\]
+ _1342_ _1343_ VGND VGND VPWR VPWR _1363_ sky130_fd_sc_hd__mux4_1
Xclkbuf_leaf_62_CLK clknet_3_6__leaf_CLK VGND VGND VPWR VPWR clknet_leaf_62_CLK sky130_fd_sc_hd__clkbuf_8
X_7362_ _3056_ net902 _3630_ VGND VGND VPWR VPWR _3631_ sky130_fd_sc_hd__mux2_1
Xhold702 RF.reg_arr\[11\]\[11\] VGND VGND VPWR VPWR net784 sky130_fd_sc_hd__dlygate4sd3_1
Xhold724 RF.reg_arr\[20\]\[24\] VGND VGND VPWR VPWR net806 sky130_fd_sc_hd__dlygate4sd3_1
Xhold746 RF.reg_arr\[23\]\[30\] VGND VGND VPWR VPWR net828 sky130_fd_sc_hd__dlygate4sd3_1
X_6313_ _3041_ VGND VGND VPWR VPWR _0787_ sky130_fd_sc_hd__clkbuf_1
X_7293_ _3593_ VGND VGND VPWR VPWR _3594_ sky130_fd_sc_hd__clkbuf_8
XFILLER_0_12_333 VGND VGND VPWR VPWR sky130_fd_sc_hd__fill_1
Xhold735 RF.reg_arr\[28\]\[5\] VGND VGND VPWR VPWR net817 sky130_fd_sc_hd__dlygate4sd3_1
X_9101_ clknet_leaf_10_CLK _0334_ VGND VGND VPWR VPWR RF.reg_arr\[2\]\[15\] sky130_fd_sc_hd__dfxtp_1
XFILLER_0_40_642 VGND VGND VPWR VPWR sky130_fd_sc_hd__fill_2
Xhold713 RF.reg_arr\[19\]\[10\] VGND VGND VPWR VPWR net795 sky130_fd_sc_hd__dlygate4sd3_1
X_6244_ _2993_ VGND VGND VPWR VPWR _0766_ sky130_fd_sc_hd__clkbuf_1
XTAP_TAPCELL_ROW_73_1127 VGND VPWR sky130_fd_sc_hd__tapvpwrvgnd_1
Xhold768 RF.reg_arr\[22\]\[9\] VGND VGND VPWR VPWR net850 sky130_fd_sc_hd__dlygate4sd3_1
Xhold757 RF.reg_arr\[21\]\[6\] VGND VGND VPWR VPWR net839 sky130_fd_sc_hd__dlygate4sd3_1
Xhold779 RF.reg_arr\[18\]\[13\] VGND VGND VPWR VPWR net861 sky130_fd_sc_hd__dlygate4sd3_1
X_9032_ clknet_leaf_10_CLK _0265_ VGND VGND VPWR VPWR RF.reg_arr\[26\]\[10\] sky130_fd_sc_hd__dfxtp_1
XFILLER_0_110_563 VGND VGND VPWR VPWR sky130_fd_sc_hd__decap_3
X_6175_ _1293_ _2913_ _2759_ VGND VGND VPWR VPWR _2935_ sky130_fd_sc_hd__a21o_1
XFILLER_0_41_3 VPWR VGND VPWR VGND sky130_ef_sc_hd__decap_12
X_5126_ RF.reg_arr\[28\]\[21\] RF.reg_arr\[29\]\[21\] RF.reg_arr\[30\]\[21\] RF.reg_arr\[31\]\[21\]
+ _1625_ _1598_ VGND VGND VPWR VPWR _1915_ sky130_fd_sc_hd__mux4_1
X_5057_ _1621_ VGND VGND VPWR VPWR _1846_ sky130_fd_sc_hd__buf_4
XTAP_TAPCELL_ROW_84_1256 VGND VPWR sky130_fd_sc_hd__tapvpwrvgnd_1
XFILLER_0_67_539 VGND VGND VPWR VPWR sky130_fd_sc_hd__fill_2
X_8816_ clknet_leaf_3_CLK _0049_ VGND VGND VPWR VPWR RF.reg_arr\[4\]\[18\] sky130_fd_sc_hd__dfxtp_1
XFILLER_0_39_219 VGND VGND VPWR VPWR sky130_fd_sc_hd__decap_4
X_5959_ _2731_ _2649_ _2729_ _2577_ VGND VGND VPWR VPWR _2732_ sky130_fd_sc_hd__or4b_4
XFILLER_0_1_93 VPWR VGND VPWR VGND sky130_ef_sc_hd__decap_12
XTAP_TAPCELL_ROW_23_523 VGND VPWR sky130_fd_sc_hd__tapvpwrvgnd_1
X_8747_ clknet_leaf_89_CLK _1004_ VGND VGND VPWR VPWR RF.reg_arr\[6\]\[13\] sky130_fd_sc_hd__dfxtp_1
XFILLER_0_75_561 VPWR VGND VPWR VGND sky130_ef_sc_hd__decap_12
XTAP_TAPCELL_ROW_51_865 VGND VPWR sky130_fd_sc_hd__tapvpwrvgnd_1
X_8678_ clknet_leaf_81_CLK _0935_ VGND VGND VPWR VPWR RF.reg_arr\[15\]\[8\] sky130_fd_sc_hd__dfxtp_1
XFILLER_0_35_447 VGND VGND VPWR VPWR sky130_fd_sc_hd__fill_1
X_7629_ net384 _3381_ _3763_ VGND VGND VPWR VPWR _3773_ sky130_fd_sc_hd__mux2_1
XFILLER_0_90_575 VGND VGND VPWR VPWR sky130_fd_sc_hd__fill_1
XFILLER_0_35_458 VGND VGND VPWR VPWR sky130_fd_sc_hd__decap_4
Xclkbuf_leaf_53_CLK clknet_3_6__leaf_CLK VGND VGND VPWR VPWR clknet_leaf_53_CLK sky130_fd_sc_hd__clkbuf_8
XTAP_TAPCELL_ROW_95_1396 VGND VPWR sky130_fd_sc_hd__tapvpwrvgnd_1
Xhold40 RF.reg_arr\[0\]\[17\] VGND VGND VPWR VPWR net122 sky130_fd_sc_hd__dlygate4sd3_1
XPHY_EDGE_ROW_42_Left_159 VGND VGND VPWR VPWR sky130_fd_sc_hd__decap_3
Xhold73 RF.reg_arr\[9\]\[30\] VGND VGND VPWR VPWR net155 sky130_fd_sc_hd__dlygate4sd3_1
Xhold62 RF.reg_arr\[3\]\[21\] VGND VGND VPWR VPWR net144 sky130_fd_sc_hd__dlygate4sd3_1
Xhold51 RF.reg_arr\[5\]\[2\] VGND VGND VPWR VPWR net133 sky130_fd_sc_hd__dlygate4sd3_1
XTAP_TAPCELL_ROW_59_965 VGND VPWR sky130_fd_sc_hd__tapvpwrvgnd_1
XTAP_TAPCELL_ROW_59_954 VGND VPWR sky130_fd_sc_hd__tapvpwrvgnd_1
XFILLER_0_98_631 VGND VGND VPWR VPWR sky130_fd_sc_hd__fill_1
Xhold84 RF.reg_arr\[8\]\[29\] VGND VGND VPWR VPWR net166 sky130_fd_sc_hd__dlygate4sd3_1
Xhold95 RF.reg_arr\[1\]\[20\] VGND VGND VPWR VPWR net177 sky130_fd_sc_hd__dlygate4sd3_1
XTAP_TAPCELL_ROW_3_292 VGND VPWR sky130_fd_sc_hd__tapvpwrvgnd_1
XFILLER_0_85_303 VGND VGND VPWR VPWR sky130_fd_sc_hd__decap_4
XPHY_EDGE_ROW_51_Left_168 VGND VGND VPWR VPWR sky130_fd_sc_hd__decap_3
XFILLER_0_109_685 VGND VGND VPWR VPWR sky130_fd_sc_hd__decap_6
XFILLER_0_81_575 VGND VGND VPWR VPWR sky130_fd_sc_hd__decap_8
XFILLER_0_101_6 VPWR VGND VPWR VGND sky130_ef_sc_hd__decap_12
Xclkbuf_leaf_44_CLK clknet_3_6__leaf_CLK VGND VGND VPWR VPWR clknet_leaf_44_CLK sky130_fd_sc_hd__clkbuf_8
XFILLER_0_1_503 VGND VGND VPWR VPWR sky130_fd_sc_hd__fill_1
XANTENNA_4 WD3[10] VGND VGND VPWR VPWR sky130_fd_sc_hd__diode_2
XFILLER_0_6_27 VGND VGND VPWR VPWR sky130_fd_sc_hd__fill_1
XFILLER_0_67_57 VGND VGND VPWR VPWR sky130_fd_sc_hd__decap_4
X_4290_ RF.reg_arr\[12\]\[4\] RF.reg_arr\[13\]\[4\] RF.reg_arr\[14\]\[4\] RF.reg_arr\[15\]\[4\]
+ _1027_ _1029_ VGND VGND VPWR VPWR _1079_ sky130_fd_sc_hd__mux4_1
XPHY_EDGE_ROW_60_Left_177 VGND VGND VPWR VPWR sky130_fd_sc_hd__decap_3
Xrebuffer16 _1271_ VGND VGND VPWR VPWR net1125 sky130_fd_sc_hd__dlymetal6s2s_1
X_7980_ _3000_ net380 _3958_ VGND VGND VPWR VPWR _3960_ sky130_fd_sc_hd__mux2_1
X_6931_ net25 VGND VGND VPWR VPWR _3391_ sky130_fd_sc_hd__buf_2
XFILLER_0_16_94 VGND VGND VPWR VPWR sky130_fd_sc_hd__fill_1
X_6862_ net279 _3008_ _3344_ VGND VGND VPWR VPWR _3350_ sky130_fd_sc_hd__mux2_1
X_8601_ clknet_leaf_48_CLK _0858_ VGND VGND VPWR VPWR RF.reg_arr\[0\]\[27\] sky130_fd_sc_hd__dfxtp_1
X_5813_ _2426_ _2255_ VGND VGND VPWR VPWR _2594_ sky130_fd_sc_hd__nand2_1
XFILLER_0_64_509 VGND VGND VPWR VPWR sky130_fd_sc_hd__fill_2
XFILLER_0_91_306 VGND VGND VPWR VPWR sky130_fd_sc_hd__fill_1
X_8532_ clknet_leaf_44_CLK _0789_ VGND VGND VPWR VPWR RF.reg_arr\[1\]\[22\] sky130_fd_sc_hd__dfxtp_1
XFILLER_0_57_561 VGND VGND VPWR VPWR sky130_fd_sc_hd__decap_8
XFILLER_0_9_669 VGND VGND VPWR VPWR sky130_fd_sc_hd__decap_3
X_6793_ net632 _3008_ _3307_ VGND VGND VPWR VPWR _3313_ sky130_fd_sc_hd__mux2_1
X_5744_ _2435_ _2437_ _2003_ VGND VGND VPWR VPWR _2527_ sky130_fd_sc_hd__mux2_1
XFILLER_0_29_274 VGND VGND VPWR VPWR sky130_fd_sc_hd__decap_6
X_5675_ _2352_ VGND VGND VPWR VPWR _2461_ sky130_fd_sc_hd__inv_2
X_8463_ net205 net41 _4211_ VGND VGND VPWR VPWR _4215_ sky130_fd_sc_hd__mux2_1
Xclkbuf_leaf_35_CLK clknet_3_3__leaf_CLK VGND VGND VPWR VPWR clknet_leaf_35_CLK sky130_fd_sc_hd__clkbuf_8
X_7414_ _3111_ net1090 _3652_ VGND VGND VPWR VPWR _3658_ sky130_fd_sc_hd__mux2_1
X_4626_ _1025_ _1406_ _1410_ _1414_ VGND VGND VPWR VPWR _1415_ sky130_fd_sc_hd__a2bb2o_2
X_8394_ net597 _3397_ _4174_ VGND VGND VPWR VPWR _4179_ sky130_fd_sc_hd__mux2_1
X_7345_ _3621_ VGND VGND VPWR VPWR _0215_ sky130_fd_sc_hd__clkbuf_1
XFILLER_0_114_165 VGND VGND VPWR VPWR sky130_fd_sc_hd__fill_1
Xhold510 RF.reg_arr\[28\]\[2\] VGND VGND VPWR VPWR net592 sky130_fd_sc_hd__dlygate4sd3_1
XFILLER_0_4_363 VGND VGND VPWR VPWR sky130_fd_sc_hd__fill_1
Xhold543 RF.reg_arr\[22\]\[20\] VGND VGND VPWR VPWR net625 sky130_fd_sc_hd__dlygate4sd3_1
X_4557_ RF.reg_arr\[0\]\[20\] RF.reg_arr\[1\]\[20\] RF.reg_arr\[2\]\[20\] RF.reg_arr\[3\]\[20\]
+ _1342_ _1343_ VGND VGND VPWR VPWR _1346_ sky130_fd_sc_hd__mux4_1
Xhold532 RF.reg_arr\[15\]\[15\] VGND VGND VPWR VPWR net614 sky130_fd_sc_hd__dlygate4sd3_1
Xhold554 RF.reg_arr\[10\]\[4\] VGND VGND VPWR VPWR net636 sky130_fd_sc_hd__dlygate4sd3_1
Xhold521 RF.reg_arr\[8\]\[13\] VGND VGND VPWR VPWR net603 sky130_fd_sc_hd__dlygate4sd3_1
X_7276_ _3109_ net511 _3580_ VGND VGND VPWR VPWR _3585_ sky130_fd_sc_hd__mux2_1
X_4488_ RF.reg_arr\[20\]\[28\] RF.reg_arr\[21\]\[28\] RF.reg_arr\[22\]\[28\] RF.reg_arr\[23\]\[28\]
+ _1274_ _1276_ VGND VGND VPWR VPWR _1277_ sky130_fd_sc_hd__mux4_1
XFILLER_0_12_185 VGND VGND VPWR VPWR sky130_fd_sc_hd__fill_2
Xhold576 RF.reg_arr\[29\]\[4\] VGND VGND VPWR VPWR net658 sky130_fd_sc_hd__dlygate4sd3_1
Xhold565 RF.reg_arr\[9\]\[6\] VGND VGND VPWR VPWR net647 sky130_fd_sc_hd__dlygate4sd3_1
Xhold587 RF.reg_arr\[8\]\[9\] VGND VGND VPWR VPWR net669 sky130_fd_sc_hd__dlygate4sd3_1
X_6227_ net32 VGND VGND VPWR VPWR _2982_ sky130_fd_sc_hd__buf_2
X_9015_ clknet_leaf_31_CLK _0248_ VGND VGND VPWR VPWR RF.reg_arr\[27\]\[25\] sky130_fd_sc_hd__dfxtp_1
Xhold598 RF.reg_arr\[29\]\[13\] VGND VGND VPWR VPWR net680 sky130_fd_sc_hd__dlygate4sd3_1
X_6158_ _2892_ _2902_ VGND VGND VPWR VPWR _2919_ sky130_fd_sc_hd__nand2_1
X_5109_ _1896_ _1897_ _1865_ VGND VGND VPWR VPWR _1898_ sky130_fd_sc_hd__mux2_1
X_6089_ _2850_ _2851_ VGND VGND VPWR VPWR _2854_ sky130_fd_sc_hd__nor2_1
XTAP_TAPCELL_ROW_56_924 VGND VPWR sky130_fd_sc_hd__tapvpwrvgnd_1
XTAP_TAPCELL_ROW_0_240 VGND VPWR sky130_fd_sc_hd__tapvpwrvgnd_1
XTAP_TAPCELL_ROW_0_251 VGND VPWR sky130_fd_sc_hd__tapvpwrvgnd_1
XTAP_TAPCELL_ROW_36_681 VGND VPWR sky130_fd_sc_hd__tapvpwrvgnd_1
XFILLER_0_106_622 VGND VGND VPWR VPWR sky130_fd_sc_hd__fill_1
XTAP_TAPCELL_ROW_97_1414 VGND VPWR sky130_fd_sc_hd__tapvpwrvgnd_1
XFILLER_0_105_121 VGND VGND VPWR VPWR sky130_fd_sc_hd__fill_1
Xclkbuf_leaf_26_CLK clknet_3_2__leaf_CLK VGND VGND VPWR VPWR clknet_leaf_26_CLK sky130_fd_sc_hd__clkbuf_8
XFILLER_0_23_439 VGND VGND VPWR VPWR sky130_fd_sc_hd__fill_1
XFILLER_0_105_165 VGND VGND VPWR VPWR sky130_fd_sc_hd__decap_3
XFILLER_0_90_394 VGND VGND VPWR VPWR sky130_fd_sc_hd__fill_2
Xoutput52 net52 VGND VGND VPWR VPWR result[12] sky130_fd_sc_hd__clkbuf_4
Xoutput63 net63 VGND VGND VPWR VPWR result[22] sky130_fd_sc_hd__clkbuf_4
Xoutput74 net74 VGND VGND VPWR VPWR result[3] sky130_fd_sc_hd__clkbuf_4
XTAP_TAPCELL_ROW_8_351 VGND VPWR sky130_fd_sc_hd__tapvpwrvgnd_1
XTAP_TAPCELL_ROW_106_1521 VGND VPWR sky130_fd_sc_hd__tapvpwrvgnd_1
XFILLER_0_98_494 VGND VGND VPWR VPWR sky130_fd_sc_hd__fill_2
XFILLER_0_66_391 VGND VGND VPWR VPWR sky130_fd_sc_hd__fill_1
XFILLER_0_54_531 VGND VGND VPWR VPWR sky130_fd_sc_hd__fill_1
Xclkbuf_leaf_17_CLK clknet_3_2__leaf_CLK VGND VGND VPWR VPWR clknet_leaf_17_CLK sky130_fd_sc_hd__clkbuf_8
X_5460_ RF.reg_arr\[4\]\[7\] RF.reg_arr\[5\]\[7\] RF.reg_arr\[6\]\[7\] RF.reg_arr\[7\]\[7\]
+ _1590_ _1835_ VGND VGND VPWR VPWR _2249_ sky130_fd_sc_hd__mux4_1
XFILLER_0_54_597 VGND VGND VPWR VPWR sky130_fd_sc_hd__decap_8
XFILLER_0_112_614 VGND VGND VPWR VPWR sky130_fd_sc_hd__fill_1
X_4411_ _1133_ _1199_ _1158_ VGND VGND VPWR VPWR _1200_ sky130_fd_sc_hd__o21a_1
XFILLER_0_41_225 VGND VGND VPWR VPWR sky130_fd_sc_hd__decap_6
XFILLER_0_111_113 VGND VGND VPWR VPWR sky130_fd_sc_hd__fill_2
X_5391_ RF.reg_arr\[20\]\[13\] RF.reg_arr\[21\]\[13\] RF.reg_arr\[22\]\[13\] RF.reg_arr\[23\]\[13\]
+ _2030_ _1858_ VGND VGND VPWR VPWR _2180_ sky130_fd_sc_hd__mux4_1
X_7130_ _3484_ VGND VGND VPWR VPWR _3507_ sky130_fd_sc_hd__clkbuf_8
XFILLER_0_22_494 VGND VGND VPWR VPWR sky130_fd_sc_hd__fill_1
X_4342_ RF.reg_arr\[4\]\[16\] RF.reg_arr\[5\]\[16\] RF.reg_arr\[6\]\[16\] RF.reg_arr\[7\]\[16\]
+ _1129_ _1130_ VGND VGND VPWR VPWR _1131_ sky130_fd_sc_hd__mux4_1
X_4273_ _1061_ VGND VGND VPWR VPWR _1062_ sky130_fd_sc_hd__buf_4
X_7061_ _3470_ VGND VGND VPWR VPWR _0082_ sky130_fd_sc_hd__clkbuf_1
X_6012_ _2418_ _2491_ VGND VGND VPWR VPWR _2781_ sky130_fd_sc_hd__or2_1
.ends
